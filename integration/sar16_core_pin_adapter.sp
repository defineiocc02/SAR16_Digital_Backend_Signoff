* Generated by tools/check_sar16_interface.py --generate.
* Positional naming adapter for the extracted SP only; not an analog hookup.
* Source CDL VDD/VSS globals are unchanged. Include the extracted core separately.
* LVS is not closed; differing foundry/PDK designs cannot be physically spliced.
* Voltage, switch truth table, timing and sample pairing require validation.
.SUBCKT sar16_core_pin_adapter clk dec_clk rst_n start_calib calib_comp_out calib_done calib_done_pulse calib_mode_en
+ dac_p_force[19] dac_p_force[18] dac_p_force[17] dac_p_force[16] dac_p_force[15] dac_p_force[14] dac_p_force[13] dac_p_force[12]
+ dac_p_force[11] dac_p_force[10] dac_p_force[9] dac_p_force[8] dac_p_force[7] dac_p_force[6] dac_p_force[5] dac_p_force[4]
+ dac_p_force[3] dac_p_force[2] dac_p_force[1] dac_p_force[0] dac_n_force[19] dac_n_force[18] dac_n_force[17] dac_n_force[16]
+ dac_n_force[15] dac_n_force[14] dac_n_force[13] dac_n_force[12] dac_n_force[11] dac_n_force[10] dac_n_force[9] dac_n_force[8]
+ dac_n_force[7] dac_n_force[6] dac_n_force[5] dac_n_force[4] dac_n_force[3] dac_n_force[2] dac_n_force[1] dac_n_force[0]
+ calib_overrange calib_overrange_bits[19] calib_overrange_bits[18] calib_overrange_bits[17] calib_overrange_bits[16] calib_overrange_bits[15] calib_overrange_bits[14] calib_overrange_bits[13]
+ calib_overrange_bits[12] calib_overrange_bits[11] calib_overrange_bits[10] calib_overrange_bits[9] calib_overrange_bits[8] calib_overrange_bits[7] calib_overrange_bits[6] calib_overrange_bits[5]
+ calib_overrange_bits[4] calib_overrange_bits[3] calib_overrange_bits[2] calib_overrange_bits[1] calib_overrange_bits[0] data_valid_i raw_bits_i[19] raw_bits_i[18]
+ raw_bits_i[17] raw_bits_i[16] raw_bits_i[15] raw_bits_i[14] raw_bits_i[13] raw_bits_i[12] raw_bits_i[11] raw_bits_i[10]
+ raw_bits_i[9] raw_bits_i[8] raw_bits_i[7] raw_bits_i[6] raw_bits_i[5] raw_bits_i[4] raw_bits_i[3] raw_bits_i[2]
+ raw_bits_i[1] raw_bits_i[0] raw_code_o[19] raw_code_o[18] raw_code_o[17] raw_code_o[16] raw_code_o[15] raw_code_o[14]
+ raw_code_o[13] raw_code_o[12] raw_code_o[11] raw_code_o[10] raw_code_o[9] raw_code_o[8] raw_code_o[7] raw_code_o[6]
+ raw_code_o[5] raw_code_o[4] raw_code_o[3] raw_code_o[2] raw_code_o[1] raw_code_o[0] raw_code_valid_o w_wr_en
+ w_wr_addr[4] w_wr_addr[3] w_wr_addr[2] w_wr_addr[1] w_wr_addr[0] w_wr_data[29] w_wr_data[28] w_wr_data[27]
+ w_wr_data[26] w_wr_data[25] w_wr_data[24] w_wr_data[23] w_wr_data[22] w_wr_data[21] w_wr_data[20] w_wr_data[19]
+ w_wr_data[18] w_wr_data[17] w_wr_data[16] w_wr_data[15] w_wr_data[14] w_wr_data[13] w_wr_data[12] w_wr_data[11]
+ w_wr_data[10] w_wr_data[9] w_wr_data[8] w_wr_data[7] w_wr_data[6] w_wr_data[5] w_wr_data[4] w_wr_data[3]
+ w_wr_data[2] w_wr_data[1] w_wr_data[0] srm_start srm_decision_valid srm_decision_bit residue_consume_i srm_busy
+ srm_done srm_residue_valid srm_ones_count[4] srm_ones_count[3] srm_ones_count[2] srm_ones_count[1] srm_ones_count[0] srm_total_count[4]
+ srm_total_count[3] srm_total_count[2] srm_total_count[1] srm_total_count[0] srm_count_shortfall srm_stalled srm_residue_o[9] srm_residue_o[8]
+ srm_residue_o[7] srm_residue_o[6] srm_residue_o[5] srm_residue_o[4] srm_residue_o[3] srm_residue_o[2] srm_residue_o[1] srm_residue_o[0]
+ VDD VSS
Xcore clk w_wr_data[20] w_wr_data[23] w_wr_data[2] w_wr_data[19] w_wr_data[22] w_wr_data[28] w_wr_data[17]
+ w_wr_data[26] w_wr_data[25] w_wr_data[29] w_wr_data[24] w_wr_data[27] w_wr_data[21] w_wr_addr[2] w_wr_data[18]
+ w_wr_addr[3] w_wr_addr[4] w_wr_en raw_code_valid_o raw_code_o[0] raw_code_o[3] raw_code_o[1] calib_overrange
+ dac_n_force[0] dac_n_force[1] dac_n_force[2] raw_code_o[6] raw_code_o[9] dac_n_force[3] raw_code_o[10] raw_code_o[2]
+ raw_code_o[7] raw_code_o[13] raw_code_o[4] raw_code_o[11] raw_code_o[8] raw_code_o[12] raw_code_o[14] raw_code_o[15]
+ raw_code_o[5] raw_code_o[17] raw_code_o[16] raw_code_o[19] VDD w_wr_data[0] w_wr_addr[0] calib_overrange_bits[16]
+ calib_overrange_bits[18] calib_overrange_bits[14] calib_overrange_bits[17] calib_overrange_bits[15] calib_overrange_bits[19] calib_overrange_bits[13] srm_decision_bit srm_start
+ calib_overrange_bits[7] srm_decision_valid calib_overrange_bits[12] calib_overrange_bits[11] calib_overrange_bits[10] calib_overrange_bits[9] calib_overrange_bits[8] srm_residue_valid
+ srm_ones_count[4] srm_busy srm_done residue_consume_i calib_overrange_bits[2] calib_overrange_bits[4] calib_overrange_bits[3] calib_overrange_bits[5]
+ calib_overrange_bits[6] srm_total_count[3] srm_ones_count[0] srm_ones_count[1] srm_total_count[4] srm_ones_count[2] srm_ones_count[3] srm_stalled
+ srm_count_shortfall raw_bits_i[3] start_calib calib_mode_en w_wr_data[9] w_wr_data[10] w_wr_data[11] w_wr_data[12]
+ w_wr_data[13] w_wr_data[14] w_wr_data[3] w_wr_data[4] w_wr_data[5] w_wr_data[6] w_wr_data[7] w_wr_data[8]
+ w_wr_data[1] raw_bits_i[17] raw_bits_i[18] raw_bits_i[19] data_valid_i calib_overrange_bits[0] calib_overrange_bits[1] srm_total_count[0]
+ srm_total_count[1] srm_total_count[2] raw_bits_i[12] raw_bits_i[13] raw_bits_i[14] raw_bits_i[15] raw_bits_i[16] srm_residue_o[4]
+ srm_residue_o[5] srm_residue_o[6] srm_residue_o[7] srm_residue_o[8] srm_residue_o[9] raw_bits_i[6] raw_bits_i[7] raw_bits_i[8]
+ raw_bits_i[9] raw_bits_i[10] raw_bits_i[11] srm_residue_o[0] srm_residue_o[1] srm_residue_o[2] srm_residue_o[3] raw_bits_i[2]
+ raw_bits_i[4] raw_bits_i[5] w_wr_data[15] VSS w_wr_data[16] w_wr_addr[1] raw_code_o[18] raw_bits_i[0]
+ raw_bits_i[1] calib_done dac_n_force[4] dac_n_force[5] dac_n_force[6] dac_n_force[7] dac_n_force[8] dac_n_force[9]
+ dac_n_force[10] dac_n_force[11] dac_n_force[12] dac_n_force[13] dac_n_force[14] dac_n_force[15] dac_n_force[16] dac_n_force[17]
+ dac_n_force[18] dac_n_force[19] dac_p_force[0] dac_p_force[1] dac_p_force[2] dac_p_force[3] dac_p_force[4] dac_p_force[5]
+ dac_p_force[6] dac_p_force[7] dac_p_force[8] dac_p_force[9] dac_p_force[10] dac_p_force[11] dac_p_force[12] dac_p_force[13]
+ dac_p_force[14] dac_p_force[15] dac_p_force[16] dac_p_force[17] dac_p_force[18] dac_p_force[19] calib_done_pulse calib_comp_out
+ rst_n dec_clk sar_digi_paper_core
.ENDS sar16_core_pin_adapter
