* NGSPICE file created from sar_digi_paper_core.ext - technology: sky130A

.subckt sky130_fd_sc_hs__xnor2_1 VPWR VGND A Y B VNB VPB
X0 a_138_385# A VPWR VPB sky130_fd_pr__pfet_01v8 ad=0.126 pd=1.14 as=0.2898 ps=2.37 w=0.84 l=0.15
X1 a_138_385# B a_112_119# VNB sky130_fd_pr__nfet_01v8_lvt ad=0.176 pd=1.83 as=0.0672 ps=0.85 w=0.64 l=0.15
X2 VGND A a_293_74# VNB sky130_fd_pr__nfet_01v8_lvt ad=0.182 pd=1.345 as=0.2035 ps=2.03 w=0.74 l=0.15
X3 a_293_74# B VGND VNB sky130_fd_pr__nfet_01v8_lvt ad=0.1036 pd=1.02 as=0.182 ps=1.345 w=0.74 l=0.15
X4 Y B a_376_368# VPB sky130_fd_pr__pfet_01v8 ad=0.2352 pd=1.54 as=0.1512 ps=1.39 w=1.12 l=0.15
X5 a_376_368# A VPWR VPB sky130_fd_pr__pfet_01v8 ad=0.1512 pd=1.39 as=0.28782 ps=1.71 w=1.12 l=0.15
X6 VPWR B a_138_385# VPB sky130_fd_pr__pfet_01v8 ad=0.28782 pd=1.71 as=0.126 ps=1.14 w=0.84 l=0.15
X7 VPWR a_138_385# Y VPB sky130_fd_pr__pfet_01v8 ad=0.3304 pd=2.83 as=0.2352 ps=1.54 w=1.12 l=0.15
X8 Y a_138_385# a_293_74# VNB sky130_fd_pr__nfet_01v8_lvt ad=0.2294 pd=2.1 as=0.1036 ps=1.02 w=0.74 l=0.15
X9 a_112_119# A VGND VNB sky130_fd_pr__nfet_01v8_lvt ad=0.0672 pd=0.85 as=0.176 ps=1.83 w=0.64 l=0.15
.ends

.subckt sky130_fd_sc_hs__mux2_1 VPWR VGND X S A0 A1 VNB VPB
X0 VGND a_27_112# a_443_74# VNB sky130_fd_pr__nfet_01v8_lvt ad=0.20905 pd=1.305 as=0.2997 ps=1.55 w=0.74 l=0.15
X1 VPWR S a_27_112# VPB sky130_fd_pr__pfet_01v8 ad=0.1853 pd=1.385 as=0.2478 ps=2.27 w=0.84 l=0.15
X2 X a_304_74# VPWR VPB sky130_fd_pr__pfet_01v8 ad=0.3304 pd=2.83 as=0.2557 ps=1.59 w=1.12 l=0.15
X3 VPWR a_27_112# a_524_368# VPB sky130_fd_pr__pfet_01v8 ad=0.2557 pd=1.59 as=0.21 ps=1.42 w=1 l=0.15
X4 a_304_74# A1 a_226_74# VNB sky130_fd_pr__nfet_01v8_lvt ad=0.20165 pd=1.285 as=0.0888 ps=0.98 w=0.74 l=0.15
X5 X a_304_74# VGND VNB sky130_fd_pr__nfet_01v8_lvt ad=0.2109 pd=2.05 as=0.20905 ps=1.305 w=0.74 l=0.15
X6 a_223_368# S VPWR VPB sky130_fd_pr__pfet_01v8 ad=0.4075 pd=1.815 as=0.1853 ps=1.385 w=1 l=0.15
X7 a_304_74# A0 a_223_368# VPB sky130_fd_pr__pfet_01v8 ad=0.195 pd=1.39 as=0.4075 ps=1.815 w=1 l=0.15
X8 a_443_74# A0 a_304_74# VNB sky130_fd_pr__nfet_01v8_lvt ad=0.2997 pd=1.55 as=0.20165 ps=1.285 w=0.74 l=0.15
X9 a_524_368# A1 a_304_74# VPB sky130_fd_pr__pfet_01v8 ad=0.21 pd=1.42 as=0.195 ps=1.39 w=1 l=0.15
X10 a_226_74# S VGND VNB sky130_fd_pr__nfet_01v8_lvt ad=0.0888 pd=0.98 as=0.14457 ps=1.15 w=0.74 l=0.15
X11 VGND S a_27_112# VNB sky130_fd_pr__nfet_01v8_lvt ad=0.14457 pd=1.15 as=0.15675 ps=1.67 w=0.55 l=0.15
.ends

.subckt sky130_fd_sc_hs__nor2b_1 VPWR VGND B_N Y A VNB VPB
X0 Y A VGND VNB sky130_fd_pr__nfet_01v8_lvt ad=0.13135 pd=1.095 as=0.15358 ps=1.2 w=0.74 l=0.15
X1 Y a_27_112# a_278_368# VPB sky130_fd_pr__pfet_01v8 ad=0.42 pd=2.99 as=0.1512 ps=1.39 w=1.12 l=0.15
X2 a_278_368# A VPWR VPB sky130_fd_pr__pfet_01v8 ad=0.1512 pd=1.39 as=0.2345 ps=1.58 w=1.12 l=0.15
X3 VGND B_N a_27_112# VNB sky130_fd_pr__nfet_01v8_lvt ad=0.15358 pd=1.2 as=0.2805 ps=2.12 w=0.55 l=0.15
X4 VGND a_27_112# Y VNB sky130_fd_pr__nfet_01v8_lvt ad=0.2627 pd=2.19 as=0.13135 ps=1.095 w=0.74 l=0.15
X5 VPWR B_N a_27_112# VPB sky130_fd_pr__pfet_01v8 ad=0.2345 pd=1.58 as=0.2478 ps=2.27 w=0.84 l=0.15
.ends

.subckt sky130_fd_sc_hs__o22ai_1 VPWR VGND B2 B1 Y A2 A1 VNB VPB
X0 VGND A2 a_27_74# VNB sky130_fd_pr__nfet_01v8_lvt ad=0.1554 pd=1.16 as=0.1295 ps=1.09 w=0.74 l=0.15
X1 Y B2 a_142_368# VPB sky130_fd_pr__pfet_01v8 ad=0.2352 pd=1.54 as=0.1512 ps=1.39 w=1.12 l=0.15
X2 a_27_74# B2 Y VNB sky130_fd_pr__nfet_01v8_lvt ad=0.1295 pd=1.09 as=0.21275 ps=1.315 w=0.74 l=0.15
X3 Y B1 a_27_74# VNB sky130_fd_pr__nfet_01v8_lvt ad=0.21275 pd=1.315 as=0.2109 ps=2.05 w=0.74 l=0.15
X4 a_27_74# A1 VGND VNB sky130_fd_pr__nfet_01v8_lvt ad=0.2109 pd=2.05 as=0.1554 ps=1.16 w=0.74 l=0.15
X5 a_142_368# B1 VPWR VPB sky130_fd_pr__pfet_01v8 ad=0.1512 pd=1.39 as=0.4648 ps=3.07 w=1.12 l=0.15
X6 a_340_368# A2 Y VPB sky130_fd_pr__pfet_01v8 ad=0.2352 pd=1.54 as=0.2352 ps=1.54 w=1.12 l=0.15
X7 VPWR A1 a_340_368# VPB sky130_fd_pr__pfet_01v8 ad=0.3304 pd=2.83 as=0.2352 ps=1.54 w=1.12 l=0.15
.ends

.subckt sky130_fd_sc_hs__or2_1 VPWR VGND B A X VNB VPB
X0 VGND A a_63_368# VNB sky130_fd_pr__nfet_01v8_lvt ad=0.15198 pd=1.17 as=0.13062 ps=1.025 w=0.55 l=0.15
X1 VPWR A a_152_368# VPB sky130_fd_pr__pfet_01v8 ad=0.3346 pd=1.76 as=0.1134 ps=1.11 w=0.84 l=0.15
X2 a_152_368# B a_63_368# VPB sky130_fd_pr__pfet_01v8 ad=0.1134 pd=1.11 as=0.2478 ps=2.27 w=0.84 l=0.15
X3 X a_63_368# VGND VNB sky130_fd_pr__nfet_01v8_lvt ad=0.2109 pd=2.05 as=0.15198 ps=1.17 w=0.74 l=0.15
X4 X a_63_368# VPWR VPB sky130_fd_pr__pfet_01v8 ad=0.3304 pd=2.83 as=0.3346 ps=1.76 w=1.12 l=0.15
X5 a_63_368# B VGND VNB sky130_fd_pr__nfet_01v8_lvt ad=0.13062 pd=1.025 as=0.2695 ps=2.08 w=0.55 l=0.15
.ends

.subckt sky130_fd_sc_hs__dfrtp_1 RESET_B VPWR VGND Q CLK D VNB VPB
X0 a_894_138# a_830_359# a_816_138# VNB sky130_fd_pr__nfet_01v8_lvt ad=0.0504 pd=0.66 as=0.0504 ps=0.66 w=0.42 l=0.15
X1 VPWR a_1518_203# a_1468_493# VPB sky130_fd_pr__pfet_01v8 ad=0.08925 pd=0.845 as=0.0567 ps=0.69 w=0.42 l=0.15
X2 a_1864_409# a_1266_74# VPWR VPB sky130_fd_pr__pfet_01v8 ad=0.2478 pd=2.27 as=0.1428 ps=1.225 w=0.84 l=0.15
X3 a_816_138# a_490_366# a_695_457# VNB sky130_fd_pr__nfet_01v8_lvt ad=0.0504 pd=0.66 as=0.0735 ps=0.77 w=0.42 l=0.15
X4 a_830_359# a_695_457# VGND VNB sky130_fd_pr__nfet_01v8_lvt ad=0.24605 pd=1.405 as=0.21123 ps=1.45 w=0.74 l=0.15
X5 a_1476_81# a_306_74# a_1266_74# VNB sky130_fd_pr__nfet_01v8_lvt ad=0.0504 pd=0.66 as=0.229 ps=1.64 w=0.42 l=0.15
X6 VGND a_1864_409# Q VNB sky130_fd_pr__nfet_01v8_lvt ad=0.2109 pd=2.05 as=0.2109 ps=2.05 w=0.74 l=0.15
X7 a_490_366# a_306_74# VPWR VPB sky130_fd_pr__pfet_01v8 ad=0.3136 pd=2.8 as=0.168 ps=1.42 w=1.12 l=0.15
X8 VPWR CLK a_306_74# VPB sky130_fd_pr__pfet_01v8 ad=0.168 pd=1.42 as=0.3136 ps=2.8 w=1.12 l=0.15
X9 a_1468_493# a_490_366# a_1266_74# VPB sky130_fd_pr__pfet_01v8 ad=0.0567 pd=0.69 as=0.23015 ps=1.73 w=0.42 l=0.15
X10 a_1266_74# a_306_74# a_830_359# VPB sky130_fd_pr__pfet_01v8 ad=0.23015 pd=1.73 as=0.19062 ps=1.505 w=1 l=0.15
X11 a_830_359# a_695_457# VPWR VPB sky130_fd_pr__pfet_01v8 ad=0.19062 pd=1.505 as=0.305 ps=2.61 w=1 l=0.15
X12 a_1656_81# RESET_B VGND VNB sky130_fd_pr__nfet_01v8_lvt ad=0.0441 pd=0.63 as=0.0756 ps=0.78 w=0.42 l=0.15
X13 VPWR a_1864_409# Q VPB sky130_fd_pr__pfet_01v8 ad=0.336 pd=2.84 as=0.3808 ps=2.92 w=1.12 l=0.15
X14 a_1864_409# a_1266_74# VGND VNB sky130_fd_pr__nfet_01v8_lvt ad=0.15675 pd=1.67 as=0.15675 ps=1.67 w=0.55 l=0.15
X15 VPWR a_1266_74# a_1518_203# VPB sky130_fd_pr__pfet_01v8 ad=0.1428 pd=1.225 as=0.063 ps=0.72 w=0.42 l=0.15
X16 VPWR RESET_B a_30_78# VPB sky130_fd_pr__pfet_01v8 ad=0.1176 pd=1.4 as=0.063 ps=0.72 w=0.42 l=0.15
X17 a_1518_203# RESET_B VPWR VPB sky130_fd_pr__pfet_01v8 ad=0.063 pd=0.72 as=0.08925 ps=0.845 w=0.42 l=0.15
X18 a_117_78# D a_30_78# VNB sky130_fd_pr__nfet_01v8_lvt ad=0.0504 pd=0.66 as=0.1197 ps=1.41 w=0.42 l=0.15
X19 a_695_457# a_306_74# a_30_78# VNB sky130_fd_pr__nfet_01v8_lvt ad=0.0735 pd=0.77 as=0.1197 ps=1.41 w=0.42 l=0.15
X20 a_1518_203# a_1266_74# a_1656_81# VNB sky130_fd_pr__nfet_01v8_lvt ad=0.1197 pd=1.41 as=0.0441 ps=0.63 w=0.42 l=0.15
X21 a_695_457# RESET_B VPWR VPB sky130_fd_pr__pfet_01v8 ad=0.1239 pd=1.43 as=0.13713 ps=1.155 w=0.42 l=0.15
X22 a_490_366# a_306_74# VGND VNB sky130_fd_pr__nfet_01v8_lvt ad=0.2627 pd=2.19 as=0.1295 ps=1.09 w=0.74 l=0.15
X23 VPWR a_830_359# a_785_457# VPB sky130_fd_pr__pfet_01v8 ad=0.13713 pd=1.155 as=0.0504 ps=0.66 w=0.42 l=0.15
X24 VGND a_1518_203# a_1476_81# VNB sky130_fd_pr__nfet_01v8_lvt ad=0.0756 pd=0.78 as=0.0504 ps=0.66 w=0.42 l=0.15
X25 VGND RESET_B a_117_78# VNB sky130_fd_pr__nfet_01v8_lvt ad=0.1197 pd=1.41 as=0.0504 ps=0.66 w=0.42 l=0.15
X26 a_785_457# a_306_74# a_695_457# VPB sky130_fd_pr__pfet_01v8 ad=0.0504 pd=0.66 as=0.063 ps=0.72 w=0.42 l=0.15
X27 a_695_457# a_490_366# a_30_78# VPB sky130_fd_pr__pfet_01v8 ad=0.063 pd=0.72 as=0.1239 ps=1.43 w=0.42 l=0.15
X28 a_1266_74# a_490_366# a_830_359# VNB sky130_fd_pr__nfet_01v8_lvt ad=0.229 pd=1.64 as=0.24605 ps=1.405 w=0.74 l=0.15
X29 a_30_78# D VPWR VPB sky130_fd_pr__pfet_01v8 ad=0.063 pd=0.72 as=0.1197 ps=1.41 w=0.42 l=0.15
X30 VGND CLK a_306_74# VNB sky130_fd_pr__nfet_01v8_lvt ad=0.1295 pd=1.09 as=0.2109 ps=2.05 w=0.74 l=0.15
X31 VGND RESET_B a_894_138# VNB sky130_fd_pr__nfet_01v8_lvt ad=0.21123 pd=1.45 as=0.0504 ps=0.66 w=0.42 l=0.15
.ends

.subckt sky130_fd_sc_hs__clkbuf_4 VPWR VGND A X VNB VPB
X0 X a_83_270# VPWR VPB sky130_fd_pr__pfet_01v8 ad=0.168 pd=1.42 as=0.3304 ps=2.83 w=1.12 l=0.15
X1 X a_83_270# VGND VNB sky130_fd_pr__nfet_01v8_lvt ad=0.0588 pd=0.7 as=0.1197 ps=1.41 w=0.42 l=0.15
X2 a_83_270# A VPWR VPB sky130_fd_pr__pfet_01v8 ad=0.3304 pd=2.83 as=0.196 ps=1.47 w=1.12 l=0.15
X3 a_83_270# A VGND VNB sky130_fd_pr__nfet_01v8_lvt ad=0.126 pd=1.44 as=0.0798 ps=0.8 w=0.42 l=0.15
X4 VPWR a_83_270# X VPB sky130_fd_pr__pfet_01v8 ad=0.196 pd=1.47 as=0.168 ps=1.42 w=1.12 l=0.15
X5 X a_83_270# VPWR VPB sky130_fd_pr__pfet_01v8 ad=0.168 pd=1.42 as=0.168 ps=1.42 w=1.12 l=0.15
X6 VPWR a_83_270# X VPB sky130_fd_pr__pfet_01v8 ad=0.168 pd=1.42 as=0.168 ps=1.42 w=1.12 l=0.15
X7 VGND a_83_270# X VNB sky130_fd_pr__nfet_01v8_lvt ad=0.0588 pd=0.7 as=0.0588 ps=0.7 w=0.42 l=0.15
X8 VGND a_83_270# X VNB sky130_fd_pr__nfet_01v8_lvt ad=0.0798 pd=0.8 as=0.0672 ps=0.74 w=0.42 l=0.15
X9 X a_83_270# VGND VNB sky130_fd_pr__nfet_01v8_lvt ad=0.0672 pd=0.74 as=0.0588 ps=0.7 w=0.42 l=0.15
.ends

.subckt sky130_fd_sc_hs__clkinv_4 VPWR VGND Y A VNB VPB
X0 Y A VPWR VPB sky130_fd_pr__pfet_01v8 ad=0.168 pd=1.42 as=0.3304 ps=2.83 w=1.12 l=0.15
X1 VPWR A Y VPB sky130_fd_pr__pfet_01v8 ad=0.3864 pd=2.93 as=0.168 ps=1.42 w=1.12 l=0.15
X2 VGND A Y VNB sky130_fd_pr__nfet_01v8_lvt ad=0.1386 pd=1.5 as=0.06405 ps=0.725 w=0.42 l=0.15
X3 Y A VPWR VPB sky130_fd_pr__pfet_01v8 ad=0.168 pd=1.42 as=0.196 ps=1.47 w=1.12 l=0.15
X4 VPWR A Y VPB sky130_fd_pr__pfet_01v8 ad=0.196 pd=1.47 as=0.168 ps=1.42 w=1.12 l=0.15
X5 Y A VPWR VPB sky130_fd_pr__pfet_01v8 ad=0.168 pd=1.42 as=0.168 ps=1.42 w=1.12 l=0.15
X6 VPWR A Y VPB sky130_fd_pr__pfet_01v8 ad=0.168 pd=1.42 as=0.168 ps=1.42 w=1.12 l=0.15
X7 Y A VGND VNB sky130_fd_pr__nfet_01v8_lvt ad=0.06405 pd=0.725 as=0.0882 ps=0.84 w=0.42 l=0.15
X8 VGND A Y VNB sky130_fd_pr__nfet_01v8_lvt ad=0.0882 pd=0.84 as=0.14805 ps=1.125 w=0.42 l=0.15
X9 Y A VGND VNB sky130_fd_pr__nfet_01v8_lvt ad=0.14805 pd=1.125 as=0.3066 ps=2.3 w=0.42 l=0.15
.ends

.subckt sky130_fd_sc_hs__a311oi_1 VPWR VGND C1 B1 A3 A2 A1 Y VNB VPB
X0 a_462_368# B1 a_156_368# VPB sky130_fd_pr__pfet_01v8 ad=0.1848 pd=1.45 as=0.168 ps=1.42 w=1.12 l=0.15
X1 Y C1 a_462_368# VPB sky130_fd_pr__pfet_01v8 ad=0.308 pd=2.79 as=0.1848 ps=1.45 w=1.12 l=0.15
X2 a_156_368# A1 VPWR VPB sky130_fd_pr__pfet_01v8 ad=0.168 pd=1.42 as=0.2688 ps=1.6 w=1.12 l=0.15
X3 a_231_74# A2 a_159_74# VNB sky130_fd_pr__nfet_01v8_lvt ad=0.1443 pd=1.13 as=0.0777 ps=0.95 w=0.74 l=0.15
X4 a_159_74# A3 VGND VNB sky130_fd_pr__nfet_01v8_lvt ad=0.0777 pd=0.95 as=0.1961 ps=2.01 w=0.74 l=0.15
X5 Y A1 a_231_74# VNB sky130_fd_pr__nfet_01v8_lvt ad=0.1443 pd=1.13 as=0.1443 ps=1.13 w=0.74 l=0.15
X6 VGND B1 Y VNB sky130_fd_pr__nfet_01v8_lvt ad=0.1443 pd=1.13 as=0.1443 ps=1.13 w=0.74 l=0.15
X7 Y C1 VGND VNB sky130_fd_pr__nfet_01v8_lvt ad=0.1961 pd=2.01 as=0.1443 ps=1.13 w=0.74 l=0.15
X8 VPWR A2 a_156_368# VPB sky130_fd_pr__pfet_01v8 ad=0.2688 pd=1.6 as=0.168 ps=1.42 w=1.12 l=0.15
X9 a_156_368# A3 VPWR VPB sky130_fd_pr__pfet_01v8 ad=0.168 pd=1.42 as=0.308 ps=2.79 w=1.12 l=0.15
.ends

.subckt sky130_fd_sc_hs__clkinv_1 VPWR VGND A Y VNB VPB
X0 Y A VPWR VPB sky130_fd_pr__pfet_01v8 ad=0.126 pd=1.14 as=0.2394 ps=2.25 w=0.84 l=0.15
X1 Y A VGND VNB sky130_fd_pr__nfet_01v8_lvt ad=0.22535 pd=2.17 as=0.1491 ps=1.55 w=0.42 l=0.15
X2 VPWR A Y VPB sky130_fd_pr__pfet_01v8 ad=0.2394 pd=2.25 as=0.126 ps=1.14 w=0.84 l=0.15
.ends

.subckt sky130_fd_sc_hs__clkbuf_2 VPWR VGND X A VNB VPB
X0 a_43_192# A VPWR VPB sky130_fd_pr__pfet_01v8 ad=0.3528 pd=2.87 as=0.168 ps=1.42 w=1.12 l=0.15
X1 VPWR a_43_192# X VPB sky130_fd_pr__pfet_01v8 ad=0.168 pd=1.42 as=0.168 ps=1.42 w=1.12 l=0.15
X2 X a_43_192# VGND VNB sky130_fd_pr__nfet_01v8_lvt ad=0.0588 pd=0.7 as=0.1197 ps=1.41 w=0.42 l=0.15
X3 a_43_192# A VGND VNB sky130_fd_pr__nfet_01v8_lvt ad=0.1197 pd=1.41 as=0.0735 ps=0.77 w=0.42 l=0.15
X4 X a_43_192# VPWR VPB sky130_fd_pr__pfet_01v8 ad=0.168 pd=1.42 as=0.3192 ps=2.81 w=1.12 l=0.15
X5 VGND a_43_192# X VNB sky130_fd_pr__nfet_01v8_lvt ad=0.0735 pd=0.77 as=0.0588 ps=0.7 w=0.42 l=0.15
.ends

.subckt sky130_fd_sc_hs__a22o_1 VPWR VGND X B2 B1 A2 A1 VNB VPB
X0 a_222_392# B1 a_230_79# VNB sky130_fd_pr__nfet_01v8_lvt ad=0.0896 pd=0.92 as=0.0672 ps=0.85 w=0.64 l=0.15
X1 a_52_123# A1 a_222_392# VNB sky130_fd_pr__nfet_01v8_lvt ad=0.1824 pd=1.85 as=0.0896 ps=0.92 w=0.64 l=0.15
X2 a_222_392# B2 a_132_392# VPB sky130_fd_pr__pfet_01v8 ad=0.165 pd=1.33 as=0.15 ps=1.3 w=1 l=0.15
X3 a_132_392# B1 a_222_392# VPB sky130_fd_pr__pfet_01v8 ad=0.195 pd=1.39 as=0.165 ps=1.33 w=1 l=0.15
X4 X a_222_392# VPWR VPB sky130_fd_pr__pfet_01v8 ad=0.308 pd=2.79 as=0.3065 ps=1.7 w=1.12 l=0.15
X5 VGND A2 a_52_123# VNB sky130_fd_pr__nfet_01v8_lvt ad=0.12325 pd=1.185 as=0.1696 ps=1.81 w=0.64 l=0.15
X6 X a_222_392# VGND VNB sky130_fd_pr__nfet_01v8_lvt ad=0.1961 pd=2.01 as=0.1961 ps=2.01 w=0.74 l=0.15
X7 VPWR A1 a_132_392# VPB sky130_fd_pr__pfet_01v8 ad=0.3065 pd=1.7 as=0.195 ps=1.39 w=1 l=0.15
X8 a_132_392# A2 VPWR VPB sky130_fd_pr__pfet_01v8 ad=0.15 pd=1.3 as=0.275 ps=2.55 w=1 l=0.15
X9 a_230_79# B2 VGND VNB sky130_fd_pr__nfet_01v8_lvt ad=0.0672 pd=0.85 as=0.12325 ps=1.185 w=0.64 l=0.15
.ends

.subckt sky130_fd_sc_hs__o21ai_1 VPWR VGND Y B1 A2 A1 VNB VPB
X0 a_27_74# A2 VGND VNB sky130_fd_pr__nfet_01v8_lvt ad=0.1036 pd=1.02 as=0.3361 ps=1.68 w=0.74 l=0.15
X1 VGND A1 a_27_74# VNB sky130_fd_pr__nfet_01v8_lvt ad=0.3361 pd=1.68 as=0.2109 ps=2.05 w=0.74 l=0.15
X2 Y B1 a_27_74# VNB sky130_fd_pr__nfet_01v8_lvt ad=0.2627 pd=2.19 as=0.1036 ps=1.02 w=0.74 l=0.15
X3 Y A2 a_162_368# VPB sky130_fd_pr__pfet_01v8 ad=0.2828 pd=1.625 as=0.1512 ps=1.39 w=1.12 l=0.15
X4 a_162_368# A1 VPWR VPB sky130_fd_pr__pfet_01v8 ad=0.1512 pd=1.39 as=0.4648 ps=3.07 w=1.12 l=0.15
X5 VPWR B1 Y VPB sky130_fd_pr__pfet_01v8 ad=0.3304 pd=2.83 as=0.2828 ps=1.625 w=1.12 l=0.15
.ends

.subckt sky130_fd_sc_hs__nand4_1 VPWR VGND C Y D B A VNB VPB
X0 Y B VPWR VPB sky130_fd_pr__pfet_01v8 ad=0.196 pd=1.47 as=0.2576 ps=1.58 w=1.12 l=0.15
X1 a_259_74# C a_181_74# VNB sky130_fd_pr__nfet_01v8_lvt ad=0.1554 pd=1.16 as=0.0888 ps=0.98 w=0.74 l=0.15
X2 a_181_74# D VGND VNB sky130_fd_pr__nfet_01v8_lvt ad=0.0888 pd=0.98 as=0.2923 ps=2.72 w=0.74 l=0.15
X3 Y A a_373_74# VNB sky130_fd_pr__nfet_01v8_lvt ad=0.2085 pd=2.05 as=0.1554 ps=1.16 w=0.74 l=0.15
X4 a_373_74# B a_259_74# VNB sky130_fd_pr__nfet_01v8_lvt ad=0.1554 pd=1.16 as=0.1554 ps=1.16 w=0.74 l=0.15
X5 VPWR C Y VPB sky130_fd_pr__pfet_01v8 ad=0.2576 pd=1.58 as=0.168 ps=1.42 w=1.12 l=0.15
X6 Y D VPWR VPB sky130_fd_pr__pfet_01v8 ad=0.168 pd=1.42 as=0.3864 ps=2.93 w=1.12 l=0.15
X7 VPWR A Y VPB sky130_fd_pr__pfet_01v8 ad=0.3304 pd=2.83 as=0.196 ps=1.47 w=1.12 l=0.15
.ends

.subckt sky130_fd_sc_hs__clkinv_2 VPWR VGND Y A VNB VPB
X0 VPWR A Y VPB sky130_fd_pr__pfet_01v8 ad=0.168 pd=1.42 as=0.3304 ps=2.83 w=1.12 l=0.15
X1 Y A VGND VNB sky130_fd_pr__nfet_01v8_lvt ad=0.1638 pd=1.2 as=0.1197 ps=1.41 w=0.42 l=0.15
X2 VPWR A Y VPB sky130_fd_pr__pfet_01v8 ad=0.3304 pd=2.83 as=0.168 ps=1.42 w=1.12 l=0.15
X3 Y A VPWR VPB sky130_fd_pr__pfet_01v8 ad=0.168 pd=1.42 as=0.168 ps=1.42 w=1.12 l=0.15
X4 VGND A Y VNB sky130_fd_pr__nfet_01v8_lvt ad=0.1197 pd=1.41 as=0.1638 ps=1.2 w=0.42 l=0.15
.ends

.subckt sky130_fd_sc_hs__nand2_1 VPWR VGND B Y A VNB VPB
X0 a_117_74# B VGND VNB sky130_fd_pr__nfet_01v8_lvt ad=0.0888 pd=0.98 as=0.2109 ps=2.05 w=0.74 l=0.15
X1 VPWR A Y VPB sky130_fd_pr__pfet_01v8 ad=0.3192 pd=2.81 as=0.168 ps=1.42 w=1.12 l=0.15
X2 Y A a_117_74# VNB sky130_fd_pr__nfet_01v8_lvt ad=0.2109 pd=2.05 as=0.0888 ps=0.98 w=0.74 l=0.15
X3 Y B VPWR VPB sky130_fd_pr__pfet_01v8 ad=0.168 pd=1.42 as=0.3192 ps=2.81 w=1.12 l=0.15
.ends

.subckt sky130_fd_sc_hs__dlygate4sd3_1 VGND VPWR A X VNB VPB
X0 a_289_74# a_28_74# VGND VNB sky130_fd_pr__nfet_01v8_lvt ad=0.1092 pd=1.36 as=0.1491 ps=1.13 w=0.42 l=0.18
X1 VPWR A a_28_74# VPB sky130_fd_pr__pfet_01v8 ad=0.15125 pd=1.375 as=0.1176 ps=1.4 w=0.42 l=0.15
X2 X a_405_138# VGND VNB sky130_fd_pr__nfet_01v8_lvt ad=0.1961 pd=2.01 as=0.11485 ps=1.085 w=0.74 l=0.15
X3 VPWR a_289_74# a_405_138# VPB sky130_fd_pr__pfet_01v8 ad=0.194 pd=1.475 as=0.26 ps=2.52 w=1 l=0.5
X4 VGND A a_28_74# VNB sky130_fd_pr__nfet_01v8_lvt ad=0.1491 pd=1.13 as=0.1113 ps=1.37 w=0.42 l=0.15
X5 VGND a_289_74# a_405_138# VNB sky130_fd_pr__nfet_01v8_lvt ad=0.11485 pd=1.085 as=0.2436 ps=2 w=0.42 l=0.18
X6 X a_405_138# VPWR VPB sky130_fd_pr__pfet_01v8 ad=0.3136 pd=2.8 as=0.194 ps=1.475 w=1.12 l=0.15
X7 a_289_74# a_28_74# VPWR VPB sky130_fd_pr__pfet_01v8 ad=0.26 pd=2.52 as=0.15125 ps=1.375 w=1 l=0.5
.ends

.subckt sky130_fd_sc_hs__clkbuf_8 VPWR VGND X A VNB VPB
X0 X a_125_368# VGND VNB sky130_fd_pr__nfet_01v8_lvt ad=0.0588 pd=0.7 as=0.0882 ps=0.84 w=0.42 l=0.15
X1 VGND a_125_368# X VNB sky130_fd_pr__nfet_01v8_lvt ad=0.1197 pd=1.41 as=0.0588 ps=0.7 w=0.42 l=0.15
X2 VGND a_125_368# X VNB sky130_fd_pr__nfet_01v8_lvt ad=0.0882 pd=0.84 as=0.06405 ps=0.725 w=0.42 l=0.15
X3 X a_125_368# VPWR VPB sky130_fd_pr__pfet_01v8 ad=0.1764 pd=1.435 as=0.196 ps=1.47 w=1.12 l=0.15
X4 a_125_368# A VGND VNB sky130_fd_pr__nfet_01v8_lvt ad=0.0588 pd=0.7 as=0.1491 ps=1.55 w=0.42 l=0.15
X5 X a_125_368# VGND VNB sky130_fd_pr__nfet_01v8_lvt ad=0.0588 pd=0.7 as=0.0735 ps=0.77 w=0.42 l=0.15
X6 VPWR A a_125_368# VPB sky130_fd_pr__pfet_01v8 ad=0.224 pd=1.52 as=0.1708 ps=1.425 w=1.12 l=0.15
X7 X a_125_368# VGND VNB sky130_fd_pr__nfet_01v8_lvt ad=0.0588 pd=0.7 as=0.0588 ps=0.7 w=0.42 l=0.15
X8 a_125_368# A VPWR VPB sky130_fd_pr__pfet_01v8 ad=0.1708 pd=1.425 as=0.3808 ps=2.92 w=1.12 l=0.15
X9 VPWR a_125_368# X VPB sky130_fd_pr__pfet_01v8 ad=0.196 pd=1.47 as=0.168 ps=1.42 w=1.12 l=0.15
X10 VGND a_125_368# X VNB sky130_fd_pr__nfet_01v8_lvt ad=0.0735 pd=0.77 as=0.0588 ps=0.7 w=0.42 l=0.15
X11 X a_125_368# VPWR VPB sky130_fd_pr__pfet_01v8 ad=0.168 pd=1.42 as=0.168 ps=1.42 w=1.12 l=0.15
X12 VPWR a_125_368# X VPB sky130_fd_pr__pfet_01v8 ad=0.168 pd=1.42 as=0.168 ps=1.42 w=1.12 l=0.15
X13 X a_125_368# VPWR VPB sky130_fd_pr__pfet_01v8 ad=0.168 pd=1.42 as=0.168 ps=1.42 w=1.12 l=0.15
X14 X a_125_368# VGND VNB sky130_fd_pr__nfet_01v8_lvt ad=0.06405 pd=0.725 as=0.08295 ps=0.815 w=0.42 l=0.15
X15 VGND a_125_368# X VNB sky130_fd_pr__nfet_01v8_lvt ad=0.0588 pd=0.7 as=0.0588 ps=0.7 w=0.42 l=0.15
X16 VGND A a_125_368# VNB sky130_fd_pr__nfet_01v8_lvt ad=0.08295 pd=0.815 as=0.0588 ps=0.7 w=0.42 l=0.15
X17 VPWR a_125_368# X VPB sky130_fd_pr__pfet_01v8 ad=0.168 pd=1.42 as=0.168 ps=1.42 w=1.12 l=0.15
X18 VPWR a_125_368# X VPB sky130_fd_pr__pfet_01v8 ad=0.3304 pd=2.83 as=0.1764 ps=1.435 w=1.12 l=0.15
X19 X a_125_368# VPWR VPB sky130_fd_pr__pfet_01v8 ad=0.168 pd=1.42 as=0.224 ps=1.52 w=1.12 l=0.15
.ends

.subckt sky130_fd_sc_hs__o211ai_1 VPWR VGND B1 Y C1 A2 A1 VNB VPB
X0 a_116_368# A1 VPWR VPB sky130_fd_pr__pfet_01v8 ad=0.1512 pd=1.39 as=0.3304 ps=2.83 w=1.12 l=0.15
X1 VGND A1 a_31_74# VNB sky130_fd_pr__nfet_01v8_lvt ad=0.1295 pd=1.09 as=0.2109 ps=2.05 w=0.74 l=0.15
X2 VPWR B1 Y VPB sky130_fd_pr__pfet_01v8 ad=0.196 pd=1.47 as=0.3192 ps=1.69 w=1.12 l=0.15
X3 Y C1 a_311_74# VNB sky130_fd_pr__nfet_01v8_lvt ad=0.4588 pd=2.72 as=0.1554 ps=1.16 w=0.74 l=0.15
X4 Y A2 a_116_368# VPB sky130_fd_pr__pfet_01v8 ad=0.3192 pd=1.69 as=0.1512 ps=1.39 w=1.12 l=0.15
X5 a_311_74# B1 a_31_74# VNB sky130_fd_pr__nfet_01v8_lvt ad=0.1554 pd=1.16 as=0.11655 ps=1.055 w=0.74 l=0.15
X6 a_31_74# A2 VGND VNB sky130_fd_pr__nfet_01v8_lvt ad=0.11655 pd=1.055 as=0.1295 ps=1.09 w=0.74 l=0.15
X7 Y C1 VPWR VPB sky130_fd_pr__pfet_01v8 ad=0.3304 pd=2.83 as=0.196 ps=1.47 w=1.12 l=0.15
.ends

.subckt sky130_fd_sc_hs__and4_1 VPWR VGND A B C D X VNB VPB
X0 a_257_74# B a_179_74# VNB sky130_fd_pr__nfet_01v8_lvt ad=0.0768 pd=0.88 as=0.0768 ps=0.88 w=0.64 l=0.15
X1 a_96_74# A VPWR VPB sky130_fd_pr__pfet_01v8 ad=0.147 pd=1.19 as=0.2898 ps=2.37 w=0.84 l=0.15
X2 VGND D a_335_74# VNB sky130_fd_pr__nfet_01v8_lvt ad=0.1277 pd=1.1 as=0.1344 ps=1.06 w=0.64 l=0.15
X3 VPWR D a_96_74# VPB sky130_fd_pr__pfet_01v8 ad=0.2198 pd=1.555 as=0.147 ps=1.19 w=0.84 l=0.15
X4 VPWR B a_96_74# VPB sky130_fd_pr__pfet_01v8 ad=0.2352 pd=1.4 as=0.147 ps=1.19 w=0.84 l=0.15
X5 X a_96_74# VPWR VPB sky130_fd_pr__pfet_01v8 ad=0.3304 pd=2.83 as=0.2198 ps=1.555 w=1.12 l=0.15
X6 a_335_74# C a_257_74# VNB sky130_fd_pr__nfet_01v8_lvt ad=0.1344 pd=1.06 as=0.0768 ps=0.88 w=0.64 l=0.15
X7 X a_96_74# VGND VNB sky130_fd_pr__nfet_01v8_lvt ad=0.2109 pd=2.05 as=0.1277 ps=1.1 w=0.74 l=0.15
X8 a_179_74# A a_96_74# VNB sky130_fd_pr__nfet_01v8_lvt ad=0.0768 pd=0.88 as=0.1696 ps=1.81 w=0.64 l=0.15
X9 a_96_74# C VPWR VPB sky130_fd_pr__pfet_01v8 ad=0.147 pd=1.19 as=0.2352 ps=1.4 w=0.84 l=0.15
.ends

.subckt sky130_fd_sc_hs__a21oi_1 VPWR VGND B1 Y A2 A1 VNB VPB
X0 Y A1 a_117_74# VNB sky130_fd_pr__nfet_01v8_lvt ad=0.1443 pd=1.13 as=0.0777 ps=0.95 w=0.74 l=0.15
X1 VGND B1 Y VNB sky130_fd_pr__nfet_01v8_lvt ad=0.2109 pd=2.05 as=0.1443 ps=1.13 w=0.74 l=0.15
X2 a_117_74# A2 VGND VNB sky130_fd_pr__nfet_01v8_lvt ad=0.0777 pd=0.95 as=0.1961 ps=2.01 w=0.74 l=0.15
X3 Y B1 a_29_368# VPB sky130_fd_pr__pfet_01v8 ad=0.308 pd=2.79 as=0.168 ps=1.42 w=1.12 l=0.15
X4 a_29_368# A1 VPWR VPB sky130_fd_pr__pfet_01v8 ad=0.168 pd=1.42 as=0.1848 ps=1.45 w=1.12 l=0.15
X5 VPWR A2 a_29_368# VPB sky130_fd_pr__pfet_01v8 ad=0.1848 pd=1.45 as=0.308 ps=2.79 w=1.12 l=0.15
.ends

.subckt sky130_fd_sc_hs__maj3_1 VPWR VGND A B X C VNB VPB
X0 a_84_74# B a_226_384# VPB sky130_fd_pr__pfet_01v8 ad=0.165 pd=1.33 as=0.135 ps=1.27 w=1 l=0.15
X1 a_406_384# B a_84_74# VPB sky130_fd_pr__pfet_01v8 ad=0.135 pd=1.27 as=0.165 ps=1.33 w=1 l=0.15
X2 a_598_384# A VPWR VPB sky130_fd_pr__pfet_01v8 ad=0.135 pd=1.27 as=0.195 ps=1.39 w=1 l=0.15
X3 a_226_384# A VPWR VPB sky130_fd_pr__pfet_01v8 ad=0.135 pd=1.27 as=0.1934 ps=1.475 w=1 l=0.15
X4 VGND C a_403_136# VNB sky130_fd_pr__nfet_01v8_lvt ad=0.1344 pd=1.06 as=0.0768 ps=0.88 w=0.64 l=0.15
X5 a_84_74# C a_595_136# VNB sky130_fd_pr__nfet_01v8_lvt ad=0.1733 pd=1.85 as=0.0864 ps=0.91 w=0.64 l=0.15
X6 a_403_136# B a_84_74# VNB sky130_fd_pr__nfet_01v8_lvt ad=0.0768 pd=0.88 as=0.1222 ps=1.08 w=0.64 l=0.15
X7 a_595_136# A VGND VNB sky130_fd_pr__nfet_01v8_lvt ad=0.0864 pd=0.91 as=0.1344 ps=1.06 w=0.64 l=0.15
X8 VGND a_84_74# X VNB sky130_fd_pr__nfet_01v8_lvt ad=0.1389 pd=1.135 as=0.2081 ps=2.05 w=0.74 l=0.15
X9 VPWR a_84_74# X VPB sky130_fd_pr__pfet_01v8 ad=0.1934 pd=1.475 as=0.3304 ps=2.83 w=1.12 l=0.15
X10 a_84_74# B a_223_120# VNB sky130_fd_pr__nfet_01v8_lvt ad=0.1222 pd=1.08 as=0.0768 ps=0.88 w=0.64 l=0.15
X11 a_223_120# A VGND VNB sky130_fd_pr__nfet_01v8_lvt ad=0.0768 pd=0.88 as=0.1389 ps=1.135 w=0.64 l=0.15
X12 VPWR C a_406_384# VPB sky130_fd_pr__pfet_01v8 ad=0.195 pd=1.39 as=0.135 ps=1.27 w=1 l=0.15
X13 a_84_74# C a_598_384# VPB sky130_fd_pr__pfet_01v8 ad=0.295 pd=2.59 as=0.135 ps=1.27 w=1 l=0.15
.ends

.subckt sky130_fd_sc_hs__nor2_2 VPWR VGND B Y A VNB VPB
X0 a_35_368# B Y VPB sky130_fd_pr__pfet_01v8 ad=0.168 pd=1.42 as=0.168 ps=1.42 w=1.12 l=0.15
X1 Y B VGND VNB sky130_fd_pr__nfet_01v8_lvt ad=0.1036 pd=1.02 as=0.2627 ps=2.19 w=0.74 l=0.15
X2 Y B a_35_368# VPB sky130_fd_pr__pfet_01v8 ad=0.168 pd=1.42 as=0.3304 ps=2.83 w=1.12 l=0.15
X3 VGND A Y VNB sky130_fd_pr__nfet_01v8_lvt ad=0.2627 pd=2.19 as=0.1036 ps=1.02 w=0.74 l=0.15
X4 a_35_368# A VPWR VPB sky130_fd_pr__pfet_01v8 ad=0.3304 pd=2.83 as=0.168 ps=1.42 w=1.12 l=0.15
X5 VPWR A a_35_368# VPB sky130_fd_pr__pfet_01v8 ad=0.168 pd=1.42 as=0.168 ps=1.42 w=1.12 l=0.15
.ends

.subckt sky130_fd_sc_hs__buf_8 VPWR VGND X A VNB VPB
X0 VGND a_27_74# X VNB sky130_fd_pr__nfet_01v8_lvt ad=0.1295 pd=1.09 as=0.1036 ps=1.02 w=0.74 l=0.15
X1 VPWR a_27_74# X VPB sky130_fd_pr__pfet_01v8 ad=0.196 pd=1.47 as=0.168 ps=1.42 w=1.12 l=0.15
X2 VGND A a_27_74# VNB sky130_fd_pr__nfet_01v8_lvt ad=0.1036 pd=1.02 as=0.1036 ps=1.02 w=0.74 l=0.15
X3 X a_27_74# VPWR VPB sky130_fd_pr__pfet_01v8 ad=0.168 pd=1.42 as=0.196 ps=1.47 w=1.12 l=0.15
X4 VPWR A a_27_74# VPB sky130_fd_pr__pfet_01v8 ad=0.168 pd=1.42 as=0.3304 ps=2.83 w=1.12 l=0.15
X5 X a_27_74# VGND VNB sky130_fd_pr__nfet_01v8_lvt ad=0.1036 pd=1.02 as=0.1554 ps=1.16 w=0.74 l=0.15
X6 VGND A a_27_74# VNB sky130_fd_pr__nfet_01v8_lvt ad=0.12025 pd=1.065 as=0.2109 ps=2.05 w=0.74 l=0.15
X7 VGND a_27_74# X VNB sky130_fd_pr__nfet_01v8_lvt ad=0.2627 pd=2.19 as=0.10545 ps=1.025 w=0.74 l=0.15
X8 VPWR a_27_74# X VPB sky130_fd_pr__pfet_01v8 ad=0.196 pd=1.47 as=0.196 ps=1.47 w=1.12 l=0.15
X9 a_27_74# A VGND VNB sky130_fd_pr__nfet_01v8_lvt ad=0.1036 pd=1.02 as=0.12025 ps=1.065 w=0.74 l=0.15
X10 VGND a_27_74# X VNB sky130_fd_pr__nfet_01v8_lvt ad=0.1554 pd=1.16 as=0.1036 ps=1.02 w=0.74 l=0.15
X11 VPWR a_27_74# X VPB sky130_fd_pr__pfet_01v8 ad=0.3304 pd=2.83 as=0.1764 ps=1.435 w=1.12 l=0.15
X12 X a_27_74# VPWR VPB sky130_fd_pr__pfet_01v8 ad=0.196 pd=1.47 as=0.168 ps=1.42 w=1.12 l=0.15
X13 VPWR a_27_74# X VPB sky130_fd_pr__pfet_01v8 ad=0.1876 pd=1.455 as=0.168 ps=1.42 w=1.12 l=0.15
X14 X a_27_74# VGND VNB sky130_fd_pr__nfet_01v8_lvt ad=0.1036 pd=1.02 as=0.1295 ps=1.09 w=0.74 l=0.15
X15 X a_27_74# VGND VNB sky130_fd_pr__nfet_01v8_lvt ad=0.10545 pd=1.025 as=0.1554 ps=1.16 w=0.74 l=0.15
X16 VPWR A a_27_74# VPB sky130_fd_pr__pfet_01v8 ad=0.168 pd=1.42 as=0.168 ps=1.42 w=1.12 l=0.15
X17 X a_27_74# VPWR VPB sky130_fd_pr__pfet_01v8 ad=0.168 pd=1.42 as=0.196 ps=1.47 w=1.12 l=0.15
X18 a_27_74# A VPWR VPB sky130_fd_pr__pfet_01v8 ad=0.168 pd=1.42 as=0.168 ps=1.42 w=1.12 l=0.15
X19 X a_27_74# VGND VNB sky130_fd_pr__nfet_01v8_lvt ad=0.1036 pd=1.02 as=0.1036 ps=1.02 w=0.74 l=0.15
X20 X a_27_74# VPWR VPB sky130_fd_pr__pfet_01v8 ad=0.1764 pd=1.435 as=0.1876 ps=1.455 w=1.12 l=0.15
X21 VGND a_27_74# X VNB sky130_fd_pr__nfet_01v8_lvt ad=0.1554 pd=1.16 as=0.1036 ps=1.02 w=0.74 l=0.15
.ends

.subckt sky130_fd_sc_hs__nor2_1 VPWR VGND B Y A VNB VPB
X0 a_116_368# A VPWR VPB sky130_fd_pr__pfet_01v8 ad=0.1512 pd=1.39 as=0.3304 ps=2.83 w=1.12 l=0.15
X1 Y A VGND VNB sky130_fd_pr__nfet_01v8_lvt ad=0.1036 pd=1.02 as=0.2109 ps=2.05 w=0.74 l=0.15
X2 Y B a_116_368# VPB sky130_fd_pr__pfet_01v8 ad=0.3304 pd=2.83 as=0.1512 ps=1.39 w=1.12 l=0.15
X3 VGND B Y VNB sky130_fd_pr__nfet_01v8_lvt ad=0.2109 pd=2.05 as=0.1036 ps=1.02 w=0.74 l=0.15
.ends

.subckt sky130_fd_sc_hs__nand3b_1 VPWR VGND A_N C Y B VNB VPB
X0 Y C VPWR VPB sky130_fd_pr__pfet_01v8 ad=0.168 pd=1.42 as=0.231 ps=1.555 w=1.12 l=0.15
X1 VGND A_N a_27_116# VNB sky130_fd_pr__nfet_01v8_lvt ad=0.22412 pd=1.365 as=0.15675 ps=1.67 w=0.55 l=0.15
X2 a_347_78# B a_269_78# VNB sky130_fd_pr__nfet_01v8_lvt ad=0.1443 pd=1.13 as=0.0888 ps=0.98 w=0.74 l=0.15
X3 Y a_27_116# a_347_78# VNB sky130_fd_pr__nfet_01v8_lvt ad=0.3404 pd=2.4 as=0.1443 ps=1.13 w=0.74 l=0.15
X4 VPWR A_N a_27_116# VPB sky130_fd_pr__pfet_01v8 ad=0.231 pd=1.555 as=0.2478 ps=2.27 w=0.84 l=0.15
X5 Y a_27_116# VPWR VPB sky130_fd_pr__pfet_01v8 ad=0.3304 pd=2.83 as=0.224 ps=1.52 w=1.12 l=0.15
X6 a_269_78# C VGND VNB sky130_fd_pr__nfet_01v8_lvt ad=0.0888 pd=0.98 as=0.22412 ps=1.365 w=0.74 l=0.15
X7 VPWR B Y VPB sky130_fd_pr__pfet_01v8 ad=0.224 pd=1.52 as=0.168 ps=1.42 w=1.12 l=0.15
.ends

.subckt sky130_fd_sc_hs__conb_1 VPWR VGND LO HI VNB VPB
X0 VPWR HI sky130_fd_pr__res_generic_po w=0.51 l=0.045
X1 LO VGND sky130_fd_pr__res_generic_po w=0.51 l=0.045
.ends

.subckt sky130_fd_sc_hs__a32o_1 VPWR VGND X B2 B1 A2 A1 A3 VNB VPB
X0 a_601_94# B1 a_84_48# VNB sky130_fd_pr__nfet_01v8_lvt ad=0.0768 pd=0.88 as=0.2016 ps=1.27 w=0.64 l=0.15
X1 a_337_94# A2 a_259_94# VNB sky130_fd_pr__nfet_01v8_lvt ad=0.1248 pd=1.03 as=0.0768 ps=0.88 w=0.64 l=0.15
X2 a_84_48# A1 a_337_94# VNB sky130_fd_pr__nfet_01v8_lvt ad=0.2016 pd=1.27 as=0.1248 ps=1.03 w=0.64 l=0.15
X3 VGND a_84_48# X VNB sky130_fd_pr__nfet_01v8_lvt ad=0.209 pd=1.315 as=0.2109 ps=2.05 w=0.74 l=0.15
X4 VPWR a_84_48# X VPB sky130_fd_pr__pfet_01v8 ad=0.2607 pd=1.6 as=0.3304 ps=2.83 w=1.12 l=0.15
X5 VPWR A2 a_244_368# VPB sky130_fd_pr__pfet_01v8 ad=0.295 pd=1.59 as=0.15 ps=1.3 w=1 l=0.15
X6 a_84_48# B1 a_244_368# VPB sky130_fd_pr__pfet_01v8 ad=0.2 pd=1.4 as=0.15 ps=1.3 w=1 l=0.15
X7 a_244_368# A3 VPWR VPB sky130_fd_pr__pfet_01v8 ad=0.15 pd=1.3 as=0.2607 ps=1.6 w=1 l=0.15
X8 a_244_368# A1 VPWR VPB sky130_fd_pr__pfet_01v8 ad=0.15 pd=1.3 as=0.295 ps=1.59 w=1 l=0.15
X9 a_259_94# A3 VGND VNB sky130_fd_pr__nfet_01v8_lvt ad=0.0768 pd=0.88 as=0.209 ps=1.315 w=0.64 l=0.15
X10 a_244_368# B2 a_84_48# VPB sky130_fd_pr__pfet_01v8 ad=0.295 pd=2.59 as=0.2 ps=1.4 w=1 l=0.15
X11 VGND B2 a_601_94# VNB sky130_fd_pr__nfet_01v8_lvt ad=0.1824 pd=1.85 as=0.0768 ps=0.88 w=0.64 l=0.15
.ends

.subckt sky130_fd_sc_hs__nand3_1 VPWR VGND C Y B A VNB VPB
X0 a_233_74# B a_155_74# VNB sky130_fd_pr__nfet_01v8_lvt ad=0.1554 pd=1.16 as=0.0888 ps=0.98 w=0.74 l=0.15
X1 VPWR B Y VPB sky130_fd_pr__pfet_01v8 ad=0.2352 pd=1.54 as=0.168 ps=1.42 w=1.12 l=0.15
X2 Y C VPWR VPB sky130_fd_pr__pfet_01v8 ad=0.168 pd=1.42 as=0.42 ps=2.99 w=1.12 l=0.15
X3 Y A VPWR VPB sky130_fd_pr__pfet_01v8 ad=0.3304 pd=2.83 as=0.2352 ps=1.54 w=1.12 l=0.15
X4 a_155_74# C VGND VNB sky130_fd_pr__nfet_01v8_lvt ad=0.0888 pd=0.98 as=0.2109 ps=2.05 w=0.74 l=0.15
X5 Y A a_233_74# VNB sky130_fd_pr__nfet_01v8_lvt ad=0.2109 pd=2.05 as=0.1554 ps=1.16 w=0.74 l=0.15
.ends

.subckt sky130_fd_sc_hs__o311ai_1 VPWR VGND A2 A1 C1 B1 Y A3 VNB VPB
X0 Y C1 VPWR VPB sky130_fd_pr__pfet_01v8 ad=0.3304 pd=2.83 as=0.2352 ps=1.54 w=1.12 l=0.15
X1 a_128_74# A3 VGND VNB sky130_fd_pr__nfet_01v8_lvt ad=0.1295 pd=1.09 as=0.222 ps=1.34 w=0.74 l=0.15
X2 a_128_74# A1 VGND VNB sky130_fd_pr__nfet_01v8_lvt ad=0.11285 pd=1.045 as=0.2627 ps=2.19 w=0.74 l=0.15
X3 a_222_368# A2 a_138_368# VPB sky130_fd_pr__pfet_01v8 ad=0.2352 pd=1.54 as=0.1512 ps=1.39 w=1.12 l=0.15
X4 VGND A2 a_128_74# VNB sky130_fd_pr__nfet_01v8_lvt ad=0.222 pd=1.34 as=0.11285 ps=1.045 w=0.74 l=0.15
X5 a_138_368# A1 VPWR VPB sky130_fd_pr__pfet_01v8 ad=0.1512 pd=1.39 as=0.3304 ps=2.83 w=1.12 l=0.15
X6 Y A3 a_222_368# VPB sky130_fd_pr__pfet_01v8 ad=0.2352 pd=1.54 as=0.2352 ps=1.54 w=1.12 l=0.15
X7 a_469_74# B1 a_128_74# VNB sky130_fd_pr__nfet_01v8_lvt ad=0.1147 pd=1.05 as=0.1295 ps=1.09 w=0.74 l=0.15
X8 VPWR B1 Y VPB sky130_fd_pr__pfet_01v8 ad=0.2352 pd=1.54 as=0.2352 ps=1.54 w=1.12 l=0.15
X9 Y C1 a_469_74# VNB sky130_fd_pr__nfet_01v8_lvt ad=0.2109 pd=2.05 as=0.1147 ps=1.05 w=0.74 l=0.15
.ends

.subckt sky130_fd_sc_hs__a31o_1 VPWR VGND X A3 A2 A1 B1 VNB VPB
X0 VGND a_81_270# X VNB sky130_fd_pr__nfet_01v8_lvt ad=0.20655 pd=1.33 as=0.1961 ps=2.01 w=0.74 l=0.15
X1 VGND B1 a_81_270# VNB sky130_fd_pr__nfet_01v8_lvt ad=0.1696 pd=1.81 as=0.1408 ps=1.08 w=0.64 l=0.15
X2 a_337_120# A2 a_265_120# VNB sky130_fd_pr__nfet_01v8_lvt ad=0.12562 pd=1.045 as=0.0672 ps=0.85 w=0.64 l=0.15
X3 a_81_270# A1 a_337_120# VNB sky130_fd_pr__nfet_01v8_lvt ad=0.1408 pd=1.08 as=0.12562 ps=1.045 w=0.64 l=0.15
X4 a_265_120# A3 VGND VNB sky130_fd_pr__nfet_01v8_lvt ad=0.0672 pd=0.85 as=0.20655 ps=1.33 w=0.64 l=0.15
X5 VPWR A2 a_250_392# VPB sky130_fd_pr__pfet_01v8 ad=0.24 pd=1.48 as=0.15 ps=1.3 w=1 l=0.15
X6 a_250_392# A3 VPWR VPB sky130_fd_pr__pfet_01v8 ad=0.15 pd=1.3 as=0.2809 ps=1.65 w=1 l=0.15
X7 VPWR a_81_270# X VPB sky130_fd_pr__pfet_01v8 ad=0.2809 pd=1.65 as=0.308 ps=2.79 w=1.12 l=0.15
X8 a_81_270# B1 a_250_392# VPB sky130_fd_pr__pfet_01v8 ad=0.275 pd=2.55 as=0.15 ps=1.3 w=1 l=0.15
X9 a_250_392# A1 VPWR VPB sky130_fd_pr__pfet_01v8 ad=0.15 pd=1.3 as=0.24 ps=1.48 w=1 l=0.15
.ends

.subckt sky130_fd_sc_hs__o32ai_1 VPWR VGND Y B2 B1 A3 A2 A1 VNB VPB
X0 a_456_368# A2 a_342_368# VPB sky130_fd_pr__pfet_01v8 ad=0.2352 pd=1.54 as=0.2352 ps=1.54 w=1.12 l=0.15
X1 a_128_368# B1 VPWR VPB sky130_fd_pr__pfet_01v8 ad=0.1512 pd=1.39 as=0.3752 ps=2.91 w=1.12 l=0.15
X2 VPWR A1 a_456_368# VPB sky130_fd_pr__pfet_01v8 ad=0.3304 pd=2.83 as=0.2352 ps=1.54 w=1.12 l=0.15
X3 Y B1 a_27_74# VNB sky130_fd_pr__nfet_01v8_lvt ad=0.21645 pd=1.325 as=0.2109 ps=2.05 w=0.74 l=0.15
X4 VGND A3 a_27_74# VNB sky130_fd_pr__nfet_01v8_lvt ad=0.1665 pd=1.19 as=0.1295 ps=1.09 w=0.74 l=0.15
X5 a_27_74# A2 VGND VNB sky130_fd_pr__nfet_01v8_lvt ad=0.1036 pd=1.02 as=0.1665 ps=1.19 w=0.74 l=0.15
X6 Y B2 a_128_368# VPB sky130_fd_pr__pfet_01v8 ad=0.28 pd=1.62 as=0.1512 ps=1.39 w=1.12 l=0.15
X7 a_27_74# B2 Y VNB sky130_fd_pr__nfet_01v8_lvt ad=0.1295 pd=1.09 as=0.21645 ps=1.325 w=0.74 l=0.15
X8 VGND A1 a_27_74# VNB sky130_fd_pr__nfet_01v8_lvt ad=0.2109 pd=2.05 as=0.1036 ps=1.02 w=0.74 l=0.15
X9 a_342_368# A3 Y VPB sky130_fd_pr__pfet_01v8 ad=0.2352 pd=1.54 as=0.28 ps=1.62 w=1.12 l=0.15
.ends

.subckt sky130_fd_sc_hs__nor3b_1 VPWR VGND Y C_N A B VNB VPB
X0 VGND B Y VNB sky130_fd_pr__nfet_01v8_lvt ad=0.1554 pd=1.16 as=0.1184 ps=1.06 w=0.74 l=0.15
X1 VPWR C_N a_27_112# VPB sky130_fd_pr__pfet_01v8 ad=0.2177 pd=1.54 as=0.2478 ps=2.27 w=0.84 l=0.15
X2 a_344_368# B a_260_368# VPB sky130_fd_pr__pfet_01v8 ad=0.2352 pd=1.54 as=0.1512 ps=1.39 w=1.12 l=0.15
X3 a_260_368# A VPWR VPB sky130_fd_pr__pfet_01v8 ad=0.1512 pd=1.39 as=0.2177 ps=1.54 w=1.12 l=0.15
X4 Y a_27_112# a_344_368# VPB sky130_fd_pr__pfet_01v8 ad=0.3304 pd=2.83 as=0.2352 ps=1.54 w=1.12 l=0.15
X5 Y a_27_112# VGND VNB sky130_fd_pr__nfet_01v8_lvt ad=0.2109 pd=2.05 as=0.1554 ps=1.16 w=0.74 l=0.15
X6 Y A VGND VNB sky130_fd_pr__nfet_01v8_lvt ad=0.1184 pd=1.06 as=0.13717 ps=1.13 w=0.74 l=0.15
X7 VGND C_N a_27_112# VNB sky130_fd_pr__nfet_01v8_lvt ad=0.13717 pd=1.13 as=0.2695 ps=2.08 w=0.55 l=0.15
.ends

.subckt sky130_fd_sc_hs__o32a_1 VPWR VGND B1 A1 A2 A3 B2 X VNB VPB
X0 VPWR a_83_264# X VPB sky130_fd_pr__pfet_01v8 ad=0.2757 pd=1.63 as=0.3304 ps=2.83 w=1.12 l=0.15
X1 a_251_74# A3 VGND VNB sky130_fd_pr__nfet_01v8_lvt ad=0.112 pd=0.99 as=0.1344 ps=1.06 w=0.64 l=0.15
X2 a_332_368# A2 a_248_368# VPB sky130_fd_pr__pfet_01v8 ad=0.195 pd=1.39 as=0.135 ps=1.27 w=1 l=0.15
X3 a_83_264# A3 a_332_368# VPB sky130_fd_pr__pfet_01v8 ad=0.195 pd=1.39 as=0.195 ps=1.39 w=1 l=0.15
X4 a_248_368# A1 VPWR VPB sky130_fd_pr__pfet_01v8 ad=0.135 pd=1.27 as=0.2757 ps=1.63 w=1 l=0.15
X5 VGND a_83_264# X VNB sky130_fd_pr__nfet_01v8_lvt ad=0.1469 pd=1.16 as=0.2109 ps=2.05 w=0.74 l=0.15
X6 a_548_368# B2 a_83_264# VPB sky130_fd_pr__pfet_01v8 ad=0.2225 pd=1.445 as=0.195 ps=1.39 w=1 l=0.15
X7 VPWR B1 a_548_368# VPB sky130_fd_pr__pfet_01v8 ad=0.295 pd=2.59 as=0.2225 ps=1.445 w=1 l=0.15
X8 a_251_74# A1 VGND VNB sky130_fd_pr__nfet_01v8_lvt ad=0.0896 pd=0.92 as=0.1469 ps=1.16 w=0.64 l=0.15
X9 VGND A2 a_251_74# VNB sky130_fd_pr__nfet_01v8_lvt ad=0.1344 pd=1.06 as=0.0896 ps=0.92 w=0.64 l=0.15
X10 a_83_264# B2 a_251_74# VNB sky130_fd_pr__nfet_01v8_lvt ad=0.1424 pd=1.085 as=0.112 ps=0.99 w=0.64 l=0.15
X11 a_251_74# B1 a_83_264# VNB sky130_fd_pr__nfet_01v8_lvt ad=0.2144 pd=1.95 as=0.1424 ps=1.085 w=0.64 l=0.15
.ends

.subckt sky130_fd_sc_hs__o31ai_1 VPWR VGND A3 A2 B1 A1 Y VNB VPB
X0 VPWR B1 Y VPB sky130_fd_pr__pfet_01v8 ad=0.3304 pd=2.83 as=0.3864 ps=1.81 w=1.12 l=0.15
X1 a_203_368# A2 a_119_368# VPB sky130_fd_pr__pfet_01v8 ad=0.2352 pd=1.54 as=0.1512 ps=1.39 w=1.12 l=0.15
X2 Y A3 a_203_368# VPB sky130_fd_pr__pfet_01v8 ad=0.3864 pd=1.81 as=0.2352 ps=1.54 w=1.12 l=0.15
X3 a_114_74# A1 VGND VNB sky130_fd_pr__nfet_01v8_lvt ad=0.1036 pd=1.02 as=0.2109 ps=2.05 w=0.74 l=0.15
X4 Y B1 a_114_74# VNB sky130_fd_pr__nfet_01v8_lvt ad=0.2479 pd=2.15 as=0.111 ps=1.04 w=0.74 l=0.15
X5 a_119_368# A1 VPWR VPB sky130_fd_pr__pfet_01v8 ad=0.1512 pd=1.39 as=0.3304 ps=2.83 w=1.12 l=0.15
X6 VGND A2 a_114_74# VNB sky130_fd_pr__nfet_01v8_lvt ad=0.3492 pd=1.7 as=0.1036 ps=1.02 w=0.74 l=0.15
X7 a_114_74# A3 VGND VNB sky130_fd_pr__nfet_01v8_lvt ad=0.111 pd=1.04 as=0.3492 ps=1.7 w=0.74 l=0.15
.ends

.subckt sky130_fd_sc_hs__a222o_1 VPWR VGND C2 X C1 B2 A2 A1 B1 VNB VPB
X0 a_337_390# A1 VPWR VPB sky130_fd_pr__pfet_01v8 ad=0.15 pd=1.3 as=0.345 ps=2.69 w=1 l=0.15
X1 a_32_74# B1 a_386_74# VNB sky130_fd_pr__nfet_01v8_lvt ad=0.2512 pd=1.425 as=0.0768 ps=0.88 w=0.64 l=0.15
X2 a_119_74# C1 a_32_74# VNB sky130_fd_pr__nfet_01v8_lvt ad=0.0768 pd=0.88 as=0.1824 ps=1.85 w=0.64 l=0.15
X3 a_27_390# B1 a_337_390# VPB sky130_fd_pr__pfet_01v8 ad=0.295 pd=2.59 as=0.22 ps=1.44 w=1 l=0.15
X4 X a_32_74# VGND VNB sky130_fd_pr__nfet_01v8_lvt ad=0.2109 pd=2.05 as=0.1997 ps=1.325 w=0.74 l=0.15
X5 VGND C2 a_119_74# VNB sky130_fd_pr__nfet_01v8_lvt ad=0.2544 pd=1.435 as=0.0768 ps=0.88 w=0.64 l=0.15
X6 a_337_390# B2 a_27_390# VPB sky130_fd_pr__pfet_01v8 ad=0.22 pd=1.44 as=0.175 ps=1.35 w=1 l=0.15
X7 a_32_74# C1 a_27_390# VPB sky130_fd_pr__pfet_01v8 ad=0.2275 pd=1.455 as=0.295 ps=2.59 w=1 l=0.15
X8 VGND A2 a_651_74# VNB sky130_fd_pr__nfet_01v8_lvt ad=0.1997 pd=1.325 as=0.0768 ps=0.88 w=0.64 l=0.15
X9 a_651_74# A1 a_32_74# VNB sky130_fd_pr__nfet_01v8_lvt ad=0.0768 pd=0.88 as=0.2512 ps=1.425 w=0.64 l=0.15
X10 a_386_74# B2 VGND VNB sky130_fd_pr__nfet_01v8_lvt ad=0.0768 pd=0.88 as=0.2544 ps=1.435 w=0.64 l=0.15
X11 a_27_390# C2 a_32_74# VPB sky130_fd_pr__pfet_01v8 ad=0.175 pd=1.35 as=0.2275 ps=1.455 w=1 l=0.15
X12 X a_32_74# VPWR VPB sky130_fd_pr__pfet_01v8 ad=0.3304 pd=2.83 as=0.2352 ps=1.555 w=1.12 l=0.15
X13 VPWR A2 a_337_390# VPB sky130_fd_pr__pfet_01v8 ad=0.2352 pd=1.555 as=0.15 ps=1.3 w=1 l=0.15
.ends

.subckt sky130_fd_sc_hs__o22a_1 VPWR VGND X B1 A2 B2 A1 VNB VPB
X0 VPWR a_83_260# X VPB sky130_fd_pr__pfet_01v8 ad=0.6459 pd=2.38 as=0.3304 ps=2.83 w=1.12 l=0.15
X1 a_299_139# B2 a_83_260# VNB sky130_fd_pr__nfet_01v8_lvt ad=0.0896 pd=0.92 as=0.1024 ps=0.96 w=0.64 l=0.15
X2 a_299_139# A1 VGND VNB sky130_fd_pr__nfet_01v8_lvt ad=0.18205 pd=1.85 as=0.14472 ps=1.125 w=0.64 l=0.15
X3 VGND a_83_260# X VNB sky130_fd_pr__nfet_01v8_lvt ad=0.2109 pd=2.05 as=0.2109 ps=2.05 w=0.74 l=0.15
X4 VGND A2 a_299_139# VNB sky130_fd_pr__nfet_01v8_lvt ad=0.14472 pd=1.125 as=0.0896 ps=0.92 w=0.64 l=0.15
X5 a_572_392# A2 a_83_260# VPB sky130_fd_pr__pfet_01v8 ad=0.195 pd=1.39 as=0.15 ps=1.3 w=1 l=0.15
X6 a_83_260# B1 a_299_139# VNB sky130_fd_pr__nfet_01v8_lvt ad=0.1024 pd=0.96 as=0.1705 ps=1.85 w=0.64 l=0.15
X7 a_83_260# B2 a_398_392# VPB sky130_fd_pr__pfet_01v8 ad=0.15 pd=1.3 as=0.135 ps=1.27 w=1 l=0.15
X8 VPWR A1 a_572_392# VPB sky130_fd_pr__pfet_01v8 ad=0.295 pd=2.59 as=0.195 ps=1.39 w=1 l=0.15
X9 a_398_392# B1 VPWR VPB sky130_fd_pr__pfet_01v8 ad=0.135 pd=1.27 as=0.6459 ps=2.38 w=1 l=0.15
.ends

.subckt sky130_fd_sc_hs__dfrtp_2 RESET_B VPWR VGND D CLK Q VNB VPB
X0 a_786_457# a_306_74# a_696_457# VPB sky130_fd_pr__pfet_01v8 ad=0.0567 pd=0.69 as=0.063 ps=0.72 w=0.42 l=0.15
X1 a_696_457# a_490_362# a_30_78# VPB sky130_fd_pr__pfet_01v8 ad=0.063 pd=0.72 as=0.1218 ps=1.42 w=0.42 l=0.15
X2 a_1478_493# a_490_362# a_1271_74# VPB sky130_fd_pr__pfet_01v8 ad=0.0567 pd=0.69 as=0.22695 ps=1.83 w=0.42 l=0.15
X3 a_1921_409# a_1271_74# VPWR VPB sky130_fd_pr__pfet_01v8 ad=0.2478 pd=2.27 as=0.1638 ps=1.275 w=0.84 l=0.15
X4 a_1525_212# a_1271_74# a_1663_81# VNB sky130_fd_pr__nfet_01v8_lvt ad=0.1176 pd=1.4 as=0.0504 ps=0.66 w=0.42 l=0.15
X5 VGND a_1921_409# Q VNB sky130_fd_pr__nfet_01v8_lvt ad=0.2072 pd=2.04 as=0.1036 ps=1.02 w=0.74 l=0.15
X6 VGND RESET_B a_895_138# VNB sky130_fd_pr__nfet_01v8_lvt ad=0.35328 pd=1.84 as=0.0504 ps=0.66 w=0.42 l=0.15
X7 a_1271_74# a_490_362# a_837_359# VNB sky130_fd_pr__nfet_01v8_lvt ad=0.229 pd=1.64 as=0.12025 ps=1.065 w=0.74 l=0.15
X8 a_837_359# a_696_457# VPWR VPB sky130_fd_pr__pfet_01v8 ad=0.18405 pd=1.43 as=0.295 ps=2.59 w=1 l=0.15
X9 a_895_138# a_837_359# a_817_138# VNB sky130_fd_pr__nfet_01v8_lvt ad=0.0504 pd=0.66 as=0.0504 ps=0.66 w=0.42 l=0.15
X10 a_837_359# a_696_457# VGND VNB sky130_fd_pr__nfet_01v8_lvt ad=0.12025 pd=1.065 as=0.35328 ps=1.84 w=0.74 l=0.15
X11 Q a_1921_409# VGND VNB sky130_fd_pr__nfet_01v8_lvt ad=0.1036 pd=1.02 as=0.2109 ps=2.05 w=0.74 l=0.15
X12 a_817_138# a_490_362# a_696_457# VNB sky130_fd_pr__nfet_01v8_lvt ad=0.0504 pd=0.66 as=0.0735 ps=0.77 w=0.42 l=0.15
X13 VPWR RESET_B a_30_78# VPB sky130_fd_pr__pfet_01v8 ad=0.1176 pd=1.4 as=0.063 ps=0.72 w=0.42 l=0.15
X14 VGND a_1525_212# a_1481_81# VNB sky130_fd_pr__nfet_01v8_lvt ad=0.0777 pd=0.79 as=0.0504 ps=0.66 w=0.42 l=0.15
X15 a_1921_409# a_1271_74# VGND VNB sky130_fd_pr__nfet_01v8_lvt ad=0.2109 pd=2.05 as=0.2072 ps=2.04 w=0.74 l=0.15
X16 a_117_78# D a_30_78# VNB sky130_fd_pr__nfet_01v8_lvt ad=0.0504 pd=0.66 as=0.1197 ps=1.41 w=0.42 l=0.15
X17 VPWR a_1921_409# Q VPB sky130_fd_pr__pfet_01v8 ad=0.3304 pd=2.83 as=0.168 ps=1.42 w=1.12 l=0.15
X18 a_1481_81# a_306_74# a_1271_74# VNB sky130_fd_pr__nfet_01v8_lvt ad=0.0504 pd=0.66 as=0.229 ps=1.64 w=0.42 l=0.15
X19 a_1525_212# RESET_B VPWR VPB sky130_fd_pr__pfet_01v8 ad=0.1176 pd=0.98 as=0.0735 ps=0.77 w=0.42 l=0.15
X20 Q a_1921_409# VPWR VPB sky130_fd_pr__pfet_01v8 ad=0.168 pd=1.42 as=0.3584 ps=2.88 w=1.12 l=0.15
X21 a_1663_81# RESET_B VGND VNB sky130_fd_pr__nfet_01v8_lvt ad=0.0504 pd=0.66 as=0.0777 ps=0.79 w=0.42 l=0.15
X22 VPWR a_1271_74# a_1525_212# VPB sky130_fd_pr__pfet_01v8 ad=0.1638 pd=1.275 as=0.1176 ps=0.98 w=0.42 l=0.15
X23 a_490_362# a_306_74# VGND VNB sky130_fd_pr__nfet_01v8_lvt ad=0.2109 pd=2.05 as=0.1554 ps=1.16 w=0.74 l=0.15
X24 a_696_457# a_306_74# a_30_78# VNB sky130_fd_pr__nfet_01v8_lvt ad=0.0735 pd=0.77 as=0.1197 ps=1.41 w=0.42 l=0.15
X25 VGND RESET_B a_117_78# VNB sky130_fd_pr__nfet_01v8_lvt ad=0.1197 pd=1.41 as=0.0504 ps=0.66 w=0.42 l=0.15
X26 a_696_457# RESET_B VPWR VPB sky130_fd_pr__pfet_01v8 ad=0.1239 pd=1.43 as=0.1393 ps=1.17 w=0.42 l=0.15
X27 a_1271_74# a_306_74# a_837_359# VPB sky130_fd_pr__pfet_01v8 ad=0.22695 pd=1.83 as=0.18405 ps=1.43 w=1 l=0.15
X28 a_490_362# a_306_74# VPWR VPB sky130_fd_pr__pfet_01v8 ad=0.3136 pd=2.8 as=0.168 ps=1.42 w=1.12 l=0.15
X29 VPWR a_837_359# a_786_457# VPB sky130_fd_pr__pfet_01v8 ad=0.1393 pd=1.17 as=0.0567 ps=0.69 w=0.42 l=0.15
X30 a_30_78# D VPWR VPB sky130_fd_pr__pfet_01v8 ad=0.063 pd=0.72 as=0.1197 ps=1.41 w=0.42 l=0.15
X31 VPWR CLK a_306_74# VPB sky130_fd_pr__pfet_01v8 ad=0.168 pd=1.42 as=0.3136 ps=2.8 w=1.12 l=0.15
X32 VPWR a_1525_212# a_1478_493# VPB sky130_fd_pr__pfet_01v8 ad=0.0735 pd=0.77 as=0.0567 ps=0.69 w=0.42 l=0.15
X33 VGND CLK a_306_74# VNB sky130_fd_pr__nfet_01v8_lvt ad=0.1554 pd=1.16 as=0.2109 ps=2.05 w=0.74 l=0.15
.ends

.subckt sky130_fd_sc_hs__nor3_1 VPWR VGND Y C B A VNB VPB
X0 a_198_368# B a_114_368# VPB sky130_fd_pr__pfet_01v8 ad=0.2016 pd=1.48 as=0.1512 ps=1.39 w=1.12 l=0.15
X1 Y C a_198_368# VPB sky130_fd_pr__pfet_01v8 ad=0.3192 pd=2.81 as=0.2016 ps=1.48 w=1.12 l=0.15
X2 Y A VGND VNB sky130_fd_pr__nfet_01v8_lvt ad=0.1036 pd=1.02 as=0.2109 ps=2.05 w=0.74 l=0.15
X3 Y C VGND VNB sky130_fd_pr__nfet_01v8_lvt ad=0.2109 pd=2.05 as=0.1295 ps=1.09 w=0.74 l=0.15
X4 a_114_368# A VPWR VPB sky130_fd_pr__pfet_01v8 ad=0.1512 pd=1.39 as=0.3192 ps=2.81 w=1.12 l=0.15
X5 VGND B Y VNB sky130_fd_pr__nfet_01v8_lvt ad=0.1295 pd=1.09 as=0.1036 ps=1.02 w=0.74 l=0.15
.ends

.subckt sky130_fd_sc_hs__a22oi_1 VPWR VGND B2 Y B1 A2 A1 VNB VPB
X0 Y B1 a_159_74# VNB sky130_fd_pr__nfet_01v8_lvt ad=0.1443 pd=1.13 as=0.0777 ps=0.95 w=0.74 l=0.15
X1 a_159_74# B2 VGND VNB sky130_fd_pr__nfet_01v8_lvt ad=0.0777 pd=0.95 as=0.1961 ps=2.01 w=0.74 l=0.15
X2 a_339_74# A1 Y VNB sky130_fd_pr__nfet_01v8_lvt ad=0.1443 pd=1.13 as=0.1443 ps=1.13 w=0.74 l=0.15
X3 VGND A2 a_339_74# VNB sky130_fd_pr__nfet_01v8_lvt ad=0.1961 pd=2.01 as=0.1443 ps=1.13 w=0.74 l=0.15
X4 VPWR A1 a_71_368# VPB sky130_fd_pr__pfet_01v8 ad=0.2184 pd=1.51 as=0.1848 ps=1.45 w=1.12 l=0.15
X5 a_71_368# B1 Y VPB sky130_fd_pr__pfet_01v8 ad=0.1848 pd=1.45 as=0.168 ps=1.42 w=1.12 l=0.15
X6 Y B2 a_71_368# VPB sky130_fd_pr__pfet_01v8 ad=0.168 pd=1.42 as=0.308 ps=2.79 w=1.12 l=0.15
X7 a_71_368# A2 VPWR VPB sky130_fd_pr__pfet_01v8 ad=0.308 pd=2.79 as=0.2184 ps=1.51 w=1.12 l=0.15
.ends

.subckt sky130_fd_sc_hs__xor2_1 VPWR VGND A B X VNB VPB
X0 X B a_455_87# VNB sky130_fd_pr__nfet_01v8_lvt ad=0.1554 pd=1.16 as=0.0888 ps=0.98 w=0.74 l=0.15
X1 X a_194_125# a_355_368# VPB sky130_fd_pr__pfet_01v8 ad=0.3864 pd=2.93 as=0.196 ps=1.47 w=1.12 l=0.15
X2 a_194_125# B a_158_392# VPB sky130_fd_pr__pfet_01v8 ad=0.295 pd=2.59 as=0.135 ps=1.27 w=1 l=0.15
X3 VPWR A a_355_368# VPB sky130_fd_pr__pfet_01v8 ad=0.2352 pd=1.54 as=0.3752 ps=2.91 w=1.12 l=0.15
X4 a_158_392# A VPWR VPB sky130_fd_pr__pfet_01v8 ad=0.135 pd=1.27 as=0.295 ps=2.59 w=1 l=0.15
X5 a_355_368# B VPWR VPB sky130_fd_pr__pfet_01v8 ad=0.196 pd=1.47 as=0.2352 ps=1.54 w=1.12 l=0.15
X6 a_194_125# A VGND VNB sky130_fd_pr__nfet_01v8_lvt ad=0.17738 pd=1.195 as=0.33275 ps=2.31 w=0.55 l=0.15
X7 a_455_87# A VGND VNB sky130_fd_pr__nfet_01v8_lvt ad=0.0888 pd=0.98 as=0.12607 ps=1.1 w=0.74 l=0.15
X8 VGND B a_194_125# VNB sky130_fd_pr__nfet_01v8_lvt ad=0.12607 pd=1.1 as=0.17738 ps=1.195 w=0.55 l=0.15
X9 VGND a_194_125# X VNB sky130_fd_pr__nfet_01v8_lvt ad=0.2997 pd=2.29 as=0.1554 ps=1.16 w=0.74 l=0.15
.ends

.subckt sky130_fd_sc_hs__buf_1 VPWR VGND A X VNB VPB
X0 VGND A a_27_164# VNB sky130_fd_pr__nfet_01v8_lvt ad=0.15198 pd=1.17 as=0.24915 ps=2.37 w=0.55 l=0.15
X1 X a_27_164# VGND VNB sky130_fd_pr__nfet_01v8_lvt ad=0.2109 pd=2.05 as=0.15198 ps=1.17 w=0.74 l=0.15
X2 X a_27_164# VPWR VPB sky130_fd_pr__pfet_01v8 ad=0.3304 pd=2.83 as=0.2051 ps=1.52 w=1.12 l=0.15
X3 VPWR A a_27_164# VPB sky130_fd_pr__pfet_01v8 ad=0.2051 pd=1.52 as=0.2478 ps=2.27 w=0.84 l=0.15
.ends

.subckt sky130_fd_sc_hs__a211oi_1 VPWR VGND C1 Y B1 A2 A1 VNB VPB
X0 a_71_368# A1 VPWR VPB sky130_fd_pr__pfet_01v8 ad=0.168 pd=1.42 as=0.2184 ps=1.51 w=1.12 l=0.15
X1 Y A1 a_159_74# VNB sky130_fd_pr__nfet_01v8_lvt ad=0.1443 pd=1.13 as=0.0777 ps=0.95 w=0.74 l=0.15
X2 a_159_74# A2 VGND VNB sky130_fd_pr__nfet_01v8_lvt ad=0.0777 pd=0.95 as=0.1961 ps=2.01 w=0.74 l=0.15
X3 VGND B1 Y VNB sky130_fd_pr__nfet_01v8_lvt ad=0.1443 pd=1.13 as=0.1443 ps=1.13 w=0.74 l=0.15
X4 Y C1 VGND VNB sky130_fd_pr__nfet_01v8_lvt ad=0.1961 pd=2.01 as=0.1443 ps=1.13 w=0.74 l=0.15
X5 VPWR A2 a_71_368# VPB sky130_fd_pr__pfet_01v8 ad=0.2184 pd=1.51 as=0.308 ps=2.79 w=1.12 l=0.15
X6 a_354_368# B1 a_71_368# VPB sky130_fd_pr__pfet_01v8 ad=0.1848 pd=1.45 as=0.168 ps=1.42 w=1.12 l=0.15
X7 Y C1 a_354_368# VPB sky130_fd_pr__pfet_01v8 ad=0.308 pd=2.79 as=0.1848 ps=1.45 w=1.12 l=0.15
.ends

.subckt sky130_fd_sc_hs__and3_1 VPWR VGND A B C X VNB VPB
X0 VPWR A a_27_398# VPB sky130_fd_pr__pfet_01v8 ad=0.168 pd=1.24 as=0.2478 ps=2.27 w=0.84 l=0.15
X1 VPWR C a_27_398# VPB sky130_fd_pr__pfet_01v8 ad=0.36323 pd=1.84 as=0.126 ps=1.14 w=0.84 l=0.15
X2 a_27_398# B VPWR VPB sky130_fd_pr__pfet_01v8 ad=0.126 pd=1.14 as=0.168 ps=1.24 w=0.84 l=0.15
X3 VGND C a_233_136# VNB sky130_fd_pr__nfet_01v8_lvt ad=0.15535 pd=1.17 as=0.111 ps=1.045 w=0.64 l=0.15
X4 a_233_136# B a_121_136# VNB sky130_fd_pr__nfet_01v8_lvt ad=0.111 pd=1.045 as=0.1312 ps=1.05 w=0.64 l=0.15
X5 X a_27_398# VGND VNB sky130_fd_pr__nfet_01v8_lvt ad=0.2109 pd=2.05 as=0.15535 ps=1.17 w=0.74 l=0.15
X6 a_121_136# A a_27_398# VNB sky130_fd_pr__nfet_01v8_lvt ad=0.1312 pd=1.05 as=0.1824 ps=1.85 w=0.64 l=0.15
X7 X a_27_398# VPWR VPB sky130_fd_pr__pfet_01v8 ad=0.3304 pd=2.83 as=0.36323 ps=1.84 w=1.12 l=0.15
.ends

.subckt sky130_fd_sc_hs__nand2b_1 VPWR VGND A_N B Y VNB VPB
X0 VPWR A_N a_27_112# VPB sky130_fd_pr__pfet_01v8 ad=0.2786 pd=1.64 as=0.2478 ps=2.27 w=0.84 l=0.15
X1 VPWR a_27_112# Y VPB sky130_fd_pr__pfet_01v8 ad=0.336 pd=2.84 as=0.196 ps=1.47 w=1.12 l=0.15
X2 a_269_74# B VGND VNB sky130_fd_pr__nfet_01v8_lvt ad=0.0888 pd=0.98 as=0.22412 ps=1.365 w=0.74 l=0.15
X3 Y B VPWR VPB sky130_fd_pr__pfet_01v8 ad=0.196 pd=1.47 as=0.2786 ps=1.64 w=1.12 l=0.15
X4 Y a_27_112# a_269_74# VNB sky130_fd_pr__nfet_01v8_lvt ad=0.3182 pd=2.34 as=0.0888 ps=0.98 w=0.74 l=0.15
X5 VGND A_N a_27_112# VNB sky130_fd_pr__nfet_01v8_lvt ad=0.22412 pd=1.365 as=0.15675 ps=1.67 w=0.55 l=0.15
.ends

.subckt sky130_fd_sc_hs__o2bb2ai_1 VPWR VGND Y B2 A1_N B1 A2_N VNB VPB
X0 a_131_383# A1_N VPWR VPB sky130_fd_pr__pfet_01v8 ad=0.126 pd=1.14 as=0.2898 ps=2.37 w=0.84 l=0.15
X1 a_397_74# B1 VGND VNB sky130_fd_pr__nfet_01v8_lvt ad=0.2109 pd=2.05 as=0.1036 ps=1.02 w=0.74 l=0.15
X2 a_114_74# A1_N VGND VNB sky130_fd_pr__nfet_01v8_lvt ad=0.0768 pd=0.88 as=0.1824 ps=1.85 w=0.64 l=0.15
X3 a_131_383# A2_N a_114_74# VNB sky130_fd_pr__nfet_01v8_lvt ad=0.1824 pd=1.85 as=0.0768 ps=0.88 w=0.64 l=0.15
X4 VGND B2 a_397_74# VNB sky130_fd_pr__nfet_01v8_lvt ad=0.1036 pd=1.02 as=0.1295 ps=1.09 w=0.74 l=0.15
X5 a_397_74# a_131_383# Y VNB sky130_fd_pr__nfet_01v8_lvt ad=0.1295 pd=1.09 as=0.2109 ps=2.05 w=0.74 l=0.15
X6 VPWR A2_N a_131_383# VPB sky130_fd_pr__pfet_01v8 ad=0.371 pd=1.865 as=0.126 ps=1.14 w=0.84 l=0.15
X7 a_490_368# B2 Y VPB sky130_fd_pr__pfet_01v8 ad=0.1848 pd=1.45 as=0.168 ps=1.42 w=1.12 l=0.15
X8 VPWR B1 a_490_368# VPB sky130_fd_pr__pfet_01v8 ad=0.3304 pd=2.83 as=0.1848 ps=1.45 w=1.12 l=0.15
X9 Y a_131_383# VPWR VPB sky130_fd_pr__pfet_01v8 ad=0.168 pd=1.42 as=0.371 ps=1.865 w=1.12 l=0.15
.ends

.subckt sky130_fd_sc_hs__or3b_1 VPWR VGND A B C_N X VNB VPB
X0 a_452_391# B a_368_391# VPB sky130_fd_pr__pfet_01v8 ad=0.135 pd=1.27 as=0.135 ps=1.27 w=1 l=0.15
X1 a_368_391# a_124_424# a_239_74# VPB sky130_fd_pr__pfet_01v8 ad=0.135 pd=1.27 as=0.295 ps=2.59 w=1 l=0.15
X2 VGND A a_239_74# VNB sky130_fd_pr__nfet_01v8_lvt ad=0.19013 pd=1.345 as=0.08663 ps=0.865 w=0.55 l=0.15
X3 a_124_424# C_N VGND VNB sky130_fd_pr__nfet_01v8_lvt ad=0.1595 pd=1.68 as=0.1925 ps=1.8 w=0.55 l=0.15
X4 VGND a_124_424# a_239_74# VNB sky130_fd_pr__nfet_01v8_lvt ad=0.1155 pd=0.97 as=0.15675 ps=1.67 w=0.55 l=0.15
X5 X a_239_74# VPWR VPB sky130_fd_pr__pfet_01v8 ad=0.3304 pd=2.83 as=0.2382 ps=1.555 w=1.12 l=0.15
X6 a_239_74# B VGND VNB sky130_fd_pr__nfet_01v8_lvt ad=0.08663 pd=0.865 as=0.1155 ps=0.97 w=0.55 l=0.15
X7 VPWR A a_452_391# VPB sky130_fd_pr__pfet_01v8 ad=0.2382 pd=1.555 as=0.135 ps=1.27 w=1 l=0.15
X8 X a_239_74# VGND VNB sky130_fd_pr__nfet_01v8_lvt ad=0.2109 pd=2.05 as=0.19013 ps=1.345 w=0.74 l=0.15
X9 a_124_424# C_N VPWR VPB sky130_fd_pr__pfet_01v8 ad=0.2562 pd=2.29 as=0.2814 ps=2.35 w=0.84 l=0.15
.ends

.subckt sky130_fd_sc_hs__a31oi_1 VPWR VGND Y A3 B1 A2 A1 VNB VPB
X0 VGND B1 Y VNB sky130_fd_pr__nfet_01v8_lvt ad=0.2109 pd=2.05 as=0.1554 ps=1.16 w=0.74 l=0.15
X1 VPWR A2 a_136_368# VPB sky130_fd_pr__pfet_01v8 ad=0.2744 pd=1.61 as=0.168 ps=1.42 w=1.12 l=0.15
X2 a_136_368# A3 VPWR VPB sky130_fd_pr__pfet_01v8 ad=0.168 pd=1.42 as=0.4312 ps=3.01 w=1.12 l=0.15
X3 a_145_74# A3 VGND VNB sky130_fd_pr__nfet_01v8_lvt ad=0.0888 pd=0.98 as=0.3182 ps=2.34 w=0.74 l=0.15
X4 Y B1 a_136_368# VPB sky130_fd_pr__pfet_01v8 ad=0.3304 pd=2.83 as=0.196 ps=1.47 w=1.12 l=0.15
X5 Y A1 a_223_74# VNB sky130_fd_pr__nfet_01v8_lvt ad=0.1554 pd=1.16 as=0.1554 ps=1.16 w=0.74 l=0.15
X6 a_136_368# A1 VPWR VPB sky130_fd_pr__pfet_01v8 ad=0.196 pd=1.47 as=0.2744 ps=1.61 w=1.12 l=0.15
X7 a_223_74# A2 a_145_74# VNB sky130_fd_pr__nfet_01v8_lvt ad=0.1554 pd=1.16 as=0.0888 ps=0.98 w=0.74 l=0.15
.ends

.subckt sky130_fd_sc_hs__o41ai_1 VPWR VGND A3 A2 B1 Y A4 A1 VNB VPB
X0 a_157_74# A1 VGND VNB sky130_fd_pr__nfet_01v8_lvt ad=0.2109 pd=2.05 as=0.1554 ps=1.16 w=0.74 l=0.15
X1 a_260_368# A4 Y VPB sky130_fd_pr__pfet_01v8 ad=0.1904 pd=1.46 as=0.196 ps=1.47 w=1.12 l=0.15
X2 VGND A4 a_157_74# VNB sky130_fd_pr__nfet_01v8_lvt ad=0.16095 pd=1.175 as=0.14615 ps=1.135 w=0.74 l=0.15
X3 a_157_74# B1 Y VNB sky130_fd_pr__nfet_01v8_lvt ad=0.14615 pd=1.135 as=0.2109 ps=2.05 w=0.74 l=0.15
X4 Y B1 VPWR VPB sky130_fd_pr__pfet_01v8 ad=0.196 pd=1.47 as=0.5768 ps=3.27 w=1.12 l=0.15
X5 a_358_368# A3 a_260_368# VPB sky130_fd_pr__pfet_01v8 ad=0.2352 pd=1.54 as=0.1904 ps=1.46 w=1.12 l=0.15
X6 a_157_74# A3 VGND VNB sky130_fd_pr__nfet_01v8_lvt ad=0.1036 pd=1.02 as=0.16095 ps=1.175 w=0.74 l=0.15
X7 a_472_368# A2 a_358_368# VPB sky130_fd_pr__pfet_01v8 ad=0.2352 pd=1.54 as=0.2352 ps=1.54 w=1.12 l=0.15
X8 VGND A2 a_157_74# VNB sky130_fd_pr__nfet_01v8_lvt ad=0.1554 pd=1.16 as=0.1036 ps=1.02 w=0.74 l=0.15
X9 VPWR A1 a_472_368# VPB sky130_fd_pr__pfet_01v8 ad=0.3304 pd=2.83 as=0.2352 ps=1.54 w=1.12 l=0.15
.ends

.subckt sky130_fd_sc_hs__o2111ai_1 VPWR VGND Y D1 C1 B1 A2 A1 VNB VPB
X0 VPWR A1 a_490_368# VPB sky130_fd_pr__pfet_01v8 ad=0.3304 pd=2.83 as=0.1708 ps=1.425 w=1.12 l=0.15
X1 a_368_74# A1 VGND VNB sky130_fd_pr__nfet_01v8_lvt ad=0.2109 pd=2.05 as=0.1628 ps=1.18 w=0.74 l=0.15
X2 Y B1 VPWR VPB sky130_fd_pr__pfet_01v8 ad=0.182 pd=1.445 as=0.2688 ps=1.6 w=1.12 l=0.15
X3 a_368_74# B1 a_260_74# VNB sky130_fd_pr__nfet_01v8_lvt ad=0.1332 pd=1.1 as=0.1443 ps=1.13 w=0.74 l=0.15
X4 a_182_74# D1 Y VNB sky130_fd_pr__nfet_01v8_lvt ad=0.0888 pd=0.98 as=0.4625 ps=2.73 w=0.74 l=0.15
X5 VGND A2 a_368_74# VNB sky130_fd_pr__nfet_01v8_lvt ad=0.1628 pd=1.18 as=0.1332 ps=1.1 w=0.74 l=0.15
X6 a_260_74# C1 a_182_74# VNB sky130_fd_pr__nfet_01v8_lvt ad=0.1443 pd=1.13 as=0.0888 ps=0.98 w=0.74 l=0.15
X7 VPWR C1 Y VPB sky130_fd_pr__pfet_01v8 ad=0.2688 pd=1.6 as=0.168 ps=1.42 w=1.12 l=0.15
X8 a_490_368# A2 Y VPB sky130_fd_pr__pfet_01v8 ad=0.1708 pd=1.425 as=0.182 ps=1.445 w=1.12 l=0.15
X9 Y D1 VPWR VPB sky130_fd_pr__pfet_01v8 ad=0.168 pd=1.42 as=0.3864 ps=2.93 w=1.12 l=0.15
.ends

.subckt sky130_fd_sc_hs__a222oi_1 VPWR VGND C2 C1 B1 A2 A1 Y B2 VNB VPB
X0 a_369_392# A2 VPWR VPB sky130_fd_pr__pfet_01v8 ad=0.295 pd=2.59 as=0.225 ps=1.45 w=1 l=0.15
X1 a_697_74# A1 Y VNB sky130_fd_pr__nfet_01v8_lvt ad=0.0768 pd=0.88 as=0.2048 ps=1.28 w=0.64 l=0.15
X2 a_116_392# C1 Y VPB sky130_fd_pr__pfet_01v8 ad=0.175 pd=1.35 as=0.295 ps=2.59 w=1 l=0.15
X3 a_369_392# B1 a_116_392# VPB sky130_fd_pr__pfet_01v8 ad=0.175 pd=1.35 as=0.175 ps=1.35 w=1 l=0.15
X4 a_119_74# C1 Y VNB sky130_fd_pr__nfet_01v8_lvt ad=0.0768 pd=0.88 as=0.1824 ps=1.85 w=0.64 l=0.15
X5 Y B1 a_461_74# VNB sky130_fd_pr__nfet_01v8_lvt ad=0.2048 pd=1.28 as=0.0768 ps=0.88 w=0.64 l=0.15
X6 a_461_74# B2 VGND VNB sky130_fd_pr__nfet_01v8_lvt ad=0.0768 pd=0.88 as=0.3744 ps=1.81 w=0.64 l=0.15
X7 VGND C2 a_119_74# VNB sky130_fd_pr__nfet_01v8_lvt ad=0.3744 pd=1.81 as=0.0768 ps=0.88 w=0.64 l=0.15
X8 Y C2 a_116_392# VPB sky130_fd_pr__pfet_01v8 ad=0.345 pd=2.69 as=0.175 ps=1.35 w=1 l=0.15
X9 a_116_392# B2 a_369_392# VPB sky130_fd_pr__pfet_01v8 ad=0.175 pd=1.35 as=0.295 ps=2.59 w=1 l=0.15
X10 VGND A2 a_697_74# VNB sky130_fd_pr__nfet_01v8_lvt ad=0.1824 pd=1.85 as=0.0768 ps=0.88 w=0.64 l=0.15
X11 VPWR A1 a_369_392# VPB sky130_fd_pr__pfet_01v8 ad=0.225 pd=1.45 as=0.175 ps=1.35 w=1 l=0.15
.ends

.subckt sky130_fd_sc_hs__a32oi_1 VPWR VGND A3 B2 B1 A2 Y A1 VNB VPB
X0 a_27_368# A2 VPWR VPB sky130_fd_pr__pfet_01v8 ad=0.168 pd=1.42 as=0.3584 ps=1.76 w=1.12 l=0.15
X1 a_391_74# A1 Y VNB sky130_fd_pr__nfet_01v8_lvt ad=0.0888 pd=0.98 as=0.3034 ps=1.56 w=0.74 l=0.15
X2 Y B2 a_27_368# VPB sky130_fd_pr__pfet_01v8 ad=0.196 pd=1.47 as=0.3304 ps=2.83 w=1.12 l=0.15
X3 a_119_74# B2 VGND VNB sky130_fd_pr__nfet_01v8_lvt ad=0.0888 pd=0.98 as=0.2294 ps=2.1 w=0.74 l=0.15
X4 VPWR A1 a_27_368# VPB sky130_fd_pr__pfet_01v8 ad=0.3584 pd=1.76 as=0.2576 ps=1.58 w=1.12 l=0.15
X5 VGND A3 a_469_74# VNB sky130_fd_pr__nfet_01v8_lvt ad=0.2109 pd=2.05 as=0.1554 ps=1.16 w=0.74 l=0.15
X6 Y B1 a_119_74# VNB sky130_fd_pr__nfet_01v8_lvt ad=0.3034 pd=1.56 as=0.0888 ps=0.98 w=0.74 l=0.15
X7 a_27_368# B1 Y VPB sky130_fd_pr__pfet_01v8 ad=0.2576 pd=1.58 as=0.196 ps=1.47 w=1.12 l=0.15
X8 a_469_74# A2 a_391_74# VNB sky130_fd_pr__nfet_01v8_lvt ad=0.1554 pd=1.16 as=0.0888 ps=0.98 w=0.74 l=0.15
X9 VPWR A3 a_27_368# VPB sky130_fd_pr__pfet_01v8 ad=0.3304 pd=2.83 as=0.168 ps=1.42 w=1.12 l=0.15
.ends

.subckt sky130_fd_sc_hs__clkbuf_16 VPWR VGND X A VNB VPB
X0 VPWR a_114_74# X VPB sky130_fd_pr__pfet_01v8 ad=0.168 pd=1.42 as=0.168 ps=1.42 w=1.12 l=0.15
X1 X a_114_74# VPWR VPB sky130_fd_pr__pfet_01v8 ad=0.168 pd=1.42 as=0.1736 ps=1.43 w=1.12 l=0.15
X2 VGND a_114_74# X VNB sky130_fd_pr__nfet_01v8_lvt ad=0.0735 pd=0.77 as=0.0588 ps=0.7 w=0.42 l=0.15
X3 X a_114_74# VGND VNB sky130_fd_pr__nfet_01v8_lvt ad=0.0588 pd=0.7 as=0.0588 ps=0.7 w=0.42 l=0.15
X4 X a_114_74# VGND VNB sky130_fd_pr__nfet_01v8_lvt ad=0.0588 pd=0.7 as=0.0735 ps=0.77 w=0.42 l=0.15
X5 X a_114_74# VGND VNB sky130_fd_pr__nfet_01v8_lvt ad=0.0588 pd=0.7 as=0.0735 ps=0.77 w=0.42 l=0.15
X6 a_114_74# A VPWR VPB sky130_fd_pr__pfet_01v8 ad=0.168 pd=1.42 as=0.3304 ps=2.83 w=1.12 l=0.15
X7 VPWR a_114_74# X VPB sky130_fd_pr__pfet_01v8 ad=0.1792 pd=1.44 as=0.168 ps=1.42 w=1.12 l=0.15
X8 a_114_74# A VGND VNB sky130_fd_pr__nfet_01v8_lvt ad=0.0588 pd=0.7 as=0.1197 ps=1.41 w=0.42 l=0.15
X9 a_114_74# A VGND VNB sky130_fd_pr__nfet_01v8_lvt ad=0.0588 pd=0.7 as=0.063 ps=0.72 w=0.42 l=0.15
X10 X a_114_74# VPWR VPB sky130_fd_pr__pfet_01v8 ad=0.168 pd=1.42 as=0.168 ps=1.42 w=1.12 l=0.15
X11 VPWR a_114_74# X VPB sky130_fd_pr__pfet_01v8 ad=0.168 pd=1.42 as=0.168 ps=1.42 w=1.12 l=0.15
X12 X a_114_74# VPWR VPB sky130_fd_pr__pfet_01v8 ad=0.168 pd=1.42 as=0.168 ps=1.42 w=1.12 l=0.15
X13 VGND a_114_74# X VNB sky130_fd_pr__nfet_01v8_lvt ad=0.0735 pd=0.77 as=0.0588 ps=0.7 w=0.42 l=0.15
X14 VPWR a_114_74# X VPB sky130_fd_pr__pfet_01v8 ad=0.168 pd=1.42 as=0.168 ps=1.42 w=1.12 l=0.15
X15 VGND A a_114_74# VNB sky130_fd_pr__nfet_01v8_lvt ad=0.0735 pd=0.77 as=0.0588 ps=0.7 w=0.42 l=0.15
X16 X a_114_74# VGND VNB sky130_fd_pr__nfet_01v8_lvt ad=0.0588 pd=0.7 as=0.0735 ps=0.77 w=0.42 l=0.15
X17 X a_114_74# VPWR VPB sky130_fd_pr__pfet_01v8 ad=0.168 pd=1.42 as=0.168 ps=1.42 w=1.12 l=0.15
X18 X a_114_74# VPWR VPB sky130_fd_pr__pfet_01v8 ad=0.168 pd=1.42 as=0.168 ps=1.42 w=1.12 l=0.15
X19 X a_114_74# VGND VNB sky130_fd_pr__nfet_01v8_lvt ad=0.0588 pd=0.7 as=0.0588 ps=0.7 w=0.42 l=0.15
X20 VPWR a_114_74# X VPB sky130_fd_pr__pfet_01v8 ad=0.168 pd=1.42 as=0.168 ps=1.42 w=1.12 l=0.15
X21 VPWR a_114_74# X VPB sky130_fd_pr__pfet_01v8 ad=0.168 pd=1.42 as=0.168 ps=1.42 w=1.12 l=0.15
X22 X a_114_74# VGND VNB sky130_fd_pr__nfet_01v8_lvt ad=0.0588 pd=0.7 as=0.0735 ps=0.77 w=0.42 l=0.15
X23 VPWR A a_114_74# VPB sky130_fd_pr__pfet_01v8 ad=0.1736 pd=1.43 as=0.168 ps=1.42 w=1.12 l=0.15
X24 VGND A a_114_74# VNB sky130_fd_pr__nfet_01v8_lvt ad=0.063 pd=0.72 as=0.0588 ps=0.7 w=0.42 l=0.15
X25 VGND a_114_74# X VNB sky130_fd_pr__nfet_01v8_lvt ad=0.0735 pd=0.77 as=0.0588 ps=0.7 w=0.42 l=0.15
X26 X a_114_74# VGND VNB sky130_fd_pr__nfet_01v8_lvt ad=0.0588 pd=0.7 as=0.0735 ps=0.77 w=0.42 l=0.15
X27 a_114_74# A VPWR VPB sky130_fd_pr__pfet_01v8 ad=0.168 pd=1.42 as=0.168 ps=1.42 w=1.12 l=0.15
X28 VGND a_114_74# X VNB sky130_fd_pr__nfet_01v8_lvt ad=0.0588 pd=0.7 as=0.0588 ps=0.7 w=0.42 l=0.15
X29 VPWR A a_114_74# VPB sky130_fd_pr__pfet_01v8 ad=0.168 pd=1.42 as=0.168 ps=1.42 w=1.12 l=0.15
X30 X a_114_74# VGND VNB sky130_fd_pr__nfet_01v8_lvt ad=0.0588 pd=0.7 as=0.0735 ps=0.77 w=0.42 l=0.15
X31 VGND a_114_74# X VNB sky130_fd_pr__nfet_01v8_lvt ad=0.1197 pd=1.41 as=0.0588 ps=0.7 w=0.42 l=0.15
X32 X a_114_74# VPWR VPB sky130_fd_pr__pfet_01v8 ad=0.168 pd=1.42 as=0.168 ps=1.42 w=1.12 l=0.15
X33 VPWR a_114_74# X VPB sky130_fd_pr__pfet_01v8 ad=0.3304 pd=2.83 as=0.168 ps=1.42 w=1.12 l=0.15
X34 VGND a_114_74# X VNB sky130_fd_pr__nfet_01v8_lvt ad=0.0735 pd=0.77 as=0.0588 ps=0.7 w=0.42 l=0.15
X35 VPWR a_114_74# X VPB sky130_fd_pr__pfet_01v8 ad=0.168 pd=1.42 as=0.168 ps=1.42 w=1.12 l=0.15
X36 VGND a_114_74# X VNB sky130_fd_pr__nfet_01v8_lvt ad=0.0588 pd=0.7 as=0.0588 ps=0.7 w=0.42 l=0.15
X37 X a_114_74# VPWR VPB sky130_fd_pr__pfet_01v8 ad=0.168 pd=1.42 as=0.168 ps=1.42 w=1.12 l=0.15
X38 X a_114_74# VPWR VPB sky130_fd_pr__pfet_01v8 ad=0.168 pd=1.42 as=0.1792 ps=1.44 w=1.12 l=0.15
X39 VGND a_114_74# X VNB sky130_fd_pr__nfet_01v8_lvt ad=0.0735 pd=0.77 as=0.0588 ps=0.7 w=0.42 l=0.15
.ends

.subckt sky130_fd_sc_hs__a221oi_1 VPWR VGND C1 Y B2 B1 A1 A2 VNB VPB
X0 VGND C1 Y VNB sky130_fd_pr__nfet_01v8_lvt ad=0.1443 pd=1.13 as=0.4477 ps=2.69 w=0.74 l=0.15
X1 a_351_74# B2 VGND VNB sky130_fd_pr__nfet_01v8_lvt ad=0.0777 pd=0.95 as=0.1443 ps=1.13 w=0.74 l=0.15
X2 a_118_368# C1 Y VPB sky130_fd_pr__pfet_01v8 ad=0.308 pd=2.79 as=0.308 ps=2.79 w=1.12 l=0.15
X3 Y B1 a_351_74# VNB sky130_fd_pr__nfet_01v8_lvt ad=0.2109 pd=1.31 as=0.0777 ps=0.95 w=0.74 l=0.15
X4 a_567_74# A1 Y VNB sky130_fd_pr__nfet_01v8_lvt ad=0.0777 pd=0.95 as=0.2109 ps=1.31 w=0.74 l=0.15
X5 a_263_368# B1 a_118_368# VPB sky130_fd_pr__pfet_01v8 ad=0.1848 pd=1.45 as=0.168 ps=1.42 w=1.12 l=0.15
X6 VPWR A1 a_263_368# VPB sky130_fd_pr__pfet_01v8 ad=0.2184 pd=1.51 as=0.1848 ps=1.45 w=1.12 l=0.15
X7 VGND A2 a_567_74# VNB sky130_fd_pr__nfet_01v8_lvt ad=0.1961 pd=2.01 as=0.0777 ps=0.95 w=0.74 l=0.15
X8 a_118_368# B2 a_263_368# VPB sky130_fd_pr__pfet_01v8 ad=0.168 pd=1.42 as=0.308 ps=2.79 w=1.12 l=0.15
X9 a_263_368# A2 VPWR VPB sky130_fd_pr__pfet_01v8 ad=0.308 pd=2.79 as=0.2184 ps=1.51 w=1.12 l=0.15
.ends

.subckt sky130_fd_sc_hs__a21bo_1 VPWR VGND X B1_N A1 A2 VNB VPB
X0 a_122_136# A2 VGND VNB sky130_fd_pr__nfet_01v8_lvt ad=0.0672 pd=0.85 as=0.1696 ps=1.81 w=0.64 l=0.15
X1 a_194_136# a_272_110# a_34_392# VPB sky130_fd_pr__pfet_01v8 ad=0.275 pd=2.55 as=0.15 ps=1.3 w=1 l=0.15
X2 a_34_392# A1 VPWR VPB sky130_fd_pr__pfet_01v8 ad=0.15 pd=1.3 as=0.165 ps=1.33 w=1 l=0.15
X3 X a_194_136# VPWR VPB sky130_fd_pr__pfet_01v8 ad=0.308 pd=2.79 as=0.203 ps=1.505 w=1.12 l=0.15
X4 VPWR B1_N a_272_110# VPB sky130_fd_pr__pfet_01v8 ad=0.203 pd=1.505 as=0.231 ps=2.23 w=0.84 l=0.15
X5 a_194_136# A1 a_122_136# VNB sky130_fd_pr__nfet_01v8_lvt ad=0.1248 pd=1.03 as=0.0672 ps=0.85 w=0.64 l=0.15
X6 VPWR A2 a_34_392# VPB sky130_fd_pr__pfet_01v8 ad=0.165 pd=1.33 as=0.275 ps=2.55 w=1 l=0.15
X7 VGND a_272_110# a_194_136# VNB sky130_fd_pr__nfet_01v8_lvt ad=0.1696 pd=1.81 as=0.1248 ps=1.03 w=0.64 l=0.15
X8 X a_194_136# VGND VNB sky130_fd_pr__nfet_01v8_lvt ad=0.1961 pd=2.01 as=0.11312 ps=1.065 w=0.74 l=0.15
X9 VGND B1_N a_272_110# VNB sky130_fd_pr__nfet_01v8_lvt ad=0.11312 pd=1.065 as=0.15675 ps=1.67 w=0.55 l=0.15
.ends

.subckt sky130_fd_sc_hs__mux2i_1 VPWR VGND S A1 A0 Y VNB VPB
X0 a_114_74# S VPWR VPB sky130_fd_pr__pfet_01v8 ad=0.231 pd=2.23 as=0.2394 ps=2.25 w=0.84 l=0.15
X1 a_399_368# A1 Y VPB sky130_fd_pr__pfet_01v8 ad=0.3192 pd=2.81 as=0.168 ps=1.42 w=1.12 l=0.15
X2 a_114_74# S VGND VNB sky130_fd_pr__nfet_01v8_lvt ad=0.15675 pd=1.67 as=0.15675 ps=1.67 w=0.55 l=0.15
X3 Y A0 a_223_368# VPB sky130_fd_pr__pfet_01v8 ad=0.168 pd=1.42 as=0.3136 ps=2.8 w=1.12 l=0.15
X4 a_426_74# a_114_74# VGND VNB sky130_fd_pr__nfet_01v8_lvt ad=0.0888 pd=0.98 as=0.1554 ps=1.16 w=0.74 l=0.15
X5 VGND S a_225_74# VNB sky130_fd_pr__nfet_01v8_lvt ad=0.1554 pd=1.16 as=0.2109 ps=2.05 w=0.74 l=0.15
X6 a_225_74# A1 Y VNB sky130_fd_pr__nfet_01v8_lvt ad=0.2109 pd=2.05 as=0.26085 ps=1.445 w=0.74 l=0.15
X7 a_399_368# a_114_74# VPWR VPB sky130_fd_pr__pfet_01v8 ad=0.308 pd=2.79 as=0.168 ps=1.42 w=1.12 l=0.15
X8 Y A0 a_426_74# VNB sky130_fd_pr__nfet_01v8_lvt ad=0.26085 pd=1.445 as=0.0888 ps=0.98 w=0.74 l=0.15
X9 VPWR S a_223_368# VPB sky130_fd_pr__pfet_01v8 ad=0.168 pd=1.42 as=0.3136 ps=2.8 w=1.12 l=0.15
.ends

.subckt sky130_fd_sc_hs__o311a_1 VPWR VGND C1 B1 A3 A2 A1 X VNB VPB
X0 a_31_387# B1 VPWR VPB sky130_fd_pr__pfet_01v8 ad=0.15 pd=1.3 as=0.2 ps=1.4 w=1 l=0.15
X1 a_209_74# A3 VGND VNB sky130_fd_pr__nfet_01v8_lvt ad=0.2976 pd=1.57 as=0.1824 ps=1.21 w=0.64 l=0.15
X2 X a_31_387# VPWR VPB sky130_fd_pr__pfet_01v8 ad=0.3304 pd=2.83 as=0.2519 ps=1.59 w=1.12 l=0.15
X3 a_536_387# A2 a_320_387# VPB sky130_fd_pr__pfet_01v8 ad=0.21 pd=1.42 as=0.465 ps=1.93 w=1 l=0.15
X4 X a_31_387# VGND VNB sky130_fd_pr__nfet_01v8_lvt ad=0.2109 pd=2.05 as=0.1277 ps=1.1 w=0.74 l=0.15
X5 VPWR A1 a_536_387# VPB sky130_fd_pr__pfet_01v8 ad=0.2519 pd=1.59 as=0.21 ps=1.42 w=1 l=0.15
X6 a_209_74# B1 a_131_74# VNB sky130_fd_pr__nfet_01v8_lvt ad=0.1248 pd=1.03 as=0.0768 ps=0.88 w=0.64 l=0.15
X7 VGND A2 a_209_74# VNB sky130_fd_pr__nfet_01v8_lvt ad=0.1824 pd=1.21 as=0.1248 ps=1.03 w=0.64 l=0.15
X8 a_131_74# C1 a_31_387# VNB sky130_fd_pr__nfet_01v8_lvt ad=0.0768 pd=0.88 as=0.1824 ps=1.85 w=0.64 l=0.15
X9 VGND A1 a_209_74# VNB sky130_fd_pr__nfet_01v8_lvt ad=0.1277 pd=1.1 as=0.2976 ps=1.57 w=0.64 l=0.15
X10 VPWR C1 a_31_387# VPB sky130_fd_pr__pfet_01v8 ad=0.2 pd=1.4 as=0.295 ps=2.59 w=1 l=0.15
X11 a_320_387# A3 a_31_387# VPB sky130_fd_pr__pfet_01v8 ad=0.465 pd=1.93 as=0.15 ps=1.3 w=1 l=0.15
.ends

.subckt sky130_fd_sc_hs__a2111oi_1 VPWR VGND D1 C1 B1 A2 A1 Y VNB VPB
X0 a_342_368# A2 VPWR VPB sky130_fd_pr__pfet_01v8 ad=0.308 pd=2.79 as=0.2184 ps=1.51 w=1.12 l=0.15
X1 a_461_74# A1 Y VNB sky130_fd_pr__nfet_01v8_lvt ad=0.1184 pd=1.06 as=0.1036 ps=1.02 w=0.74 l=0.15
X2 VGND C1 Y VNB sky130_fd_pr__nfet_01v8_lvt ad=0.185 pd=1.24 as=0.1036 ps=1.02 w=0.74 l=0.15
X3 Y D1 VGND VNB sky130_fd_pr__nfet_01v8_lvt ad=0.1036 pd=1.02 as=0.1961 ps=2.01 w=0.74 l=0.15
X4 Y B1 VGND VNB sky130_fd_pr__nfet_01v8_lvt ad=0.1036 pd=1.02 as=0.185 ps=1.24 w=0.74 l=0.15
X5 VGND A2 a_461_74# VNB sky130_fd_pr__nfet_01v8_lvt ad=0.2109 pd=2.05 as=0.1184 ps=1.06 w=0.74 l=0.15
X6 a_234_368# C1 a_156_368# VPB sky130_fd_pr__pfet_01v8 ad=0.2184 pd=1.51 as=0.1344 ps=1.36 w=1.12 l=0.15
X7 a_342_368# B1 a_234_368# VPB sky130_fd_pr__pfet_01v8 ad=0.2184 pd=1.51 as=0.2184 ps=1.51 w=1.12 l=0.15
X8 a_156_368# D1 Y VPB sky130_fd_pr__pfet_01v8 ad=0.1344 pd=1.36 as=0.308 ps=2.79 w=1.12 l=0.15
X9 VPWR A1 a_342_368# VPB sky130_fd_pr__pfet_01v8 ad=0.2184 pd=1.51 as=0.2184 ps=1.51 w=1.12 l=0.15
.ends

.subckt sky130_fd_sc_hs__o31a_1 VPWR VGND B1 A2 A1 A3 X VNB VPB
X0 VGND a_84_48# X VNB sky130_fd_pr__nfet_01v8_lvt ad=0.15535 pd=1.17 as=0.2109 ps=2.05 w=0.74 l=0.15
X1 VGND A2 a_230_94# VNB sky130_fd_pr__nfet_01v8_lvt ad=0.1824 pd=1.21 as=0.1136 ps=0.995 w=0.64 l=0.15
X2 VPWR a_84_48# X VPB sky130_fd_pr__pfet_01v8 ad=0.2907 pd=1.66 as=0.3304 ps=2.83 w=1.12 l=0.15
X3 a_84_48# B1 a_230_94# VNB sky130_fd_pr__nfet_01v8_lvt ad=0.2272 pd=1.99 as=0.1104 ps=0.985 w=0.64 l=0.15
X4 a_340_368# A2 a_256_368# VPB sky130_fd_pr__pfet_01v8 ad=0.18 pd=1.36 as=0.135 ps=1.27 w=1 l=0.15
X5 a_84_48# A3 a_340_368# VPB sky130_fd_pr__pfet_01v8 ad=0.1874 pd=1.39 as=0.18 ps=1.36 w=1 l=0.15
X6 a_256_368# A1 VPWR VPB sky130_fd_pr__pfet_01v8 ad=0.135 pd=1.27 as=0.2907 ps=1.66 w=1 l=0.15
X7 a_230_94# A1 VGND VNB sky130_fd_pr__nfet_01v8_lvt ad=0.1136 pd=0.995 as=0.15535 ps=1.17 w=0.64 l=0.15
X8 VPWR B1 a_84_48# VPB sky130_fd_pr__pfet_01v8 ad=0.399 pd=2.63 as=0.1874 ps=1.39 w=0.84 l=0.15
X9 a_230_94# A3 VGND VNB sky130_fd_pr__nfet_01v8_lvt ad=0.1104 pd=0.985 as=0.1824 ps=1.21 w=0.64 l=0.15
.ends

.subckt sky130_fd_sc_hs__buf_16 X VPWR VGND A VNB VPB
X0 X a_83_260# VGND VNB sky130_fd_pr__nfet_01v8_lvt ad=0.1036 pd=1.02 as=0.1036 ps=1.02 w=0.74 l=0.15
X1 X a_83_260# VPWR VPB sky130_fd_pr__pfet_01v8 ad=0.168 pd=1.42 as=0.3304 ps=2.83 w=1.12 l=0.15
X2 VPWR a_83_260# X VPB sky130_fd_pr__pfet_01v8 ad=0.168 pd=1.42 as=0.168 ps=1.42 w=1.12 l=0.15
X3 X a_83_260# VPWR VPB sky130_fd_pr__pfet_01v8 ad=0.168 pd=1.42 as=0.168 ps=1.42 w=1.12 l=0.15
X4 VGND a_83_260# X VNB sky130_fd_pr__nfet_01v8_lvt ad=0.1036 pd=1.02 as=0.1036 ps=1.02 w=0.74 l=0.15
X5 X a_83_260# VGND VNB sky130_fd_pr__nfet_01v8_lvt ad=0.1036 pd=1.02 as=0.1036 ps=1.02 w=0.74 l=0.15
X6 VGND a_83_260# X VNB sky130_fd_pr__nfet_01v8_lvt ad=0.1554 pd=1.16 as=0.1036 ps=1.02 w=0.74 l=0.15
X7 VGND A a_83_260# VNB sky130_fd_pr__nfet_01v8_lvt ad=0.2109 pd=2.05 as=0.1295 ps=1.09 w=0.74 l=0.15
X8 VPWR a_83_260# X VPB sky130_fd_pr__pfet_01v8 ad=0.168 pd=1.42 as=0.168 ps=1.42 w=1.12 l=0.15
X9 a_83_260# A VPWR VPB sky130_fd_pr__pfet_01v8 ad=0.168 pd=1.42 as=0.168 ps=1.42 w=1.12 l=0.15
X10 a_83_260# A VGND VNB sky130_fd_pr__nfet_01v8_lvt ad=0.1036 pd=1.02 as=0.1036 ps=1.02 w=0.74 l=0.15
X11 X a_83_260# VPWR VPB sky130_fd_pr__pfet_01v8 ad=0.168 pd=1.42 as=0.168 ps=1.42 w=1.12 l=0.15
X12 VPWR A a_83_260# VPB sky130_fd_pr__pfet_01v8 ad=0.168 pd=1.42 as=0.168 ps=1.42 w=1.12 l=0.15
X13 VPWR a_83_260# X VPB sky130_fd_pr__pfet_01v8 ad=0.168 pd=1.42 as=0.168 ps=1.42 w=1.12 l=0.15
X14 X a_83_260# VGND VNB sky130_fd_pr__nfet_01v8_lvt ad=0.1036 pd=1.02 as=0.2109 ps=2.05 w=0.74 l=0.15
X15 X a_83_260# VGND VNB sky130_fd_pr__nfet_01v8_lvt ad=0.1036 pd=1.02 as=0.1036 ps=1.02 w=0.74 l=0.15
X16 a_83_260# A VPWR VPB sky130_fd_pr__pfet_01v8 ad=0.168 pd=1.42 as=0.168 ps=1.42 w=1.12 l=0.15
X17 X a_83_260# VPWR VPB sky130_fd_pr__pfet_01v8 ad=0.168 pd=1.42 as=0.196 ps=1.47 w=1.12 l=0.15
X18 VPWR A a_83_260# VPB sky130_fd_pr__pfet_01v8 ad=0.168 pd=1.42 as=0.168 ps=1.42 w=1.12 l=0.15
X19 a_83_260# A VGND VNB sky130_fd_pr__nfet_01v8_lvt ad=0.1036 pd=1.02 as=0.1036 ps=1.02 w=0.74 l=0.15
X20 a_83_260# A VPWR VPB sky130_fd_pr__pfet_01v8 ad=0.168 pd=1.42 as=0.196 ps=1.47 w=1.12 l=0.15
X21 VGND a_83_260# X VNB sky130_fd_pr__nfet_01v8_lvt ad=0.1036 pd=1.02 as=0.1036 ps=1.02 w=0.74 l=0.15
X22 a_83_260# A VGND VNB sky130_fd_pr__nfet_01v8_lvt ad=0.1295 pd=1.09 as=0.11655 ps=1.055 w=0.74 l=0.15
X23 VGND a_83_260# X VNB sky130_fd_pr__nfet_01v8_lvt ad=0.1036 pd=1.02 as=0.1036 ps=1.02 w=0.74 l=0.15
X24 X a_83_260# VGND VNB sky130_fd_pr__nfet_01v8_lvt ad=0.1036 pd=1.02 as=0.1554 ps=1.16 w=0.74 l=0.15
X25 VGND a_83_260# X VNB sky130_fd_pr__nfet_01v8_lvt ad=0.1036 pd=1.02 as=0.1036 ps=1.02 w=0.74 l=0.15
X26 X a_83_260# VGND VNB sky130_fd_pr__nfet_01v8_lvt ad=0.1036 pd=1.02 as=0.1554 ps=1.16 w=0.74 l=0.15
X27 VPWR a_83_260# X VPB sky130_fd_pr__pfet_01v8 ad=0.196 pd=1.47 as=0.168 ps=1.42 w=1.12 l=0.15
X28 X a_83_260# VPWR VPB sky130_fd_pr__pfet_01v8 ad=0.168 pd=1.42 as=0.168 ps=1.42 w=1.12 l=0.15
X29 VPWR a_83_260# X VPB sky130_fd_pr__pfet_01v8 ad=0.196 pd=1.47 as=0.168 ps=1.42 w=1.12 l=0.15
X30 VGND a_83_260# X VNB sky130_fd_pr__nfet_01v8_lvt ad=0.1554 pd=1.16 as=0.1036 ps=1.02 w=0.74 l=0.15
X31 VPWR a_83_260# X VPB sky130_fd_pr__pfet_01v8 ad=0.168 pd=1.42 as=0.168 ps=1.42 w=1.12 l=0.15
X32 X a_83_260# VPWR VPB sky130_fd_pr__pfet_01v8 ad=0.168 pd=1.42 as=0.168 ps=1.42 w=1.12 l=0.15
X33 VGND a_83_260# X VNB sky130_fd_pr__nfet_01v8_lvt ad=0.1036 pd=1.02 as=0.1036 ps=1.02 w=0.74 l=0.15
X34 VPWR a_83_260# X VPB sky130_fd_pr__pfet_01v8 ad=0.168 pd=1.42 as=0.168 ps=1.42 w=1.12 l=0.15
X35 X a_83_260# VPWR VPB sky130_fd_pr__pfet_01v8 ad=0.168 pd=1.42 as=0.168 ps=1.42 w=1.12 l=0.15
X36 X a_83_260# VPWR VPB sky130_fd_pr__pfet_01v8 ad=0.168 pd=1.42 as=0.168 ps=1.42 w=1.12 l=0.15
X37 VGND a_83_260# X VNB sky130_fd_pr__nfet_01v8_lvt ad=0.1554 pd=1.16 as=0.1036 ps=1.02 w=0.74 l=0.15
X38 VPWR a_83_260# X VPB sky130_fd_pr__pfet_01v8 ad=0.168 pd=1.42 as=0.168 ps=1.42 w=1.12 l=0.15
X39 X a_83_260# VGND VNB sky130_fd_pr__nfet_01v8_lvt ad=0.1036 pd=1.02 as=0.1036 ps=1.02 w=0.74 l=0.15
X40 VPWR A a_83_260# VPB sky130_fd_pr__pfet_01v8 ad=0.3304 pd=2.83 as=0.168 ps=1.42 w=1.12 l=0.15
X41 VGND A a_83_260# VNB sky130_fd_pr__nfet_01v8_lvt ad=0.11655 pd=1.055 as=0.1036 ps=1.02 w=0.74 l=0.15
X42 X a_83_260# VGND VNB sky130_fd_pr__nfet_01v8_lvt ad=0.1036 pd=1.02 as=0.1554 ps=1.16 w=0.74 l=0.15
X43 VGND A a_83_260# VNB sky130_fd_pr__nfet_01v8_lvt ad=0.1036 pd=1.02 as=0.1036 ps=1.02 w=0.74 l=0.15
.ends

.subckt sky130_fd_sc_hs__a221o_1 VPWR VGND X C1 B2 A2 A1 B1 VNB VPB
X0 VPWR A1 a_310_392# VPB sky130_fd_pr__pfet_01v8 ad=0.275 pd=2.55 as=0.15 ps=1.3 w=1 l=0.15
X1 a_310_392# A2 VPWR VPB sky130_fd_pr__pfet_01v8 ad=0.15 pd=1.3 as=0.199 ps=1.485 w=1 l=0.15
X2 a_148_260# C1 VGND VNB sky130_fd_pr__nfet_01v8_lvt ad=0.1696 pd=1.81 as=0.14295 ps=1.25 w=0.64 l=0.15
X3 VGND B2 a_597_79# VNB sky130_fd_pr__nfet_01v8_lvt ad=0.14295 pd=1.25 as=0.0672 ps=0.85 w=0.64 l=0.15
X4 a_509_392# B2 a_310_392# VPB sky130_fd_pr__pfet_01v8 ad=0.165 pd=1.33 as=0.15 ps=1.3 w=1 l=0.15
X5 a_148_260# C1 a_509_392# VPB sky130_fd_pr__pfet_01v8 ad=0.275 pd=2.55 as=0.165 ps=1.33 w=1 l=0.15
X6 a_310_392# B1 a_509_392# VPB sky130_fd_pr__pfet_01v8 ad=0.15 pd=1.3 as=0.275 ps=2.55 w=1 l=0.15
X7 VGND a_148_260# X VNB sky130_fd_pr__nfet_01v8_lvt ad=0.28947 pd=1.605 as=0.1961 ps=2.01 w=0.74 l=0.15
X8 VPWR a_148_260# X VPB sky130_fd_pr__pfet_01v8 ad=0.199 pd=1.485 as=0.308 ps=2.79 w=1.12 l=0.15
X9 a_417_79# A2 VGND VNB sky130_fd_pr__nfet_01v8_lvt ad=0.0672 pd=0.85 as=0.28947 ps=1.605 w=0.64 l=0.15
X10 a_148_260# A1 a_417_79# VNB sky130_fd_pr__nfet_01v8_lvt ad=0.1248 pd=1.03 as=0.0672 ps=0.85 w=0.64 l=0.15
X11 a_597_79# B1 a_148_260# VNB sky130_fd_pr__nfet_01v8_lvt ad=0.0672 pd=0.85 as=0.1248 ps=1.03 w=0.64 l=0.15
.ends

.subckt sky130_fd_sc_hs__o21a_1 VPWR VGND X A2 B1 A1 VNB VPB
X0 VGND A2 a_320_74# VNB sky130_fd_pr__nfet_01v8_lvt ad=0.0896 pd=0.92 as=0.0896 ps=0.92 w=0.64 l=0.15
X1 VPWR a_83_244# X VPB sky130_fd_pr__pfet_01v8 ad=0.33483 pd=1.765 as=0.3304 ps=2.83 w=1.12 l=0.15
X2 VGND a_83_244# X VNB sky130_fd_pr__nfet_01v8_lvt ad=0.2109 pd=2.05 as=0.2109 ps=2.05 w=0.74 l=0.15
X3 a_320_74# A1 VGND VNB sky130_fd_pr__nfet_01v8_lvt ad=0.1824 pd=1.85 as=0.0896 ps=0.92 w=0.64 l=0.15
X4 a_320_74# B1 a_83_244# VNB sky130_fd_pr__nfet_01v8_lvt ad=0.0896 pd=0.92 as=0.1824 ps=1.85 w=0.64 l=0.15
X5 a_376_387# A2 a_83_244# VPB sky130_fd_pr__pfet_01v8 ad=0.21 pd=1.42 as=0.1703 ps=1.355 w=1 l=0.15
X6 a_83_244# B1 VPWR VPB sky130_fd_pr__pfet_01v8 ad=0.1703 pd=1.355 as=0.33483 ps=1.765 w=0.84 l=0.15
X7 VPWR A1 a_376_387# VPB sky130_fd_pr__pfet_01v8 ad=0.295 pd=2.59 as=0.21 ps=1.42 w=1 l=0.15
.ends

.subckt sky130_fd_sc_hs__xnor3_1 VPWR VGND X B C A VNB VPB
X0 a_1113_383# a_897_54# VGND VNB sky130_fd_pr__nfet_01v8_lvt ad=0.1824 pd=1.85 as=0.1376 ps=1.07 w=0.64 l=0.15
X1 a_81_268# C a_363_394# VPB sky130_fd_pr__pfet_01v8 ad=0.20898 pd=1.425 as=0.2478 ps=2.27 w=0.84 l=0.15
X2 VGND a_81_268# X VNB sky130_fd_pr__nfet_01v8_lvt ad=0.19575 pd=1.49 as=0.2109 ps=2.05 w=0.74 l=0.15
X3 a_232_162# C VGND VNB sky130_fd_pr__nfet_01v8_lvt ad=0.1575 pd=1.59 as=0.19575 ps=1.49 w=0.42 l=0.15
X4 a_786_100# B VGND VNB sky130_fd_pr__nfet_01v8_lvt ad=0.2109 pd=2.05 as=0.36 ps=2.83 w=0.74 l=0.15
X5 a_363_394# a_786_100# a_897_54# VPB sky130_fd_pr__pfet_01v8 ad=0.1527 pd=1.225 as=0.36585 ps=2.87 w=0.84 l=0.15
X6 a_371_74# a_786_100# a_897_54# VNB sky130_fd_pr__nfet_01v8_lvt ad=0.1328 pd=1.055 as=0.37462 ps=2.77 w=0.64 l=0.15
X7 a_371_74# a_232_162# a_81_268# VPB sky130_fd_pr__pfet_01v8 ad=0.2436 pd=2.26 as=0.20898 ps=1.425 w=0.84 l=0.15
X8 a_1113_383# B a_371_74# VNB sky130_fd_pr__nfet_01v8_lvt ad=0.1136 pd=1.05 as=0.1328 ps=1.055 w=0.64 l=0.15
X9 VGND A a_897_54# VNB sky130_fd_pr__nfet_01v8_lvt ad=0.1376 pd=1.07 as=0.1104 ps=0.985 w=0.64 l=0.15
X10 a_232_162# C VPWR VPB sky130_fd_pr__pfet_01v8 ad=0.1888 pd=1.87 as=0.2404 ps=1.65 w=0.64 l=0.15
X11 a_786_100# B VPWR VPB sky130_fd_pr__pfet_01v8 ad=0.3192 pd=2.81 as=0.4194 ps=3.08 w=1.12 l=0.15
X12 a_897_54# B a_371_74# VPB sky130_fd_pr__pfet_01v8 ad=0.1858 pd=1.39 as=0.1852 ps=1.325 w=0.84 l=0.15
X13 a_363_394# a_232_162# a_81_268# VNB sky130_fd_pr__nfet_01v8_lvt ad=0.2272 pd=1.99 as=0.112 ps=0.99 w=0.64 l=0.15
X14 a_1113_383# a_897_54# VPWR VPB sky130_fd_pr__pfet_01v8 ad=0.3 pd=2.6 as=0.1925 ps=1.385 w=1 l=0.15
X15 a_363_394# a_786_100# a_1113_383# VNB sky130_fd_pr__nfet_01v8_lvt ad=0.09995 pd=0.985 as=0.1136 ps=1.05 w=0.42 l=0.15
X16 VPWR A a_897_54# VPB sky130_fd_pr__pfet_01v8 ad=0.1925 pd=1.385 as=0.1858 ps=1.39 w=1 l=0.15
X17 VPWR a_81_268# X VPB sky130_fd_pr__pfet_01v8 ad=0.2404 pd=1.65 as=0.3192 ps=2.81 w=1.12 l=0.15
X18 a_81_268# C a_371_74# VNB sky130_fd_pr__nfet_01v8_lvt ad=0.112 pd=0.99 as=0.1824 ps=1.85 w=0.64 l=0.15
X19 a_371_74# a_786_100# a_1113_383# VPB sky130_fd_pr__pfet_01v8 ad=0.1852 pd=1.325 as=0.096 ps=0.94 w=0.64 l=0.15
X20 a_1113_383# B a_363_394# VPB sky130_fd_pr__pfet_01v8 ad=0.096 pd=0.94 as=0.1527 ps=1.225 w=0.64 l=0.15
X21 a_897_54# B a_363_394# VNB sky130_fd_pr__nfet_01v8_lvt ad=0.1104 pd=0.985 as=0.09995 ps=0.985 w=0.64 l=0.15
.ends

.subckt sky130_fd_sc_hs__nor3b_4 VPWR VGND Y A B C_N VNB VPB
X0 Y a_468_264# VGND VNB sky130_fd_pr__nfet_01v8_lvt ad=0.1036 pd=1.02 as=0.1295 ps=1.09 w=0.74 l=0.15
X1 VPWR C_N a_468_264# VPB sky130_fd_pr__pfet_01v8 ad=0.2478 pd=2.27 as=0.126 ps=1.14 w=0.84 l=0.15
X2 a_468_264# C_N VPWR VPB sky130_fd_pr__pfet_01v8 ad=0.126 pd=1.14 as=0.231 ps=1.555 w=0.84 l=0.15
X3 VGND A Y VNB sky130_fd_pr__nfet_01v8_lvt ad=0.2035 pd=1.29 as=0.1036 ps=1.02 w=0.74 l=0.15
X4 VGND A Y VNB sky130_fd_pr__nfet_01v8_lvt ad=0.1295 pd=1.09 as=0.1295 ps=1.09 w=0.74 l=0.15
X5 VGND B Y VNB sky130_fd_pr__nfet_01v8_lvt ad=0.1295 pd=1.09 as=0.1036 ps=1.02 w=0.74 l=0.15
X6 a_126_368# B a_27_368# VPB sky130_fd_pr__pfet_01v8 ad=0.21 pd=1.495 as=0.168 ps=1.42 w=1.12 l=0.15
X7 a_27_368# B a_126_368# VPB sky130_fd_pr__pfet_01v8 ad=0.168 pd=1.42 as=0.168 ps=1.42 w=1.12 l=0.15
X8 VPWR A a_126_368# VPB sky130_fd_pr__pfet_01v8 ad=0.231 pd=1.555 as=0.168 ps=1.42 w=1.12 l=0.15
X9 Y a_468_264# VGND VNB sky130_fd_pr__nfet_01v8_lvt ad=0.1036 pd=1.02 as=0.1295 ps=1.09 w=0.74 l=0.15
X10 a_126_368# A VPWR VPB sky130_fd_pr__pfet_01v8 ad=0.168 pd=1.42 as=0.3304 ps=2.83 w=1.12 l=0.15
X11 a_126_368# A VPWR VPB sky130_fd_pr__pfet_01v8 ad=0.168 pd=1.42 as=0.168 ps=1.42 w=1.12 l=0.15
X12 Y A VGND VNB sky130_fd_pr__nfet_01v8_lvt ad=0.1295 pd=1.09 as=0.2035 ps=1.29 w=0.74 l=0.15
X13 VPWR A a_126_368# VPB sky130_fd_pr__pfet_01v8 ad=0.168 pd=1.42 as=0.168 ps=1.42 w=1.12 l=0.15
X14 Y B VGND VNB sky130_fd_pr__nfet_01v8_lvt ad=0.11285 pd=1.045 as=0.2442 ps=2.14 w=0.74 l=0.15
X15 Y B VGND VNB sky130_fd_pr__nfet_01v8_lvt ad=0.1036 pd=1.02 as=0.1554 ps=1.16 w=0.74 l=0.15
X16 VGND a_468_264# Y VNB sky130_fd_pr__nfet_01v8_lvt ad=0.1554 pd=1.16 as=0.1036 ps=1.02 w=0.74 l=0.15
X17 VGND a_468_264# Y VNB sky130_fd_pr__nfet_01v8_lvt ad=0.1295 pd=1.09 as=0.1036 ps=1.02 w=0.74 l=0.15
X18 a_27_368# a_468_264# Y VPB sky130_fd_pr__pfet_01v8 ad=0.3304 pd=2.83 as=0.168 ps=1.42 w=1.12 l=0.15
X19 Y a_468_264# a_27_368# VPB sky130_fd_pr__pfet_01v8 ad=0.168 pd=1.42 as=0.168 ps=1.42 w=1.12 l=0.15
X20 VGND B Y VNB sky130_fd_pr__nfet_01v8_lvt ad=0.1554 pd=1.16 as=0.11285 ps=1.045 w=0.74 l=0.15
X21 a_126_368# B a_27_368# VPB sky130_fd_pr__pfet_01v8 ad=0.168 pd=1.42 as=0.3864 ps=2.93 w=1.12 l=0.15
X22 a_27_368# a_468_264# Y VPB sky130_fd_pr__pfet_01v8 ad=0.168 pd=1.42 as=0.168 ps=1.42 w=1.12 l=0.15
X23 Y a_468_264# a_27_368# VPB sky130_fd_pr__pfet_01v8 ad=0.168 pd=1.42 as=0.168 ps=1.42 w=1.12 l=0.15
X24 a_27_368# B a_126_368# VPB sky130_fd_pr__pfet_01v8 ad=0.168 pd=1.42 as=0.21 ps=1.495 w=1.12 l=0.15
X25 Y A VGND VNB sky130_fd_pr__nfet_01v8_lvt ad=0.1036 pd=1.02 as=0.1554 ps=1.16 w=0.74 l=0.15
X26 a_468_264# C_N VGND VNB sky130_fd_pr__nfet_01v8_lvt ad=0.6771 pd=3.31 as=0.1295 ps=1.09 w=0.74 l=0.15
.ends

.subckt sky130_fd_sc_hs__o31ai_4 VPWR VGND Y B1 A3 A2 A1 VNB VPB
X0 a_27_82# A3 VGND VNB sky130_fd_pr__nfet_01v8_lvt ad=0.1036 pd=1.02 as=0.3627 ps=1.75 w=0.74 l=0.15
X1 Y B1 a_27_82# VNB sky130_fd_pr__nfet_01v8_lvt ad=0.1036 pd=1.02 as=0.1036 ps=1.02 w=0.74 l=0.15
X2 Y B1 VPWR VPB sky130_fd_pr__pfet_01v8 ad=0.3304 pd=2.83 as=0.5852 ps=2.165 w=1.12 l=0.15
X3 a_27_82# A2 VGND VNB sky130_fd_pr__nfet_01v8_lvt ad=0.1295 pd=1.09 as=0.2183 ps=1.33 w=0.74 l=0.15
X4 a_28_368# A2 a_487_368# VPB sky130_fd_pr__pfet_01v8 ad=0.3192 pd=1.69 as=0.196 ps=1.47 w=1.12 l=0.15
X5 VPWR A1 a_28_368# VPB sky130_fd_pr__pfet_01v8 ad=0.168 pd=1.42 as=0.3304 ps=2.83 w=1.12 l=0.15
X6 a_27_82# A1 VGND VNB sky130_fd_pr__nfet_01v8_lvt ad=0.1036 pd=1.02 as=0.1295 ps=1.09 w=0.74 l=0.15
X7 a_487_368# A3 Y VPB sky130_fd_pr__pfet_01v8 ad=0.168 pd=1.42 as=0.3304 ps=2.83 w=1.12 l=0.15
X8 VGND A1 a_27_82# VNB sky130_fd_pr__nfet_01v8_lvt ad=0.1295 pd=1.09 as=0.2109 ps=2.05 w=0.74 l=0.15
X9 a_487_368# A2 a_28_368# VPB sky130_fd_pr__pfet_01v8 ad=0.196 pd=1.47 as=0.168 ps=1.42 w=1.12 l=0.15
X10 VGND A2 a_27_82# VNB sky130_fd_pr__nfet_01v8_lvt ad=0.2183 pd=1.33 as=0.1036 ps=1.02 w=0.74 l=0.15
X11 a_28_368# A2 a_487_368# VPB sky130_fd_pr__pfet_01v8 ad=0.3864 pd=2.93 as=0.168 ps=1.42 w=1.12 l=0.15
X12 a_28_368# A1 VPWR VPB sky130_fd_pr__pfet_01v8 ad=0.168 pd=1.42 as=0.196 ps=1.47 w=1.12 l=0.15
X13 VGND A1 a_27_82# VNB sky130_fd_pr__nfet_01v8_lvt ad=0.1295 pd=1.09 as=0.1036 ps=1.02 w=0.74 l=0.15
X14 a_27_82# A2 VGND VNB sky130_fd_pr__nfet_01v8_lvt ad=0.1036 pd=1.02 as=0.1036 ps=1.02 w=0.74 l=0.15
X15 VPWR B1 Y VPB sky130_fd_pr__pfet_01v8 ad=0.5852 pd=2.165 as=0.196 ps=1.47 w=1.12 l=0.15
X16 a_27_82# B1 Y VNB sky130_fd_pr__nfet_01v8_lvt ad=0.2109 pd=2.05 as=0.1036 ps=1.02 w=0.74 l=0.15
X17 a_27_82# B1 Y VNB sky130_fd_pr__nfet_01v8_lvt ad=0.1036 pd=1.02 as=0.1036 ps=1.02 w=0.74 l=0.15
X18 a_487_368# A2 a_28_368# VPB sky130_fd_pr__pfet_01v8 ad=0.168 pd=1.42 as=0.3192 ps=1.69 w=1.12 l=0.15
X19 VGND A3 a_27_82# VNB sky130_fd_pr__nfet_01v8_lvt ad=0.3627 pd=1.75 as=0.1036 ps=1.02 w=0.74 l=0.15
X20 VGND A3 a_27_82# VNB sky130_fd_pr__nfet_01v8_lvt ad=0.201 pd=1.42 as=0.1036 ps=1.02 w=0.74 l=0.15
X21 VPWR A1 a_28_368# VPB sky130_fd_pr__pfet_01v8 ad=0.196 pd=1.47 as=0.168 ps=1.42 w=1.12 l=0.15
X22 a_27_82# A1 VGND VNB sky130_fd_pr__nfet_01v8_lvt ad=0.1036 pd=1.02 as=0.1295 ps=1.09 w=0.74 l=0.15
X23 a_28_368# A1 VPWR VPB sky130_fd_pr__pfet_01v8 ad=0.168 pd=1.42 as=0.168 ps=1.42 w=1.12 l=0.15
X24 VGND A2 a_27_82# VNB sky130_fd_pr__nfet_01v8_lvt ad=0.1036 pd=1.02 as=0.1295 ps=1.09 w=0.74 l=0.15
X25 a_27_82# A3 VGND VNB sky130_fd_pr__nfet_01v8_lvt ad=0.1036 pd=1.02 as=0.201 ps=1.42 w=0.74 l=0.15
X26 Y A3 a_487_368# VPB sky130_fd_pr__pfet_01v8 ad=0.196 pd=1.47 as=0.168 ps=1.42 w=1.12 l=0.15
X27 Y B1 a_27_82# VNB sky130_fd_pr__nfet_01v8_lvt ad=0.1036 pd=1.02 as=0.1036 ps=1.02 w=0.74 l=0.15
X28 a_487_368# A3 Y VPB sky130_fd_pr__pfet_01v8 ad=0.168 pd=1.42 as=0.168 ps=1.42 w=1.12 l=0.15
X29 Y A3 a_487_368# VPB sky130_fd_pr__pfet_01v8 ad=0.168 pd=1.42 as=0.168 ps=1.42 w=1.12 l=0.15
.ends

.subckt sky130_fd_sc_hs__or3_1 VPWR VGND A B C X VNB VPB
X0 a_116_368# C a_27_74# VPB sky130_fd_pr__pfet_01v8 ad=0.135 pd=1.27 as=0.295 ps=2.59 w=1 l=0.15
X1 VGND C a_27_74# VNB sky130_fd_pr__nfet_01v8_lvt ad=0.09625 pd=0.9 as=0.15675 ps=1.67 w=0.55 l=0.15
X2 VGND A a_27_74# VNB sky130_fd_pr__nfet_01v8_lvt ad=0.13925 pd=1.16 as=0.18288 ps=1.215 w=0.55 l=0.15
X3 a_200_368# B a_116_368# VPB sky130_fd_pr__pfet_01v8 ad=0.21 pd=1.42 as=0.135 ps=1.27 w=1 l=0.15
X4 VPWR A a_200_368# VPB sky130_fd_pr__pfet_01v8 ad=0.3809 pd=1.85 as=0.21 ps=1.42 w=1 l=0.15
X5 a_27_74# B VGND VNB sky130_fd_pr__nfet_01v8_lvt ad=0.18288 pd=1.215 as=0.09625 ps=0.9 w=0.55 l=0.15
X6 X a_27_74# VGND VNB sky130_fd_pr__nfet_01v8_lvt ad=0.2109 pd=2.05 as=0.13925 ps=1.16 w=0.74 l=0.15
X7 X a_27_74# VPWR VPB sky130_fd_pr__pfet_01v8 ad=0.3304 pd=2.83 as=0.3809 ps=1.85 w=1.12 l=0.15
.ends

.subckt sky130_fd_sc_hs__a211o_1 VPWR VGND X C1 B1 A2 A1 VNB VPB
X0 a_366_136# A2 VGND VNB sky130_fd_pr__nfet_01v8_lvt ad=0.104 pd=0.965 as=0.15642 ps=1.35 w=0.64 l=0.15
X1 VGND B1 a_81_264# VNB sky130_fd_pr__nfet_01v8_lvt ad=0.112 pd=0.99 as=0.0896 ps=0.92 w=0.64 l=0.15
X2 a_81_264# C1 a_550_392# VPB sky130_fd_pr__pfet_01v8 ad=0.275 pd=2.55 as=0.12 ps=1.24 w=1 l=0.15
X3 VGND a_81_264# X VNB sky130_fd_pr__nfet_01v8_lvt ad=0.15642 pd=1.35 as=0.1961 ps=2.01 w=0.74 l=0.15
X4 VPWR a_81_264# X VPB sky130_fd_pr__pfet_01v8 ad=0.308 pd=2.79 as=0.308 ps=2.79 w=1.12 l=0.15
X5 a_550_392# B1 a_279_392# VPB sky130_fd_pr__pfet_01v8 ad=0.12 pd=1.24 as=0.15 ps=1.3 w=1 l=0.15
X6 a_279_392# A1 VPWR VPB sky130_fd_pr__pfet_01v8 ad=0.15 pd=1.3 as=0.165 ps=1.33 w=1 l=0.15
X7 VPWR A2 a_279_392# VPB sky130_fd_pr__pfet_01v8 ad=0.165 pd=1.33 as=0.275 ps=2.55 w=1 l=0.15
X8 a_81_264# C1 VGND VNB sky130_fd_pr__nfet_01v8_lvt ad=0.1696 pd=1.81 as=0.112 ps=0.99 w=0.64 l=0.15
X9 a_81_264# A1 a_366_136# VNB sky130_fd_pr__nfet_01v8_lvt ad=0.0896 pd=0.92 as=0.104 ps=0.965 w=0.64 l=0.15
.ends

.subckt sky130_fd_sc_hs__and2_1 VPWR VGND A B X VNB VPB
X0 VGND B a_143_136# VNB sky130_fd_pr__nfet_01v8_lvt ad=0.15535 pd=1.17 as=0.1376 ps=1.14 w=0.64 l=0.15
X1 X a_56_136# VGND VNB sky130_fd_pr__nfet_01v8_lvt ad=0.2109 pd=2.05 as=0.15535 ps=1.17 w=0.74 l=0.15
X2 VPWR B a_56_136# VPB sky130_fd_pr__pfet_01v8 ad=0.1988 pd=1.505 as=0.147 ps=1.19 w=0.84 l=0.15
X3 a_143_136# A a_56_136# VNB sky130_fd_pr__nfet_01v8_lvt ad=0.1376 pd=1.14 as=0.1824 ps=1.85 w=0.64 l=0.15
X4 a_56_136# A VPWR VPB sky130_fd_pr__pfet_01v8 ad=0.147 pd=1.19 as=0.252 ps=2.28 w=0.84 l=0.15
X5 X a_56_136# VPWR VPB sky130_fd_pr__pfet_01v8 ad=0.3304 pd=2.83 as=0.1988 ps=1.505 w=1.12 l=0.15
.ends

.subckt sky130_fd_sc_hs__o221ai_1 VPWR VGND Y B1 A1 C1 B2 A2 VNB VPB
X0 VGND A2 a_239_74# VNB sky130_fd_pr__nfet_01v8_lvt ad=0.2368 pd=1.38 as=0.1295 ps=1.09 w=0.74 l=0.15
X1 a_114_74# C1 Y VNB sky130_fd_pr__nfet_01v8_lvt ad=0.2627 pd=2.19 as=0.2109 ps=2.05 w=0.74 l=0.15
X2 a_239_74# B2 a_114_74# VNB sky130_fd_pr__nfet_01v8_lvt ad=0.1295 pd=1.09 as=0.1295 ps=1.09 w=0.74 l=0.15
X3 Y B2 a_324_368# VPB sky130_fd_pr__pfet_01v8 ad=0.2352 pd=1.54 as=0.1512 ps=1.39 w=1.12 l=0.15
X4 VPWR C1 Y VPB sky130_fd_pr__pfet_01v8 ad=0.4256 pd=1.88 as=0.3304 ps=2.83 w=1.12 l=0.15
X5 a_324_368# B1 VPWR VPB sky130_fd_pr__pfet_01v8 ad=0.1512 pd=1.39 as=0.4256 ps=1.88 w=1.12 l=0.15
X6 a_522_368# A2 Y VPB sky130_fd_pr__pfet_01v8 ad=0.2352 pd=1.54 as=0.2352 ps=1.54 w=1.12 l=0.15
X7 a_114_74# B1 a_239_74# VNB sky130_fd_pr__nfet_01v8_lvt ad=0.1295 pd=1.09 as=0.2109 ps=2.05 w=0.74 l=0.15
X8 VPWR A1 a_522_368# VPB sky130_fd_pr__pfet_01v8 ad=0.3304 pd=2.83 as=0.2352 ps=1.54 w=1.12 l=0.15
X9 a_239_74# A1 VGND VNB sky130_fd_pr__nfet_01v8_lvt ad=0.2109 pd=2.05 as=0.2368 ps=1.38 w=0.74 l=0.15
.ends

.subckt sky130_fd_sc_hs__nor3_4 VPWR VGND A B C Y VNB VPB
X0 Y C VGND VNB sky130_fd_pr__nfet_01v8_lvt ad=0.1036 pd=1.02 as=0.1554 ps=1.16 w=0.74 l=0.15
X1 a_295_368# C Y VPB sky130_fd_pr__pfet_01v8 ad=0.2744 pd=1.7 as=0.26145 ps=1.64 w=1.12 l=0.15
X2 VGND B Y VNB sky130_fd_pr__nfet_01v8_lvt ad=0.1554 pd=1.16 as=0.1036 ps=1.02 w=0.74 l=0.15
X3 Y A VGND VNB sky130_fd_pr__nfet_01v8_lvt ad=0.1073 pd=1.03 as=0.2109 ps=2.05 w=0.74 l=0.15
X4 a_27_368# A VPWR VPB sky130_fd_pr__pfet_01v8 ad=0.3192 pd=2.81 as=0.168 ps=1.42 w=1.12 l=0.15
X5 a_295_368# B a_27_368# VPB sky130_fd_pr__pfet_01v8 ad=0.2713 pd=1.695 as=0.168 ps=1.42 w=1.12 l=0.15
X6 a_295_368# B a_27_368# VPB sky130_fd_pr__pfet_01v8 ad=0.168 pd=1.42 as=0.168 ps=1.42 w=1.12 l=0.15
X7 VPWR A a_27_368# VPB sky130_fd_pr__pfet_01v8 ad=0.168 pd=1.42 as=0.168 ps=1.42 w=1.12 l=0.15
X8 a_27_368# A VPWR VPB sky130_fd_pr__pfet_01v8 ad=0.168 pd=1.42 as=0.168 ps=1.42 w=1.12 l=0.15
X9 a_27_368# B a_295_368# VPB sky130_fd_pr__pfet_01v8 ad=0.168 pd=1.42 as=0.2744 ps=1.7 w=1.12 l=0.15
X10 a_27_368# B a_295_368# VPB sky130_fd_pr__pfet_01v8 ad=0.168 pd=1.42 as=0.168 ps=1.42 w=1.12 l=0.15
X11 Y B VGND VNB sky130_fd_pr__nfet_01v8_lvt ad=0.1036 pd=1.02 as=0.1517 ps=1.15 w=0.74 l=0.15
X12 VGND A Y VNB sky130_fd_pr__nfet_01v8_lvt ad=0.1517 pd=1.15 as=0.1073 ps=1.03 w=0.74 l=0.15
X13 VGND C Y VNB sky130_fd_pr__nfet_01v8_lvt ad=0.40425 pd=2.58 as=0.1036 ps=1.02 w=0.74 l=0.15
X14 Y C a_295_368# VPB sky130_fd_pr__pfet_01v8 ad=0.26145 pd=1.64 as=0.2713 ps=1.695 w=1.12 l=0.15
X15 Y C a_295_368# VPB sky130_fd_pr__pfet_01v8 ad=0.26145 pd=1.64 as=0.2744 ps=1.7 w=1.12 l=0.15
X16 VPWR A a_27_368# VPB sky130_fd_pr__pfet_01v8 ad=0.168 pd=1.42 as=0.3248 ps=2.82 w=1.12 l=0.15
X17 a_295_368# C Y VPB sky130_fd_pr__pfet_01v8 ad=0.2744 pd=1.7 as=0.26145 ps=1.64 w=1.12 l=0.15
.ends

.subckt sky130_fd_sc_hs__a41oi_1 VPWR VGND Y A2 A1 B1 A4 A3 VNB VPB
X0 a_116_368# B1 Y VPB sky130_fd_pr__pfet_01v8 ad=0.196 pd=1.47 as=0.3304 ps=2.83 w=1.12 l=0.15
X1 VPWR A2 a_116_368# VPB sky130_fd_pr__pfet_01v8 ad=0.2296 pd=1.53 as=0.168 ps=1.42 w=1.12 l=0.15
X2 a_355_74# A3 a_277_74# VNB sky130_fd_pr__nfet_01v8_lvt ad=0.1554 pd=1.16 as=0.0888 ps=0.98 w=0.74 l=0.15
X3 a_116_368# A3 VPWR VPB sky130_fd_pr__pfet_01v8 ad=0.168 pd=1.42 as=0.3864 ps=1.81 w=1.12 l=0.15
X4 Y A1 a_469_74# VNB sky130_fd_pr__nfet_01v8_lvt ad=0.2109 pd=2.05 as=0.1554 ps=1.16 w=0.74 l=0.15
X5 VGND B1 Y VNB sky130_fd_pr__nfet_01v8_lvt ad=0.24605 pd=1.405 as=0.2109 ps=2.05 w=0.74 l=0.15
X6 VPWR A4 a_116_368# VPB sky130_fd_pr__pfet_01v8 ad=0.3864 pd=1.81 as=0.196 ps=1.47 w=1.12 l=0.15
X7 a_277_74# A4 VGND VNB sky130_fd_pr__nfet_01v8_lvt ad=0.0888 pd=0.98 as=0.24605 ps=1.405 w=0.74 l=0.15
X8 a_469_74# A2 a_355_74# VNB sky130_fd_pr__nfet_01v8_lvt ad=0.1554 pd=1.16 as=0.1554 ps=1.16 w=0.74 l=0.15
X9 a_116_368# A1 VPWR VPB sky130_fd_pr__pfet_01v8 ad=0.3304 pd=2.83 as=0.2296 ps=1.53 w=1.12 l=0.15
.ends

.subckt sky130_fd_sc_hs__inv_8 VPWR VGND A Y VNB VPB
X0 Y A VPWR VPB sky130_fd_pr__pfet_01v8 ad=0.168 pd=1.42 as=0.3304 ps=2.83 w=1.12 l=0.15
X1 VPWR A Y VPB sky130_fd_pr__pfet_01v8 ad=0.196 pd=1.47 as=0.168 ps=1.42 w=1.12 l=0.15
X2 Y A VGND VNB sky130_fd_pr__nfet_01v8_lvt ad=0.1036 pd=1.02 as=0.2109 ps=2.05 w=0.74 l=0.15
X3 Y A VPWR VPB sky130_fd_pr__pfet_01v8 ad=0.168 pd=1.42 as=0.168 ps=1.42 w=1.12 l=0.15
X4 Y A VGND VNB sky130_fd_pr__nfet_01v8_lvt ad=0.1036 pd=1.02 as=0.1295 ps=1.09 w=0.74 l=0.15
X5 VPWR A Y VPB sky130_fd_pr__pfet_01v8 ad=0.168 pd=1.42 as=0.168 ps=1.42 w=1.12 l=0.15
X6 Y A VPWR VPB sky130_fd_pr__pfet_01v8 ad=0.168 pd=1.42 as=0.196 ps=1.47 w=1.12 l=0.15
X7 VGND A Y VNB sky130_fd_pr__nfet_01v8_lvt ad=0.2146 pd=2.06 as=0.1036 ps=1.02 w=0.74 l=0.15
X8 VGND A Y VNB sky130_fd_pr__nfet_01v8_lvt ad=0.1295 pd=1.09 as=0.1036 ps=1.02 w=0.74 l=0.15
X9 VPWR A Y VPB sky130_fd_pr__pfet_01v8 ad=0.196 pd=1.47 as=0.168 ps=1.42 w=1.12 l=0.15
X10 VGND A Y VNB sky130_fd_pr__nfet_01v8_lvt ad=0.1036 pd=1.02 as=0.1036 ps=1.02 w=0.74 l=0.15
X11 Y A VGND VNB sky130_fd_pr__nfet_01v8_lvt ad=0.1036 pd=1.02 as=0.1554 ps=1.16 w=0.74 l=0.15
X12 Y A VGND VNB sky130_fd_pr__nfet_01v8_lvt ad=0.1036 pd=1.02 as=0.1036 ps=1.02 w=0.74 l=0.15
X13 VPWR A Y VPB sky130_fd_pr__pfet_01v8 ad=0.3864 pd=2.93 as=0.168 ps=1.42 w=1.12 l=0.15
X14 Y A VPWR VPB sky130_fd_pr__pfet_01v8 ad=0.168 pd=1.42 as=0.196 ps=1.47 w=1.12 l=0.15
X15 VGND A Y VNB sky130_fd_pr__nfet_01v8_lvt ad=0.1554 pd=1.16 as=0.1036 ps=1.02 w=0.74 l=0.15
.ends

.subckt sky130_fd_sc_hs__a21oi_4 VPWR VGND Y B1 A2 A1 VNB VPB
X0 a_69_368# A1 VPWR VPB sky130_fd_pr__pfet_01v8 ad=0.168 pd=1.42 as=0.168 ps=1.42 w=1.12 l=0.15
X1 VPWR A1 a_69_368# VPB sky130_fd_pr__pfet_01v8 ad=0.168 pd=1.42 as=0.168 ps=1.42 w=1.12 l=0.15
X2 a_69_368# A1 VPWR VPB sky130_fd_pr__pfet_01v8 ad=0.168 pd=1.42 as=0.168 ps=1.42 w=1.12 l=0.15
X3 Y A1 a_84_74# VNB sky130_fd_pr__nfet_01v8_lvt ad=0.1036 pd=1.02 as=0.1036 ps=1.02 w=0.74 l=0.15
X4 VGND B1 Y VNB sky130_fd_pr__nfet_01v8_lvt ad=0.1036 pd=1.02 as=0.1961 ps=2.01 w=0.74 l=0.15
X5 VPWR A1 a_69_368# VPB sky130_fd_pr__pfet_01v8 ad=0.168 pd=1.42 as=0.168 ps=1.42 w=1.12 l=0.15
X6 a_69_368# A2 VPWR VPB sky130_fd_pr__pfet_01v8 ad=0.168 pd=1.42 as=0.168 ps=1.42 w=1.12 l=0.15
X7 a_84_74# A1 Y VNB sky130_fd_pr__nfet_01v8_lvt ad=0.2109 pd=2.05 as=0.1036 ps=1.02 w=0.74 l=0.15
X8 Y B1 VGND VNB sky130_fd_pr__nfet_01v8_lvt ad=0.1961 pd=2.01 as=0.1036 ps=1.02 w=0.74 l=0.15
X9 a_84_74# A1 Y VNB sky130_fd_pr__nfet_01v8_lvt ad=0.1036 pd=1.02 as=0.1036 ps=1.02 w=0.74 l=0.15
X10 a_84_74# A2 VGND VNB sky130_fd_pr__nfet_01v8_lvt ad=0.1036 pd=1.02 as=0.1036 ps=1.02 w=0.74 l=0.15
X11 VPWR A2 a_69_368# VPB sky130_fd_pr__pfet_01v8 ad=0.168 pd=1.42 as=0.168 ps=1.42 w=1.12 l=0.15
X12 a_84_74# A2 VGND VNB sky130_fd_pr__nfet_01v8_lvt ad=0.1036 pd=1.02 as=0.1036 ps=1.02 w=0.74 l=0.15
X13 a_69_368# A2 VPWR VPB sky130_fd_pr__pfet_01v8 ad=0.168 pd=1.42 as=0.168 ps=1.42 w=1.12 l=0.15
X14 VPWR A2 a_69_368# VPB sky130_fd_pr__pfet_01v8 ad=0.168 pd=1.42 as=0.308 ps=2.79 w=1.12 l=0.15
X15 VGND A2 a_84_74# VNB sky130_fd_pr__nfet_01v8_lvt ad=0.1036 pd=1.02 as=0.1036 ps=1.02 w=0.74 l=0.15
X16 VGND A2 a_84_74# VNB sky130_fd_pr__nfet_01v8_lvt ad=0.1036 pd=1.02 as=0.1961 ps=2.01 w=0.74 l=0.15
X17 a_69_368# B1 Y VPB sky130_fd_pr__pfet_01v8 ad=0.168 pd=1.42 as=0.168 ps=1.42 w=1.12 l=0.15
X18 a_69_368# B1 Y VPB sky130_fd_pr__pfet_01v8 ad=0.308 pd=2.79 as=0.168 ps=1.42 w=1.12 l=0.15
X19 Y B1 a_69_368# VPB sky130_fd_pr__pfet_01v8 ad=0.168 pd=1.42 as=0.168 ps=1.42 w=1.12 l=0.15
X20 Y B1 a_69_368# VPB sky130_fd_pr__pfet_01v8 ad=0.168 pd=1.42 as=0.168 ps=1.42 w=1.12 l=0.15
X21 Y A1 a_84_74# VNB sky130_fd_pr__nfet_01v8_lvt ad=0.1036 pd=1.02 as=0.1036 ps=1.02 w=0.74 l=0.15
.ends

.subckt sky130_fd_sc_hs__o31ai_2 VPWR VGND A2 B1 A3 A1 Y VNB VPB
X0 VPWR B1 Y VPB sky130_fd_pr__pfet_01v8 ad=0.168 pd=1.42 as=0.196 ps=1.47 w=1.12 l=0.15
X1 VGND A3 a_27_74# VNB sky130_fd_pr__nfet_01v8_lvt ad=0.32 pd=1.645 as=0.1036 ps=1.02 w=0.74 l=0.15
X2 VPWR A1 a_28_368# VPB sky130_fd_pr__pfet_01v8 ad=0.168 pd=1.42 as=0.3304 ps=2.83 w=1.12 l=0.15
X3 Y A3 a_297_368# VPB sky130_fd_pr__pfet_01v8 ad=0.196 pd=1.47 as=0.168 ps=1.42 w=1.12 l=0.15
X4 VGND A1 a_27_74# VNB sky130_fd_pr__nfet_01v8_lvt ad=0.1554 pd=1.16 as=0.2109 ps=2.05 w=0.74 l=0.15
X5 a_27_74# A2 VGND VNB sky130_fd_pr__nfet_01v8_lvt ad=0.1036 pd=1.02 as=0.1554 ps=1.16 w=0.74 l=0.15
X6 a_297_368# A3 Y VPB sky130_fd_pr__pfet_01v8 ad=0.168 pd=1.42 as=0.3304 ps=2.83 w=1.12 l=0.15
X7 a_27_74# B1 Y VNB sky130_fd_pr__nfet_01v8_lvt ad=0.2257 pd=2.09 as=0.1221 ps=1.07 w=0.74 l=0.15
X8 Y B1 a_27_74# VNB sky130_fd_pr__nfet_01v8_lvt ad=0.1221 pd=1.07 as=0.1036 ps=1.02 w=0.74 l=0.15
X9 VGND A2 a_27_74# VNB sky130_fd_pr__nfet_01v8_lvt ad=0.1554 pd=1.16 as=0.1036 ps=1.02 w=0.74 l=0.15
X10 a_28_368# A2 a_297_368# VPB sky130_fd_pr__pfet_01v8 ad=0.3304 pd=2.83 as=0.168 ps=1.42 w=1.12 l=0.15
X11 a_297_368# A2 a_28_368# VPB sky130_fd_pr__pfet_01v8 ad=0.168 pd=1.42 as=0.168 ps=1.42 w=1.12 l=0.15
X12 a_27_74# A3 VGND VNB sky130_fd_pr__nfet_01v8_lvt ad=0.1036 pd=1.02 as=0.32 ps=1.645 w=0.74 l=0.15
X13 a_27_74# A1 VGND VNB sky130_fd_pr__nfet_01v8_lvt ad=0.1036 pd=1.02 as=0.1554 ps=1.16 w=0.74 l=0.15
X14 a_28_368# A1 VPWR VPB sky130_fd_pr__pfet_01v8 ad=0.168 pd=1.42 as=0.168 ps=1.42 w=1.12 l=0.15
X15 Y B1 VPWR VPB sky130_fd_pr__pfet_01v8 ad=0.3304 pd=2.83 as=0.168 ps=1.42 w=1.12 l=0.15
.ends

.subckt sky130_fd_sc_hs__o21bai_1 VPWR VGND B1_N Y A2 A1 VNB VPB
X0 VGND A2 a_308_74# VNB sky130_fd_pr__nfet_01v8_lvt ad=0.1073 pd=1.03 as=0.1221 ps=1.07 w=0.74 l=0.15
X1 a_395_368# A2 Y VPB sky130_fd_pr__pfet_01v8 ad=0.1848 pd=1.45 as=0.168 ps=1.42 w=1.12 l=0.15
X2 VPWR A1 a_395_368# VPB sky130_fd_pr__pfet_01v8 ad=0.3248 pd=2.82 as=0.1848 ps=1.45 w=1.12 l=0.15
X3 Y a_27_74# VPWR VPB sky130_fd_pr__pfet_01v8 ad=0.168 pd=1.42 as=0.3626 ps=1.895 w=1.12 l=0.15
X4 a_308_74# a_27_74# Y VNB sky130_fd_pr__nfet_01v8_lvt ad=0.1221 pd=1.07 as=0.2072 ps=2.04 w=0.74 l=0.15
X5 VPWR B1_N a_27_74# VPB sky130_fd_pr__pfet_01v8 ad=0.3626 pd=1.895 as=0.2478 ps=2.27 w=0.84 l=0.15
X6 VGND B1_N a_27_74# VNB sky130_fd_pr__nfet_01v8_lvt ad=0.15125 pd=1.65 as=0.154 ps=1.66 w=0.55 l=0.15
X7 a_308_74# A1 VGND VNB sky130_fd_pr__nfet_01v8_lvt ad=0.2109 pd=2.05 as=0.1073 ps=1.03 w=0.74 l=0.15
.ends

.subckt sky130_fd_sc_hs__o2111a_1 VPWR VGND A1 A2 B1 C1 D1 X VNB VPB
X0 VPWR a_82_48# X VPB sky130_fd_pr__pfet_01v8 ad=0.24158 pd=1.6 as=0.3304 ps=2.83 w=1.12 l=0.15
X1 VGND A2 a_471_74# VNB sky130_fd_pr__nfet_01v8_lvt ad=0.1443 pd=1.13 as=0.1332 ps=1.1 w=0.74 l=0.15
X2 a_471_74# A1 VGND VNB sky130_fd_pr__nfet_01v8_lvt ad=0.2109 pd=2.05 as=0.1443 ps=1.13 w=0.74 l=0.15
X3 VPWR A1 a_600_381# VPB sky130_fd_pr__pfet_01v8 ad=0.285 pd=2.57 as=0.135 ps=1.27 w=1 l=0.15
X4 VPWR C1 a_82_48# VPB sky130_fd_pr__pfet_01v8 ad=0.2541 pd=1.445 as=0.147 ps=1.19 w=0.84 l=0.15
X5 a_600_381# A2 a_82_48# VPB sky130_fd_pr__pfet_01v8 ad=0.135 pd=1.27 as=0.1853 ps=1.385 w=1 l=0.15
X6 VGND a_82_48# X VNB sky130_fd_pr__nfet_01v8_lvt ad=0.2035 pd=2.03 as=0.2035 ps=2.03 w=0.74 l=0.15
X7 a_471_74# B1 a_393_74# VNB sky130_fd_pr__nfet_01v8_lvt ad=0.1332 pd=1.1 as=0.0888 ps=0.98 w=0.74 l=0.15
X8 a_82_48# D1 VPWR VPB sky130_fd_pr__pfet_01v8 ad=0.147 pd=1.19 as=0.24158 ps=1.6 w=0.84 l=0.15
X9 a_321_74# D1 a_82_48# VNB sky130_fd_pr__nfet_01v8_lvt ad=0.0777 pd=0.95 as=0.259 ps=2.18 w=0.74 l=0.15
X10 a_393_74# C1 a_321_74# VNB sky130_fd_pr__nfet_01v8_lvt ad=0.0888 pd=0.98 as=0.0777 ps=0.95 w=0.74 l=0.15
X11 a_82_48# B1 VPWR VPB sky130_fd_pr__pfet_01v8 ad=0.1853 pd=1.385 as=0.2541 ps=1.445 w=0.84 l=0.15
.ends

.subckt sky130_fd_sc_hs__a41o_1 VPWR VGND A4 A1 A2 A3 B1 X VNB VPB
X0 a_354_392# B1 a_83_244# VPB sky130_fd_pr__pfet_01v8 ad=0.175 pd=1.35 as=0.295 ps=2.59 w=1 l=0.15
X1 VPWR a_83_244# X VPB sky130_fd_pr__pfet_01v8 ad=0.3304 pd=2.83 as=0.3304 ps=2.83 w=1.12 l=0.15
X2 VGND a_83_244# X VNB sky130_fd_pr__nfet_01v8_lvt ad=0.1554 pd=1.16 as=0.7104 ps=3.4 w=0.74 l=0.15
X3 VPWR A3 a_354_392# VPB sky130_fd_pr__pfet_01v8 ad=0.21 pd=1.42 as=0.15 ps=1.3 w=1 l=0.15
X4 a_354_392# A2 VPWR VPB sky130_fd_pr__pfet_01v8 ad=0.15 pd=1.3 as=0.215 ps=1.43 w=1 l=0.15
X5 a_354_392# A4 VPWR VPB sky130_fd_pr__pfet_01v8 ad=0.295 pd=2.59 as=0.21 ps=1.42 w=1 l=0.15
X6 a_657_74# A3 a_543_74# VNB sky130_fd_pr__nfet_01v8_lvt ad=0.1554 pd=1.16 as=0.1554 ps=1.16 w=0.74 l=0.15
X7 a_83_244# B1 VGND VNB sky130_fd_pr__nfet_01v8_lvt ad=0.1036 pd=1.02 as=0.1554 ps=1.16 w=0.74 l=0.15
X8 a_543_74# A2 a_449_74# VNB sky130_fd_pr__nfet_01v8_lvt ad=0.1554 pd=1.16 as=0.1184 ps=1.06 w=0.74 l=0.15
X9 a_449_74# A1 a_83_244# VNB sky130_fd_pr__nfet_01v8_lvt ad=0.1184 pd=1.06 as=0.1036 ps=1.02 w=0.74 l=0.15
X10 VGND A4 a_657_74# VNB sky130_fd_pr__nfet_01v8_lvt ad=0.2109 pd=2.05 as=0.1554 ps=1.16 w=0.74 l=0.15
X11 VPWR A1 a_354_392# VPB sky130_fd_pr__pfet_01v8 ad=0.215 pd=1.43 as=0.175 ps=1.35 w=1 l=0.15
.ends

.subckt sky130_fd_sc_hs__nor3_2 VPWR VGND Y A B C VNB VPB
X0 a_306_368# A VPWR VPB sky130_fd_pr__pfet_01v8 ad=0.168 pd=1.42 as=0.1792 ps=1.44 w=1.12 l=0.15
X1 Y C a_27_368# VPB sky130_fd_pr__pfet_01v8 ad=0.196 pd=1.47 as=0.3304 ps=2.83 w=1.12 l=0.15
X2 VGND C Y VNB sky130_fd_pr__nfet_01v8_lvt ad=0.32745 pd=1.625 as=0.2109 ps=2.05 w=0.74 l=0.15
X3 a_306_368# B a_27_368# VPB sky130_fd_pr__pfet_01v8 ad=0.1848 pd=1.45 as=0.168 ps=1.42 w=1.12 l=0.15
X4 VPWR A a_306_368# VPB sky130_fd_pr__pfet_01v8 ad=0.1792 pd=1.44 as=0.1848 ps=1.45 w=1.12 l=0.15
X5 a_27_368# C Y VPB sky130_fd_pr__pfet_01v8 ad=0.168 pd=1.42 as=0.196 ps=1.47 w=1.12 l=0.15
X6 VGND A Y VNB sky130_fd_pr__nfet_01v8_lvt ad=0.2627 pd=2.19 as=0.1295 ps=1.09 w=0.74 l=0.15
X7 Y B VGND VNB sky130_fd_pr__nfet_01v8_lvt ad=0.1295 pd=1.09 as=0.32745 ps=1.625 w=0.74 l=0.15
X8 a_27_368# B a_306_368# VPB sky130_fd_pr__pfet_01v8 ad=0.3304 pd=2.83 as=0.168 ps=1.42 w=1.12 l=0.15
.ends

.subckt sky130_fd_sc_hs__o211a_2 VPWR VGND A2 C1 A1 B1 X VNB VPB
X0 VGND A2 a_195_74# VNB sky130_fd_pr__nfet_01v8_lvt ad=0.1751 pd=1.33 as=0.1332 ps=1.1 w=0.74 l=0.15
X1 VPWR a_27_368# X VPB sky130_fd_pr__pfet_01v8 ad=0.3864 pd=2.93 as=0.168 ps=1.42 w=1.12 l=0.15
X2 a_117_74# C1 a_27_368# VNB sky130_fd_pr__nfet_01v8_lvt ad=0.0888 pd=0.98 as=0.2109 ps=2.05 w=0.74 l=0.15
X3 X a_27_368# VPWR VPB sky130_fd_pr__pfet_01v8 ad=0.168 pd=1.42 as=0.3759 ps=1.84 w=1.12 l=0.15
X4 VPWR A1 a_314_368# VPB sky130_fd_pr__pfet_01v8 ad=0.3759 pd=1.84 as=0.16 ps=1.32 w=1 l=0.15
X5 a_195_74# B1 a_117_74# VNB sky130_fd_pr__nfet_01v8_lvt ad=0.1332 pd=1.1 as=0.0888 ps=0.98 w=0.74 l=0.15
X6 a_27_368# B1 VPWR VPB sky130_fd_pr__pfet_01v8 ad=0.155 pd=1.31 as=0.195 ps=1.39 w=1 l=0.15
X7 X a_27_368# VGND VNB sky130_fd_pr__nfet_01v8_lvt ad=0.1036 pd=1.02 as=0.1998 ps=2.02 w=0.74 l=0.15
X8 VPWR C1 a_27_368# VPB sky130_fd_pr__pfet_01v8 ad=0.195 pd=1.39 as=0.285 ps=2.57 w=1 l=0.15
X9 a_314_368# A2 a_27_368# VPB sky130_fd_pr__pfet_01v8 ad=0.16 pd=1.32 as=0.155 ps=1.31 w=1 l=0.15
X10 VGND a_27_368# X VNB sky130_fd_pr__nfet_01v8_lvt ad=0.1998 pd=2.02 as=0.1036 ps=1.02 w=0.74 l=0.15
X11 a_195_74# A1 VGND VNB sky130_fd_pr__nfet_01v8_lvt ad=0.1998 pd=2.02 as=0.1751 ps=1.33 w=0.74 l=0.15
.ends

.subckt sky130_fd_sc_hs__a21o_1 VPWR VGND X A1 B1 A2 VNB VPB
X0 a_81_264# B1 VGND VNB sky130_fd_pr__nfet_01v8_lvt ad=0.0896 pd=0.92 as=0.14225 ps=1.14 w=0.64 l=0.15
X1 VGND A2 a_452_136# VNB sky130_fd_pr__nfet_01v8_lvt ad=0.1696 pd=1.81 as=0.104 ps=0.965 w=0.64 l=0.15
X2 VGND a_81_264# X VNB sky130_fd_pr__nfet_01v8_lvt ad=0.14225 pd=1.14 as=0.1961 ps=2.01 w=0.74 l=0.15
X3 a_452_136# A1 a_81_264# VNB sky130_fd_pr__nfet_01v8_lvt ad=0.104 pd=0.965 as=0.0896 ps=0.92 w=0.64 l=0.15
X4 VPWR a_81_264# X VPB sky130_fd_pr__pfet_01v8 ad=0.308 pd=2.79 as=0.308 ps=2.79 w=1.12 l=0.15
X5 VPWR A1 a_364_392# VPB sky130_fd_pr__pfet_01v8 ad=0.165 pd=1.33 as=0.15 ps=1.3 w=1 l=0.15
X6 a_364_392# A2 VPWR VPB sky130_fd_pr__pfet_01v8 ad=0.275 pd=2.55 as=0.165 ps=1.33 w=1 l=0.15
X7 a_364_392# B1 a_81_264# VPB sky130_fd_pr__pfet_01v8 ad=0.15 pd=1.3 as=0.275 ps=2.55 w=1 l=0.15
.ends

.subckt sky130_fd_sc_hs__a311o_1 VPWR VGND X C1 B1 A3 A2 A1 VNB VPB
X0 a_258_392# A3 VPWR VPB sky130_fd_pr__pfet_01v8 ad=0.15 pd=1.3 as=0.2809 ps=1.65 w=1 l=0.15
X1 a_546_392# B1 a_258_392# VPB sky130_fd_pr__pfet_01v8 ad=0.12 pd=1.24 as=0.15 ps=1.3 w=1 l=0.15
X2 VGND B1 a_89_270# VNB sky130_fd_pr__nfet_01v8_lvt ad=0.136 pd=1.065 as=0.0896 ps=0.92 w=0.64 l=0.15
X3 VPWR a_89_270# X VPB sky130_fd_pr__pfet_01v8 ad=0.2809 pd=1.65 as=0.308 ps=2.79 w=1.12 l=0.15
X4 a_258_392# A1 VPWR VPB sky130_fd_pr__pfet_01v8 ad=0.15 pd=1.3 as=0.195 ps=1.39 w=1 l=0.15
X5 a_359_123# A2 a_264_120# VNB sky130_fd_pr__nfet_01v8_lvt ad=0.1024 pd=0.96 as=0.1053 ps=0.98 w=0.64 l=0.15
X6 a_264_120# A3 VGND VNB sky130_fd_pr__nfet_01v8_lvt ad=0.1053 pd=0.98 as=0.12845 ps=1.1 w=0.64 l=0.15
X7 a_89_270# C1 VGND VNB sky130_fd_pr__nfet_01v8_lvt ad=0.1696 pd=1.81 as=0.136 ps=1.065 w=0.64 l=0.15
X8 a_89_270# C1 a_546_392# VPB sky130_fd_pr__pfet_01v8 ad=0.275 pd=2.55 as=0.12 ps=1.24 w=1 l=0.15
X9 a_89_270# A1 a_359_123# VNB sky130_fd_pr__nfet_01v8_lvt ad=0.0896 pd=0.92 as=0.1024 ps=0.96 w=0.64 l=0.15
X10 VGND a_89_270# X VNB sky130_fd_pr__nfet_01v8_lvt ad=0.12845 pd=1.1 as=0.1961 ps=2.01 w=0.74 l=0.15
X11 VPWR A2 a_258_392# VPB sky130_fd_pr__pfet_01v8 ad=0.195 pd=1.39 as=0.15 ps=1.3 w=1 l=0.15
.ends

.subckt sky130_fd_sc_hs__dfstp_1 SET_B VPWR VGND Q D CLK VNB VPB
X0 a_1298_392# a_224_350# a_1197_341# VPB sky130_fd_pr__pfet_01v8 ad=0.21665 pd=1.645 as=0.1998 ps=1.61 w=1 l=0.15
X1 VGND a_760_395# a_740_74# VNB sky130_fd_pr__nfet_01v8_lvt ad=0.1449 pd=1.53 as=0.0504 ps=0.66 w=0.42 l=0.15
X2 VGND SET_B a_1027_118# VNB sky130_fd_pr__nfet_01v8_lvt ad=0.12165 pd=1.07 as=0.0441 ps=0.63 w=0.42 l=0.15
X3 a_1215_74# a_604_74# VGND VNB sky130_fd_pr__nfet_01v8_lvt ad=0.12 pd=1.015 as=0.12165 ps=1.07 w=0.64 l=0.15
X4 a_740_74# a_398_74# a_604_74# VNB sky130_fd_pr__nfet_01v8_lvt ad=0.0504 pd=0.66 as=0.1113 ps=0.95 w=0.42 l=0.15
X5 a_1027_118# a_604_74# a_760_395# VNB sky130_fd_pr__nfet_01v8_lvt ad=0.0441 pd=0.63 as=0.1176 ps=1.4 w=0.42 l=0.15
X6 a_1298_392# a_398_74# a_1215_74# VNB sky130_fd_pr__nfet_01v8_lvt ad=0.10695 pd=1 as=0.12 ps=1.015 w=0.64 l=0.15
X7 VGND SET_B a_1500_74# VNB sky130_fd_pr__nfet_01v8_lvt ad=0.19215 pd=1.335 as=0.0504 ps=0.66 w=0.42 l=0.15
X8 VGND D a_27_74# VNB sky130_fd_pr__nfet_01v8_lvt ad=0.1197 pd=1.41 as=0.1197 ps=1.41 w=0.42 l=0.15
X9 a_1500_74# a_1470_48# a_1422_74# VNB sky130_fd_pr__nfet_01v8_lvt ad=0.0504 pd=0.66 as=0.0504 ps=0.66 w=0.42 l=0.15
X10 a_1470_48# a_1298_392# VGND VNB sky130_fd_pr__nfet_01v8_lvt ad=0.1197 pd=1.41 as=0.19215 ps=1.335 w=0.42 l=0.15
X11 a_1298_392# SET_B VPWR VPB sky130_fd_pr__pfet_01v8 ad=0.1155 pd=1.39 as=0.063 ps=0.72 w=0.42 l=0.15
X12 VGND a_1298_392# a_1902_74# VNB sky130_fd_pr__nfet_01v8_lvt ad=0.15198 pd=1.17 as=0.15675 ps=1.67 w=0.55 l=0.15
X13 VPWR a_1470_48# a_1457_508# VPB sky130_fd_pr__pfet_01v8 ad=0.063 pd=0.72 as=0.0567 ps=0.69 w=0.42 l=0.15
X14 a_1197_341# a_604_74# VPWR VPB sky130_fd_pr__pfet_01v8 ad=0.1998 pd=1.61 as=0.23615 ps=1.86 w=1 l=0.15
X15 a_1457_508# a_398_74# a_1298_392# VPB sky130_fd_pr__pfet_01v8 ad=0.0567 pd=0.69 as=0.21665 ps=1.645 w=0.42 l=0.15
X16 VPWR a_760_395# a_709_463# VPB sky130_fd_pr__pfet_01v8 ad=0.14175 pd=1.095 as=0.0567 ps=0.69 w=0.42 l=0.15
X17 VGND CLK a_224_350# VNB sky130_fd_pr__nfet_01v8_lvt ad=0.1036 pd=1.02 as=0.2109 ps=2.05 w=0.74 l=0.15
X18 a_604_74# a_224_350# a_27_74# VNB sky130_fd_pr__nfet_01v8_lvt ad=0.1113 pd=0.95 as=0.17595 ps=1.76 w=0.42 l=0.15
X19 VPWR a_1298_392# a_1902_74# VPB sky130_fd_pr__pfet_01v8 ad=0.1946 pd=1.49 as=0.231 ps=2.23 w=0.84 l=0.15
X20 a_1470_48# a_1298_392# VPWR VPB sky130_fd_pr__pfet_01v8 ad=0.1155 pd=1.39 as=0.1176 ps=1.4 w=0.42 l=0.15
X21 a_709_463# a_224_350# a_604_74# VPB sky130_fd_pr__pfet_01v8 ad=0.0567 pd=0.69 as=0.0735 ps=0.77 w=0.42 l=0.15
X22 a_398_74# a_224_350# VPWR VPB sky130_fd_pr__pfet_01v8 ad=0.3304 pd=2.83 as=0.168 ps=1.42 w=1.12 l=0.15
X23 a_398_74# a_224_350# VGND VNB sky130_fd_pr__nfet_01v8_lvt ad=0.1961 pd=2.01 as=0.1036 ps=1.02 w=0.74 l=0.15
X24 VPWR CLK a_224_350# VPB sky130_fd_pr__pfet_01v8 ad=0.168 pd=1.42 as=0.3192 ps=2.81 w=1.12 l=0.15
X25 a_1422_74# a_224_350# a_1298_392# VNB sky130_fd_pr__nfet_01v8_lvt ad=0.0504 pd=0.66 as=0.10695 ps=1 w=0.42 l=0.15
X26 Q a_1902_74# VGND VNB sky130_fd_pr__nfet_01v8_lvt ad=0.2109 pd=2.05 as=0.15198 ps=1.17 w=0.74 l=0.15
X27 a_760_395# a_604_74# VPWR VPB sky130_fd_pr__pfet_01v8 ad=0.063 pd=0.72 as=0.14175 ps=1.095 w=0.42 l=0.15
X28 VPWR D a_27_74# VPB sky130_fd_pr__pfet_01v8 ad=0.1176 pd=1.4 as=0.1197 ps=1.41 w=0.42 l=0.15
X29 VPWR SET_B a_760_395# VPB sky130_fd_pr__pfet_01v8 ad=0.23615 pd=1.86 as=0.063 ps=0.72 w=0.42 l=0.15
X30 Q a_1902_74# VPWR VPB sky130_fd_pr__pfet_01v8 ad=0.3192 pd=2.81 as=0.1946 ps=1.49 w=1.12 l=0.15
X31 a_604_74# a_398_74# a_27_74# VPB sky130_fd_pr__pfet_01v8 ad=0.0735 pd=0.77 as=0.1239 ps=1.43 w=0.42 l=0.15
.ends

.subckt sky130_fd_sc_hs__nand4b_1 VPWR VGND A_N D Y C B VNB VPB
X0 a_341_74# C a_263_74# VNB sky130_fd_pr__nfet_01v8_lvt ad=0.1332 pd=1.1 as=0.0888 ps=0.98 w=0.74 l=0.15
X1 VPWR C Y VPB sky130_fd_pr__pfet_01v8 ad=0.2352 pd=1.54 as=0.168 ps=1.42 w=1.12 l=0.15
X2 Y D VPWR VPB sky130_fd_pr__pfet_01v8 ad=0.168 pd=1.42 as=0.231 ps=1.555 w=1.12 l=0.15
X3 VPWR a_27_112# Y VPB sky130_fd_pr__pfet_01v8 ad=0.3864 pd=2.93 as=0.168 ps=1.42 w=1.12 l=0.15
X4 Y B VPWR VPB sky130_fd_pr__pfet_01v8 ad=0.168 pd=1.42 as=0.2352 ps=1.54 w=1.12 l=0.15
X5 VPWR A_N a_27_112# VPB sky130_fd_pr__pfet_01v8 ad=0.231 pd=1.555 as=0.2478 ps=2.27 w=0.84 l=0.15
X6 a_263_74# D VGND VNB sky130_fd_pr__nfet_01v8_lvt ad=0.0888 pd=0.98 as=0.1348 ps=1.13 w=0.74 l=0.15
X7 a_443_74# B a_341_74# VNB sky130_fd_pr__nfet_01v8_lvt ad=0.1443 pd=1.13 as=0.1332 ps=1.1 w=0.74 l=0.15
X8 Y a_27_112# a_443_74# VNB sky130_fd_pr__nfet_01v8_lvt ad=0.3404 pd=2.4 as=0.1443 ps=1.13 w=0.74 l=0.15
X9 VGND A_N a_27_112# VNB sky130_fd_pr__nfet_01v8_lvt ad=0.1348 pd=1.13 as=0.2695 ps=2.08 w=0.55 l=0.15
.ends

.subckt sky130_fd_sc_hs__nand4bb_1 VPWR VGND B_N A_N D Y C VNB VPB
X0 a_513_74# a_226_398# a_435_74# VNB sky130_fd_pr__nfet_01v8_lvt ad=0.1554 pd=1.16 as=0.0888 ps=0.98 w=0.74 l=0.15
X1 VGND D a_627_74# VNB sky130_fd_pr__nfet_01v8_lvt ad=0.266 pd=2.34 as=0.1554 ps=1.16 w=0.74 l=0.15
X2 VPWR A_N a_27_398# VPB sky130_fd_pr__pfet_01v8 ad=0.168 pd=1.24 as=0.2478 ps=2.27 w=0.84 l=0.15
X3 Y D VPWR VPB sky130_fd_pr__pfet_01v8 ad=0.3304 pd=2.83 as=0.224 ps=1.52 w=1.12 l=0.15
X4 a_226_398# B_N VPWR VPB sky130_fd_pr__pfet_01v8 ad=0.2478 pd=2.27 as=0.168 ps=1.24 w=0.84 l=0.15
X5 a_435_74# a_27_398# Y VNB sky130_fd_pr__nfet_01v8_lvt ad=0.0888 pd=0.98 as=0.19585 ps=2.05 w=0.74 l=0.15
X6 VGND A_N a_27_398# VNB sky130_fd_pr__nfet_01v8_lvt ad=0.12218 pd=1.025 as=0.15098 ps=1.67 w=0.55 l=0.15
X7 VPWR C Y VPB sky130_fd_pr__pfet_01v8 ad=0.224 pd=1.52 as=0.196 ps=1.47 w=1.12 l=0.15
X8 a_627_74# C a_513_74# VNB sky130_fd_pr__nfet_01v8_lvt ad=0.1554 pd=1.16 as=0.1554 ps=1.16 w=0.74 l=0.15
X9 VPWR a_27_398# Y VPB sky130_fd_pr__pfet_01v8 ad=0.2464 pd=1.56 as=0.3304 ps=2.83 w=1.12 l=0.15
X10 a_226_398# B_N VGND VNB sky130_fd_pr__nfet_01v8_lvt ad=0.15055 pd=1.69 as=0.12218 ps=1.025 w=0.55 l=0.15
X11 Y a_226_398# VPWR VPB sky130_fd_pr__pfet_01v8 ad=0.196 pd=1.47 as=0.2464 ps=1.56 w=1.12 l=0.15
.ends

.subckt sky130_fd_sc_hs__buf_4 VPWR VGND A X VNB VPB
X0 a_86_260# A VPWR VPB sky130_fd_pr__pfet_01v8 ad=0.126 pd=1.14 as=0.203 ps=1.505 w=0.84 l=0.15
X1 VPWR a_86_260# X VPB sky130_fd_pr__pfet_01v8 ad=0.203 pd=1.505 as=0.168 ps=1.42 w=1.12 l=0.15
X2 a_86_260# A VGND VNB sky130_fd_pr__nfet_01v8_lvt ad=0.2109 pd=2.05 as=0.2664 ps=1.46 w=0.74 l=0.15
X3 X a_86_260# VPWR VPB sky130_fd_pr__pfet_01v8 ad=0.168 pd=1.42 as=0.168 ps=1.42 w=1.12 l=0.15
X4 VPWR a_86_260# X VPB sky130_fd_pr__pfet_01v8 ad=0.168 pd=1.42 as=0.168 ps=1.42 w=1.12 l=0.15
X5 VGND a_86_260# X VNB sky130_fd_pr__nfet_01v8_lvt ad=0.2664 pd=1.46 as=0.1036 ps=1.02 w=0.74 l=0.15
X6 X a_86_260# VGND VNB sky130_fd_pr__nfet_01v8_lvt ad=0.1036 pd=1.02 as=0.2627 ps=2.19 w=0.74 l=0.15
X7 X a_86_260# VGND VNB sky130_fd_pr__nfet_01v8_lvt ad=0.1036 pd=1.02 as=0.1554 ps=1.16 w=0.74 l=0.15
X8 X a_86_260# VPWR VPB sky130_fd_pr__pfet_01v8 ad=0.168 pd=1.42 as=0.3304 ps=2.83 w=1.12 l=0.15
X9 VGND a_86_260# X VNB sky130_fd_pr__nfet_01v8_lvt ad=0.1554 pd=1.16 as=0.1036 ps=1.02 w=0.74 l=0.15
X10 VPWR A a_86_260# VPB sky130_fd_pr__pfet_01v8 ad=0.2478 pd=2.27 as=0.126 ps=1.14 w=0.84 l=0.15
.ends

.subckt sky130_fd_sc_hs__and3b_1 VPWR VGND X A_N C B VNB VPB
X0 X a_266_94# VGND VNB sky130_fd_pr__nfet_01v8_lvt ad=0.2109 pd=2.05 as=0.19855 ps=1.305 w=0.74 l=0.15
X1 a_431_94# B a_353_94# VNB sky130_fd_pr__nfet_01v8_lvt ad=0.1248 pd=1.03 as=0.0768 ps=0.88 w=0.64 l=0.15
X2 VPWR a_114_74# a_266_94# VPB sky130_fd_pr__pfet_01v8 ad=0.1659 pd=1.235 as=0.2478 ps=2.27 w=0.84 l=0.15
X3 X a_266_94# VPWR VPB sky130_fd_pr__pfet_01v8 ad=0.3304 pd=2.83 as=0.231 ps=1.555 w=1.12 l=0.15
X4 a_114_74# A_N VGND VNB sky130_fd_pr__nfet_01v8_lvt ad=0.19525 pd=1.81 as=0.15675 ps=1.67 w=0.55 l=0.15
X5 a_266_94# B VPWR VPB sky130_fd_pr__pfet_01v8 ad=0.1281 pd=1.145 as=0.1659 ps=1.235 w=0.84 l=0.15
X6 VGND C a_431_94# VNB sky130_fd_pr__nfet_01v8_lvt ad=0.19855 pd=1.305 as=0.1248 ps=1.03 w=0.64 l=0.15
X7 VPWR C a_266_94# VPB sky130_fd_pr__pfet_01v8 ad=0.231 pd=1.555 as=0.1281 ps=1.145 w=0.84 l=0.15
X8 a_353_94# a_114_74# a_266_94# VNB sky130_fd_pr__nfet_01v8_lvt ad=0.0768 pd=0.88 as=0.1824 ps=1.85 w=0.64 l=0.15
X9 a_114_74# A_N VPWR VPB sky130_fd_pr__pfet_01v8 ad=0.2856 pd=2.36 as=0.252 ps=2.28 w=0.84 l=0.15
.ends

.subckt sky130_fd_sc_hs__nand2b_2 VPWR VGND B Y A_N VNB VPB
X0 Y B VPWR VPB sky130_fd_pr__pfet_01v8 ad=0.168 pd=1.42 as=0.168 ps=1.42 w=1.12 l=0.15
X1 VPWR A_N a_27_74# VPB sky130_fd_pr__pfet_01v8 ad=0.4613 pd=1.97 as=0.295 ps=2.59 w=1 l=0.15
X2 VPWR a_27_74# Y VPB sky130_fd_pr__pfet_01v8 ad=0.168 pd=1.42 as=0.168 ps=1.42 w=1.12 l=0.15
X3 Y a_27_74# VPWR VPB sky130_fd_pr__pfet_01v8 ad=0.168 pd=1.42 as=0.4613 ps=1.97 w=1.12 l=0.15
X4 a_242_74# B VGND VNB sky130_fd_pr__nfet_01v8_lvt ad=0.2109 pd=2.05 as=0.10545 ps=1.025 w=0.74 l=0.15
X5 a_242_74# a_27_74# Y VNB sky130_fd_pr__nfet_01v8_lvt ad=0.1036 pd=1.02 as=0.1036 ps=1.02 w=0.74 l=0.15
X6 VGND A_N a_27_74# VNB sky130_fd_pr__nfet_01v8_lvt ad=0.16675 pd=1.81 as=0.1824 ps=1.85 w=0.64 l=0.15
X7 Y a_27_74# a_242_74# VNB sky130_fd_pr__nfet_01v8_lvt ad=0.1036 pd=1.02 as=0.20635 ps=2.05 w=0.74 l=0.15
X8 VGND B a_242_74# VNB sky130_fd_pr__nfet_01v8_lvt ad=0.10545 pd=1.025 as=0.1036 ps=1.02 w=0.74 l=0.15
X9 VPWR B Y VPB sky130_fd_pr__pfet_01v8 ad=0.3304 pd=2.83 as=0.168 ps=1.42 w=1.12 l=0.15
.ends

.subckt sky130_fd_sc_hs__nor4b_1 VPWR VGND Y D_N A B C VNB VPB
X0 Y C VGND VNB sky130_fd_pr__nfet_01v8_lvt ad=0.1036 pd=1.02 as=0.1591 ps=1.17 w=0.74 l=0.15
X1 VPWR D_N a_57_368# VPB sky130_fd_pr__pfet_01v8 ad=0.2177 pd=1.54 as=0.2478 ps=2.27 w=0.84 l=0.15
X2 a_344_368# B a_260_368# VPB sky130_fd_pr__pfet_01v8 ad=0.2016 pd=1.48 as=0.1512 ps=1.39 w=1.12 l=0.15
X3 a_446_368# C a_344_368# VPB sky130_fd_pr__pfet_01v8 ad=0.2352 pd=1.54 as=0.2016 ps=1.48 w=1.12 l=0.15
X4 a_260_368# A VPWR VPB sky130_fd_pr__pfet_01v8 ad=0.1512 pd=1.39 as=0.2177 ps=1.54 w=1.12 l=0.15
X5 VGND D_N a_57_368# VNB sky130_fd_pr__nfet_01v8_lvt ad=0.13925 pd=1.16 as=0.15675 ps=1.67 w=0.55 l=0.15
X6 Y a_57_368# a_446_368# VPB sky130_fd_pr__pfet_01v8 ad=0.4648 pd=3.07 as=0.2352 ps=1.54 w=1.12 l=0.15
X7 Y A VGND VNB sky130_fd_pr__nfet_01v8_lvt ad=0.1036 pd=1.02 as=0.13925 ps=1.16 w=0.74 l=0.15
X8 VGND a_57_368# Y VNB sky130_fd_pr__nfet_01v8_lvt ad=0.2627 pd=2.19 as=0.1036 ps=1.02 w=0.74 l=0.15
X9 VGND B Y VNB sky130_fd_pr__nfet_01v8_lvt ad=0.1591 pd=1.17 as=0.1036 ps=1.02 w=0.74 l=0.15
.ends

.subckt sky130_fd_sc_hs__nand2_2 VPWR VGND Y B A VNB VPB
X0 VPWR A Y VPB sky130_fd_pr__pfet_01v8 ad=0.3304 pd=2.83 as=0.168 ps=1.42 w=1.12 l=0.15
X1 Y A a_27_74# VNB sky130_fd_pr__nfet_01v8_lvt ad=0.1221 pd=1.07 as=0.1036 ps=1.02 w=0.74 l=0.15
X2 Y A VPWR VPB sky130_fd_pr__pfet_01v8 ad=0.168 pd=1.42 as=0.1736 ps=1.43 w=1.12 l=0.15
X3 Y B VPWR VPB sky130_fd_pr__pfet_01v8 ad=0.168 pd=1.42 as=0.3304 ps=2.83 w=1.12 l=0.15
X4 VGND B a_27_74# VNB sky130_fd_pr__nfet_01v8_lvt ad=0.1221 pd=1.07 as=0.2109 ps=2.05 w=0.74 l=0.15
X5 VPWR B Y VPB sky130_fd_pr__pfet_01v8 ad=0.1736 pd=1.43 as=0.168 ps=1.42 w=1.12 l=0.15
X6 a_27_74# B VGND VNB sky130_fd_pr__nfet_01v8_lvt ad=0.1036 pd=1.02 as=0.1221 ps=1.07 w=0.74 l=0.15
X7 a_27_74# A Y VNB sky130_fd_pr__nfet_01v8_lvt ad=0.2257 pd=2.09 as=0.1221 ps=1.07 w=0.74 l=0.15
.ends

.subckt sky130_fd_sc_hs__buf_2 VPWR VGND A X VNB VPB
X0 a_21_260# A VPWR VPB sky130_fd_pr__pfet_01v8 ad=0.32 pd=2.64 as=0.2102 ps=1.505 w=1 l=0.15
X1 VGND a_21_260# X VNB sky130_fd_pr__nfet_01v8_lvt ad=0.15535 pd=1.17 as=0.1036 ps=1.02 w=0.74 l=0.15
X2 VPWR a_21_260# X VPB sky130_fd_pr__pfet_01v8 ad=0.2102 pd=1.505 as=0.168 ps=1.42 w=1.12 l=0.15
X3 X a_21_260# VPWR VPB sky130_fd_pr__pfet_01v8 ad=0.168 pd=1.42 as=0.756 ps=3.59 w=1.12 l=0.15
X4 a_21_260# A VGND VNB sky130_fd_pr__nfet_01v8_lvt ad=0.1824 pd=1.85 as=0.15535 ps=1.17 w=0.64 l=0.15
X5 X a_21_260# VGND VNB sky130_fd_pr__nfet_01v8_lvt ad=0.1036 pd=1.02 as=0.2109 ps=2.05 w=0.74 l=0.15
.ends

.subckt sky130_fd_sc_hs__nor2_4 VPWR VGND Y A B VNB VPB
X0 VPWR A a_27_368# VPB sky130_fd_pr__pfet_01v8 ad=0.168 pd=1.42 as=0.3304 ps=2.83 w=1.12 l=0.15
X1 Y A VGND VNB sky130_fd_pr__nfet_01v8_lvt ad=0.4218 pd=1.88 as=0.2294 ps=2.1 w=0.74 l=0.15
X2 Y B a_27_368# VPB sky130_fd_pr__pfet_01v8 ad=0.196 pd=1.47 as=0.196 ps=1.47 w=1.12 l=0.15
X3 Y B VGND VNB sky130_fd_pr__nfet_01v8_lvt ad=0.111 pd=1.04 as=0.1221 ps=1.07 w=0.74 l=0.15
X4 a_27_368# B Y VPB sky130_fd_pr__pfet_01v8 ad=0.196 pd=1.47 as=0.168 ps=1.42 w=1.12 l=0.15
X5 VGND A Y VNB sky130_fd_pr__nfet_01v8_lvt ad=0.1221 pd=1.07 as=0.4218 ps=1.88 w=0.74 l=0.15
X6 Y B a_27_368# VPB sky130_fd_pr__pfet_01v8 ad=0.168 pd=1.42 as=0.168 ps=1.42 w=1.12 l=0.15
X7 a_27_368# A VPWR VPB sky130_fd_pr__pfet_01v8 ad=0.168 pd=1.42 as=0.168 ps=1.42 w=1.12 l=0.15
X8 VPWR A a_27_368# VPB sky130_fd_pr__pfet_01v8 ad=0.168 pd=1.42 as=0.168 ps=1.42 w=1.12 l=0.15
X9 a_27_368# A VPWR VPB sky130_fd_pr__pfet_01v8 ad=0.168 pd=1.42 as=0.168 ps=1.42 w=1.12 l=0.15
X10 a_27_368# B Y VPB sky130_fd_pr__pfet_01v8 ad=0.3976 pd=2.95 as=0.196 ps=1.47 w=1.12 l=0.15
X11 VGND B Y VNB sky130_fd_pr__nfet_01v8_lvt ad=1.0138 pd=4.22 as=0.111 ps=1.04 w=0.74 l=0.15
.ends

.subckt sky130_fd_sc_hs__nor4_1 VPWR VGND Y D C B A VNB VPB
X0 Y D a_342_368# VPB sky130_fd_pr__pfet_01v8 ad=0.3304 pd=2.83 as=0.2352 ps=1.54 w=1.12 l=0.15
X1 VGND B Y VNB sky130_fd_pr__nfet_01v8_lvt ad=0.1924 pd=1.26 as=0.1036 ps=1.02 w=0.74 l=0.15
X2 Y C VGND VNB sky130_fd_pr__nfet_01v8_lvt ad=0.1036 pd=1.02 as=0.1924 ps=1.26 w=0.74 l=0.15
X3 Y A VGND VNB sky130_fd_pr__nfet_01v8_lvt ad=0.1036 pd=1.02 as=0.2627 ps=2.19 w=0.74 l=0.15
X4 a_228_368# B a_144_368# VPB sky130_fd_pr__pfet_01v8 ad=0.2352 pd=1.54 as=0.1512 ps=1.39 w=1.12 l=0.15
X5 a_144_368# A VPWR VPB sky130_fd_pr__pfet_01v8 ad=0.1512 pd=1.39 as=0.3304 ps=2.83 w=1.12 l=0.15
X6 a_342_368# C a_228_368# VPB sky130_fd_pr__pfet_01v8 ad=0.2352 pd=1.54 as=0.2352 ps=1.54 w=1.12 l=0.15
X7 VGND D Y VNB sky130_fd_pr__nfet_01v8_lvt ad=0.23225 pd=2.19 as=0.1036 ps=1.02 w=0.74 l=0.15
.ends

.subckt sky130_fd_sc_hs__xor3_1 VPWR VGND B C A X VNB VPB
X0 a_84_108# A VGND VNB sky130_fd_pr__nfet_01v8_lvt ad=0.1702 pd=1.41 as=0.34745 ps=1.81 w=0.64 l=0.15
X1 X a_1215_396# VPWR VPB sky130_fd_pr__pfet_01v8 ad=0.3304 pd=2.83 as=0.2436 ps=1.66 w=1.12 l=0.15
X2 a_27_134# a_452_288# a_384_392# VPB sky130_fd_pr__pfet_01v8 ad=0.1024 pd=0.96 as=0.1401 ps=1.195 w=0.64 l=0.15
X3 a_84_108# a_452_288# a_384_392# VNB sky130_fd_pr__nfet_01v8_lvt ad=0.2848 pd=2.17 as=0.16907 ps=1.275 w=0.64 l=0.15
X4 X a_1215_396# VGND VNB sky130_fd_pr__nfet_01v8_lvt ad=0.2109 pd=2.05 as=0.1212 ps=1.1 w=0.74 l=0.15
X5 a_384_392# B a_84_108# VPB sky130_fd_pr__pfet_01v8 ad=0.1401 pd=1.195 as=0.1837 ps=1.385 w=0.84 l=0.15
X6 a_84_108# A VPWR VPB sky130_fd_pr__pfet_01v8 ad=0.1837 pd=1.385 as=0.25 ps=1.5 w=1 l=0.15
X7 VPWR a_84_108# a_27_134# VPB sky130_fd_pr__pfet_01v8 ad=0.25 pd=1.5 as=0.295 ps=2.59 w=1 l=0.15
X8 a_27_134# a_452_288# a_416_86# VNB sky130_fd_pr__nfet_01v8_lvt ad=0.15815 pd=1.16 as=0.10375 ps=0.99 w=0.42 l=0.15
X9 VPWR C a_1157_298# VPB sky130_fd_pr__pfet_01v8 ad=0.2436 pd=1.66 as=0.2528 ps=2.07 w=0.64 l=0.15
X10 a_416_86# C a_1215_396# VNB sky130_fd_pr__nfet_01v8_lvt ad=0.24 pd=2.03 as=0.1696 ps=1.17 w=0.64 l=0.15
X11 a_384_392# C a_1215_396# VPB sky130_fd_pr__pfet_01v8 ad=0.2982 pd=2.39 as=0.2541 ps=1.445 w=0.84 l=0.15
X12 a_416_86# B a_84_108# VNB sky130_fd_pr__nfet_01v8_lvt ad=0.10375 pd=0.99 as=0.1702 ps=1.41 w=0.64 l=0.15
X13 a_1215_396# a_1157_298# a_384_392# VNB sky130_fd_pr__nfet_01v8_lvt ad=0.1696 pd=1.17 as=0.176 ps=1.83 w=0.64 l=0.15
X14 VGND B a_452_288# VNB sky130_fd_pr__nfet_01v8_lvt ad=0.3885 pd=2.53 as=0.2035 ps=2.03 w=0.74 l=0.15
X15 a_84_108# a_452_288# a_416_86# VPB sky130_fd_pr__pfet_01v8 ad=0.5082 pd=2.89 as=0.15067 ps=1.225 w=0.84 l=0.15
X16 a_1215_396# a_1157_298# a_416_86# VPB sky130_fd_pr__pfet_01v8 ad=0.2541 pd=1.445 as=0.3192 ps=2.44 w=0.84 l=0.15
X17 a_416_86# B a_27_134# VPB sky130_fd_pr__pfet_01v8 ad=0.15067 pd=1.225 as=0.1024 ps=0.96 w=0.64 l=0.15
X18 a_384_392# B a_27_134# VNB sky130_fd_pr__nfet_01v8_lvt ad=0.16907 pd=1.275 as=0.15815 ps=1.16 w=0.64 l=0.15
X19 VGND C a_1157_298# VNB sky130_fd_pr__nfet_01v8_lvt ad=0.1212 pd=1.1 as=0.1197 ps=1.41 w=0.42 l=0.15
X20 VGND a_84_108# a_27_134# VNB sky130_fd_pr__nfet_01v8_lvt ad=0.34745 pd=1.81 as=0.1824 ps=1.85 w=0.64 l=0.15
X21 VPWR B a_452_288# VPB sky130_fd_pr__pfet_01v8 ad=0.3304 pd=2.83 as=0.3304 ps=2.83 w=1.12 l=0.15
.ends

.subckt sar_digi_paper_core VDD VSS calib_done calib_done_pulse calib_overrange_bits[10]
+ calib_overrange_bits[11] calib_overrange_bits[14] calib_overrange_bits[15] calib_overrange_bits[16]
+ calib_overrange_bits[17] calib_overrange_bits[18] calib_overrange_bits[2] calib_overrange_bits[3]
+ calib_overrange_bits[7] raw_code_o[10] raw_code_o[11] raw_code_o[14] raw_code_o[16]
+ raw_code_o[17] raw_code_o[18] raw_code_o[3] raw_code_o[4] raw_code_o[6] raw_code_o[7]
+ w_wr_addr[0] w_wr_addr[3] w_wr_addr[4] w_wr_data[12] w_wr_data[16] w_wr_data[19]
+ w_wr_data[1] w_wr_data[21] w_wr_data[22] w_wr_data[23] w_wr_data[27] w_wr_data[28]
+ w_wr_data[29] w_wr_data[3] w_wr_data[4] w_wr_data[7] w_wr_data[8] w_wr_en raw_bits_i[18]
+ raw_bits_i[19] raw_bits_i[1] raw_bits_i[4] raw_bits_i[5] start_calib raw_bits_i[9]
+ calib_comp_out raw_bits_i[11] raw_bits_i[12] raw_bits_i[15] raw_bits_i[16] raw_bits_i[2]
+ raw_bits_i[3] raw_bits_i[14] raw_bits_i[0] raw_bits_i[6] raw_bits_i[7] rst_n raw_bits_i[8]
+ raw_bits_i[10] raw_bits_i[17] clk data_valid_i raw_bits_i[13] raw_code_o[8] raw_code_o[9]
+ raw_code_valid_o calib_overrange_bits[6] calib_overrange raw_code_o[0] w_wr_addr[1]
+ w_wr_addr[2] calib_overrange_bits[8] calib_overrange_bits[9] w_wr_data[0] w_wr_data[10]
+ w_wr_data[11] raw_code_o[12] w_wr_data[13] w_wr_data[14] w_wr_data[15] raw_code_o[13]
+ w_wr_data[17] w_wr_data[18] calib_overrange_bits[12] raw_code_o[15] w_wr_data[20]
+ calib_overrange_bits[13] calib_overrange_bits[19] calib_overrange_bits[1] w_wr_data[24]
+ w_wr_data[25] w_wr_data[26] raw_code_o[19] raw_code_o[1] raw_code_o[2] w_wr_data[2]
+ calib_overrange_bits[0] calib_mode_en w_wr_data[5] w_wr_data[6] raw_code_o[5] calib_overrange_bits[4]
+ w_wr_data[9] calib_overrange_bits[5] dac_n_force[0] dac_n_force[10] dac_n_force[11]
+ dac_n_force[12] dac_n_force[13] dac_n_force[14] dac_n_force[15] dac_n_force[16]
+ dac_n_force[17] dac_n_force[18] dac_n_force[19] dac_n_force[1] dac_n_force[2] dac_n_force[3]
+ dac_n_force[4] dac_n_force[5] dac_n_force[6] dac_n_force[7] dac_n_force[8] dac_n_force[9]
+ dac_p_force[0] dac_p_force[10] dac_p_force[11] dac_p_force[12] dac_p_force[13] dac_p_force[14]
+ dac_p_force[15] dac_p_force[16] dac_p_force[17] dac_p_force[18] dac_p_force[19]
+ dac_p_force[1] dac_p_force[2] dac_p_force[3] dac_p_force[4] dac_p_force[5] dac_p_force[6]
+ dac_p_force[7] dac_p_force[8] dac_p_force[9] dec_clk residue_consume_i srm_busy
+ srm_count_shortfall srm_decision_bit srm_decision_valid srm_done srm_ones_count[0]
+ srm_ones_count[1] srm_ones_count[2] srm_ones_count[3] srm_ones_count[4] srm_residue_o[0]
+ srm_residue_o[1] srm_residue_o[2] srm_residue_o[3] srm_residue_o[4] srm_residue_o[5]
+ srm_residue_o[6] srm_residue_o[7] srm_residue_o[8] srm_residue_o[9] srm_residue_valid
+ srm_stalled srm_start srm_total_count[0] srm_total_count[1] srm_total_count[2] srm_total_count[3]
+ srm_total_count[4]
Xsky130_fd_sc_hs__xnor2_1_110 VDD VSS sky130_fd_sc_hs__nor3_1_38/B sky130_fd_sc_hs__nor3b_1_1/B
+ sky130_fd_sc_hs__nor2b_1_36/Y VSS VDD sky130_fd_sc_hs__xnor2_1
Xsky130_fd_sc_hs__xnor2_1_121 VDD VSS sky130_fd_sc_hs__maj3_1_34/A sky130_fd_sc_hs__xnor2_1_121/Y
+ sky130_fd_sc_hs__a211oi_1_7/Y VSS VDD sky130_fd_sc_hs__xnor2_1
Xsky130_fd_sc_hs__xnor2_1_132 VDD VSS sky130_fd_sc_hs__o21ai_1_95/Y sky130_fd_sc_hs__xnor2_1_132/Y
+ sky130_fd_sc_hs__xnor2_1_132/B VSS VDD sky130_fd_sc_hs__xnor2_1
Xsky130_fd_sc_hs__xnor2_1_143 VDD VSS sky130_fd_sc_hs__maj3_1_64/B sky130_fd_sc_hs__xnor2_1_143/Y
+ sky130_fd_sc_hs__xnor2_1_143/B VSS VDD sky130_fd_sc_hs__xnor2_1
Xsky130_fd_sc_hs__mux2_1_50 VDD VSS sky130_fd_sc_hs__mux2_1_50/X sky130_fd_sc_hs__mux2_1_99/S
+ sky130_fd_sc_hs__mux2_1_61/A0 sky130_fd_sc_hs__mux2_1_50/A1 VSS VDD sky130_fd_sc_hs__mux2_1
Xsky130_fd_sc_hs__mux2_1_61 VDD VSS sky130_fd_sc_hs__mux2_1_61/X sky130_fd_sc_hs__mux2_1_6/S
+ sky130_fd_sc_hs__mux2_1_61/A0 sky130_fd_sc_hs__mux2_1_61/A1 VSS VDD sky130_fd_sc_hs__mux2_1
Xsky130_fd_sc_hs__mux2_1_72 VDD VSS sky130_fd_sc_hs__mux2_1_72/X sky130_fd_sc_hs__mux2_1_98/S
+ sky130_fd_sc_hs__a22o_1_8/A1 sky130_fd_sc_hs__mux2_1_96/A0 VSS VDD sky130_fd_sc_hs__mux2_1
Xsky130_fd_sc_hs__mux2_1_83 VDD VSS sky130_fd_sc_hs__mux2_1_83/X sky130_fd_sc_hs__mux2_1_7/S
+ sky130_fd_sc_hs__mux2_1_83/A0 sky130_fd_sc_hs__mux2_1_96/A0 VSS VDD sky130_fd_sc_hs__mux2_1
Xsky130_fd_sc_hs__mux2_1_94 VDD VSS sky130_fd_sc_hs__mux2_1_94/X sky130_fd_sc_hs__mux2_1_94/S
+ sky130_fd_sc_hs__maj3_1_2/B sky130_fd_sc_hs__mux2_1_94/A1 VSS VDD sky130_fd_sc_hs__mux2_1
Xsky130_fd_sc_hs__xnor2_1_7 VDD VSS sky130_fd_sc_hs__and3_1_0/A sky130_fd_sc_hs__xnor2_1_9/B
+ sky130_fd_sc_hs__xnor2_1_8/Y VSS VDD sky130_fd_sc_hs__xnor2_1
Xsky130_fd_sc_hs__nor2b_1_10 VDD VSS sky130_fd_sc_hs__buf_1_67/A sky130_fd_sc_hs__nor2_1_48/A
+ sky130_fd_sc_hs__and2_1_15/A VSS VDD sky130_fd_sc_hs__nor2b_1
Xsky130_fd_sc_hs__nor2b_1_21 VDD VSS sky130_fd_sc_hs__xnor2_1_77/Y sky130_fd_sc_hs__nor2_1_74/B
+ sky130_fd_sc_hs__maj3_1_29/X VSS VDD sky130_fd_sc_hs__nor2b_1
Xsky130_fd_sc_hs__nor2b_1_32 VDD VSS sky130_fd_sc_hs__o21ai_1_61/Y sky130_fd_sc_hs__o22ai_1_3/B1
+ sky130_fd_sc_hs__or2_1_30/B VSS VDD sky130_fd_sc_hs__nor2b_1
Xsky130_fd_sc_hs__nor2b_1_43 VDD VSS sky130_fd_sc_hs__xnor2_1_96/Y sky130_fd_sc_hs__nor2_1_83/B
+ sky130_fd_sc_hs__maj3_1_49/X VSS VDD sky130_fd_sc_hs__nor2b_1
Xsky130_fd_sc_hs__o22ai_1_2 VDD VSS sky130_fd_sc_hs__o22ai_1_2/B2 sky130_fd_sc_hs__nor3_1_40/Y
+ sky130_fd_sc_hs__o22ai_1_2/Y sky130_fd_sc_hs__o22ai_1_2/A2 sky130_fd_sc_hs__o22ai_1_2/A1
+ VSS VDD sky130_fd_sc_hs__o22ai_1
Xsky130_fd_sc_hs__or2_1_6 VDD VSS sky130_fd_sc_hs__or2_1_6/B sky130_fd_sc_hs__or2_1_6/A
+ sky130_fd_sc_hs__or2_1_6/X VSS VDD sky130_fd_sc_hs__or2_1
Xsky130_fd_sc_hs__dfrtp_1_410 sky130_fd_sc_hs__clkbuf_4_16/X VDD VSS sky130_fd_sc_hs__xnor2_1_85/A
+ sky130_fd_sc_hs__clkinv_1_76/A sky130_fd_sc_hs__a22o_1_80/X VSS VDD sky130_fd_sc_hs__dfrtp_1
Xsky130_fd_sc_hs__dfrtp_1_421 sky130_fd_sc_hs__clkbuf_4_19/X VDD VSS sky130_fd_sc_hs__a22o_1_88/B2
+ sky130_fd_sc_hs__clkinv_1_83/A sky130_fd_sc_hs__a22o_1_88/X VSS VDD sky130_fd_sc_hs__dfrtp_1
Xsky130_fd_sc_hs__dfrtp_1_432 sky130_fd_sc_hs__clkbuf_4_19/X VDD VSS sky130_fd_sc_hs__buf_1_154/A
+ sky130_fd_sc_hs__clkinv_1_84/A sky130_fd_sc_hs__a21o_1_6/X VSS VDD sky130_fd_sc_hs__dfrtp_1
Xsky130_fd_sc_hs__dfrtp_1_443 sky130_fd_sc_hs__clkbuf_4_19/X VDD VSS sky130_fd_sc_hs__nor3_1_26/B
+ sky130_fd_sc_hs__clkinv_1_83/A sky130_fd_sc_hs__nand2_1_105/Y VSS VDD sky130_fd_sc_hs__dfrtp_1
Xsky130_fd_sc_hs__dfrtp_1_454 sky130_fd_sc_hs__clkbuf_4_22/X VDD VSS sky130_fd_sc_hs__mux2i_1_16/S
+ sky130_fd_sc_hs__clkinv_1_92/A sky130_fd_sc_hs__dfrtp_1_454/D VSS VDD sky130_fd_sc_hs__dfrtp_1
Xsky130_fd_sc_hs__dfrtp_1_465 sky130_fd_sc_hs__clkbuf_4_22/A VDD VSS sky130_fd_sc_hs__xor3_1_0/B
+ sky130_fd_sc_hs__clkinv_1_101/A sky130_fd_sc_hs__mux2_1_248/X VSS VDD sky130_fd_sc_hs__dfrtp_1
Xsky130_fd_sc_hs__dfrtp_1_476 sky130_fd_sc_hs__clkbuf_4_22/A VDD VSS sky130_fd_sc_hs__xor2_1_71/A
+ sky130_fd_sc_hs__clkinv_1_101/A sky130_fd_sc_hs__mux2_1_249/X VSS VDD sky130_fd_sc_hs__dfrtp_1
Xsky130_fd_sc_hs__dfrtp_1_487 sky130_fd_sc_hs__clkbuf_4_22/A VDD VSS sky130_fd_sc_hs__xor2_1_77/A
+ sky130_fd_sc_hs__clkbuf_2_152/X sky130_fd_sc_hs__dfrtp_1_487/D VSS VDD sky130_fd_sc_hs__dfrtp_1
Xsky130_fd_sc_hs__dfrtp_1_498 sky130_fd_sc_hs__clkbuf_4_23/X VDD VSS sky130_fd_sc_hs__nor2_1_150/A
+ sky130_fd_sc_hs__clkinv_1_103/A sky130_fd_sc_hs__dfrtp_1_498/D VSS VDD sky130_fd_sc_hs__dfrtp_1
Xsky130_fd_sc_hs__clkbuf_4_6 VDD VSS sky130_fd_sc_hs__buf_4_0/A sky130_fd_sc_hs__buf_16_4/A
+ VSS VDD sky130_fd_sc_hs__clkbuf_4
Xsky130_fd_sc_hs__clkinv_4_6 VDD VSS sky130_fd_sc_hs__clkinv_4_6/Y sky130_fd_sc_hs__clkinv_4_6/A
+ VSS VDD sky130_fd_sc_hs__clkinv_4
Xsky130_fd_sc_hs__mux2_1_403 VDD VSS sky130_fd_sc_hs__mux2_1_403/X sky130_fd_sc_hs__buf_8_28/A
+ sky130_fd_sc_hs__mux2_1_473/A1 sky130_fd_sc_hs__mux2_1_403/A1 VSS VDD sky130_fd_sc_hs__mux2_1
Xsky130_fd_sc_hs__mux2_1_414 VDD VSS sky130_fd_sc_hs__mux2_1_414/X sky130_fd_sc_hs__buf_16_15/A
+ sky130_fd_sc_hs__a22o_1_88/B2 sky130_fd_sc_hs__mux2_1_414/A1 VSS VDD sky130_fd_sc_hs__mux2_1
Xsky130_fd_sc_hs__mux2_1_425 VDD VSS sky130_fd_sc_hs__mux2_1_425/X sky130_fd_sc_hs__buf_16_14/A
+ sky130_fd_sc_hs__mux2_1_425/A0 sky130_fd_sc_hs__a22o_1_94/B2 VSS VDD sky130_fd_sc_hs__mux2_1
Xsky130_fd_sc_hs__mux2_1_436 VDD VSS sky130_fd_sc_hs__mux2_1_436/X sky130_fd_sc_hs__buf_16_0/A
+ sky130_fd_sc_hs__nor2_1_183/B sky130_fd_sc_hs__a22o_1_91/B2 VSS VDD sky130_fd_sc_hs__mux2_1
Xsky130_fd_sc_hs__mux2_1_447 VDD VSS sky130_fd_sc_hs__mux2_1_447/X sky130_fd_sc_hs__buf_16_4/A
+ sky130_fd_sc_hs__mux2_1_447/A0 sky130_fd_sc_hs__a22o_1_92/B2 VSS VDD sky130_fd_sc_hs__mux2_1
Xsky130_fd_sc_hs__mux2_1_458 VDD VSS sky130_fd_sc_hs__mux2_1_458/X sky130_fd_sc_hs__buf_16_5/A
+ sky130_fd_sc_hs__mux2_1_458/A0 sky130_fd_sc_hs__a22o_1_88/B2 VSS VDD sky130_fd_sc_hs__mux2_1
Xsky130_fd_sc_hs__mux2_1_469 VDD VSS sky130_fd_sc_hs__mux2_1_469/X sky130_fd_sc_hs__mux2_1_94/S
+ sky130_fd_sc_hs__xor2_1_18/B sky130_fd_sc_hs__a22o_1_62/B2 VSS VDD sky130_fd_sc_hs__mux2_1
Xsky130_fd_sc_hs__a311oi_1_1 VDD VSS sky130_fd_sc_hs__nor2_1_10/A sky130_fd_sc_hs__nor2_1_11/A
+ sky130_fd_sc_hs__and2_1_1/B sky130_fd_sc_hs__o21a_1_1/A1 sky130_fd_sc_hs__and2_1_1/A
+ sky130_fd_sc_hs__or2_1_5/B VSS VDD sky130_fd_sc_hs__a311oi_1
Xsky130_fd_sc_hs__dfrtp_1_240 sky130_fd_sc_hs__buf_8_5/X VDD VSS sky130_fd_sc_hs__dfrtp_1_240/Q
+ sky130_fd_sc_hs__clkbuf_8_2/X sky130_fd_sc_hs__dfrtp_1_240/D VSS VDD sky130_fd_sc_hs__dfrtp_1
Xsky130_fd_sc_hs__dfrtp_1_251 sky130_fd_sc_hs__buf_2_0/A VDD VSS sky130_fd_sc_hs__o21bai_1_0/A1
+ sky130_fd_sc_hs__clkbuf_2_76/X sky130_fd_sc_hs__a21oi_1_63/Y VSS VDD sky130_fd_sc_hs__dfrtp_1
Xsky130_fd_sc_hs__dfrtp_1_262 sky130_fd_sc_hs__buf_2_0/A VDD VSS sky130_fd_sc_hs__nor3_1_2/A
+ sky130_fd_sc_hs__clkinv_1_51/A sky130_fd_sc_hs__a22o_1_33/X VSS VDD sky130_fd_sc_hs__dfrtp_1
Xsky130_fd_sc_hs__dfrtp_1_273 sky130_fd_sc_hs__buf_8_8/X VDD VSS sky130_fd_sc_hs__xor2_1_35/A
+ sky130_fd_sc_hs__clkinv_1_53/A sky130_fd_sc_hs__mux2_1_194/X VSS VDD sky130_fd_sc_hs__dfrtp_1
Xsky130_fd_sc_hs__dfrtp_1_284 sky130_fd_sc_hs__buf_2_0/A VDD VSS sky130_fd_sc_hs__xnor2_1_51/B
+ sky130_fd_sc_hs__clkbuf_2_74/X sky130_fd_sc_hs__dfrtp_1_291/Q VSS VDD sky130_fd_sc_hs__dfrtp_1
Xsky130_fd_sc_hs__dfrtp_1_295 sky130_fd_sc_hs__buf_8_5/X VDD VSS sky130_fd_sc_hs__nand2_1_69/A
+ sky130_fd_sc_hs__clkbuf_8_4/X sky130_fd_sc_hs__nand2_1_62/Y VSS VDD sky130_fd_sc_hs__dfrtp_1
Xsky130_fd_sc_hs__clkinv_1_50 VDD VSS sky130_fd_sc_hs__or2_1_0/B sky130_fd_sc_hs__a22o_1_6/B1
+ VSS VDD sky130_fd_sc_hs__clkinv_1
Xsky130_fd_sc_hs__clkbuf_2_3 VDD VSS sky130_fd_sc_hs__clkbuf_2_3/X sky130_fd_sc_hs__clkbuf_2_3/A
+ VSS VDD sky130_fd_sc_hs__clkbuf_2
Xsky130_fd_sc_hs__clkinv_1_61 VDD VSS sky130_fd_sc_hs__clkinv_1_61/A sky130_fd_sc_hs__clkinv_1_61/Y
+ VSS VDD sky130_fd_sc_hs__clkinv_1
Xsky130_fd_sc_hs__a22o_1_14 VDD VSS sky130_fd_sc_hs__nor3_1_8/B sky130_fd_sc_hs__maj3_1_3/C
+ sky130_fd_sc_hs__a22oi_1_6/B1 sky130_fd_sc_hs__a22oi_1_6/A2 sky130_fd_sc_hs__a22o_1_14/A1
+ VSS VDD sky130_fd_sc_hs__a22o_1
Xsky130_fd_sc_hs__a22o_1_25 VDD VSS sky130_fd_sc_hs__a22o_1_25/X sky130_fd_sc_hs__xnor2_1_43/Y
+ sky130_fd_sc_hs__nor2_1_45/Y sky130_fd_sc_hs__nor2_1_45/B sky130_fd_sc_hs__a22o_1_25/A1
+ VSS VDD sky130_fd_sc_hs__a22o_1
Xsky130_fd_sc_hs__clkinv_1_72 VDD VSS sky130_fd_sc_hs__nand2_1_85/A sky130_fd_sc_hs__or2_1_13/A
+ VSS VDD sky130_fd_sc_hs__clkinv_1
Xsky130_fd_sc_hs__clkinv_1_83 VDD VSS sky130_fd_sc_hs__clkinv_1_83/A sky130_fd_sc_hs__clkinv_1_83/Y
+ VSS VDD sky130_fd_sc_hs__clkinv_1
Xsky130_fd_sc_hs__clkinv_1_94 VDD VSS sky130_fd_sc_hs__clkinv_1_94/A sky130_fd_sc_hs__clkinv_1_94/Y
+ VSS VDD sky130_fd_sc_hs__clkinv_1
Xsky130_fd_sc_hs__a22o_1_36 VDD VSS sky130_fd_sc_hs__a22o_1_36/X sky130_fd_sc_hs__a22o_1_36/B2
+ sky130_fd_sc_hs__a31o_1_2/A2 sky130_fd_sc_hs__a32o_1_7/B1 sky130_fd_sc_hs__maj3_1_16/C
+ VSS VDD sky130_fd_sc_hs__a22o_1
Xsky130_fd_sc_hs__o21ai_1_1 VDD VSS sky130_fd_sc_hs__o21ai_1_1/Y sky130_fd_sc_hs__nand2_1_8/A
+ sky130_fd_sc_hs__nor3_1_5/Y sky130_fd_sc_hs__o31a_1_0/X VSS VDD sky130_fd_sc_hs__o21ai_1
Xsky130_fd_sc_hs__a22o_1_47 VDD VSS sky130_fd_sc_hs__a22o_1_47/X sky130_fd_sc_hs__a22o_1_47/B2
+ sky130_fd_sc_hs__a22o_1_93/B1 sky130_fd_sc_hs__a22o_1_93/A2 sky130_fd_sc_hs__maj3_1_12/C
+ VSS VDD sky130_fd_sc_hs__a22o_1
Xsky130_fd_sc_hs__clkbuf_2_14 VDD VSS sky130_fd_sc_hs__clkbuf_2_14/X sky130_fd_sc_hs__clkbuf_2_3/A
+ VSS VDD sky130_fd_sc_hs__clkbuf_2
Xsky130_fd_sc_hs__a22o_1_58 VDD VSS sky130_fd_sc_hs__a22o_1_58/X sky130_fd_sc_hs__a31oi_1_7/Y
+ sky130_fd_sc_hs__a21o_1_4/X sky130_fd_sc_hs__a32o_1_7/B1 sky130_fd_sc_hs__xor2_1_45/A
+ VSS VDD sky130_fd_sc_hs__a22o_1
Xsky130_fd_sc_hs__clkbuf_2_25 VDD VSS sky130_fd_sc_hs__clkbuf_2_25/X sky130_fd_sc_hs__clkbuf_2_3/A
+ VSS VDD sky130_fd_sc_hs__clkbuf_2
Xsky130_fd_sc_hs__a22o_1_69 VDD VSS sky130_fd_sc_hs__a22o_1_69/X sky130_fd_sc_hs__mux2_1_99/A0
+ sky130_fd_sc_hs__buf_8_17/X sky130_fd_sc_hs__buf_8_15/X sky130_fd_sc_hs__a22o_1_69/A1
+ VSS VDD sky130_fd_sc_hs__a22o_1
Xsky130_fd_sc_hs__clkbuf_2_36 VDD VSS sky130_fd_sc_hs__clkinv_1_19/A sky130_fd_sc_hs__clkbuf_2_92/A
+ VSS VDD sky130_fd_sc_hs__clkbuf_2
Xsky130_fd_sc_hs__clkbuf_2_47 VDD VSS sky130_fd_sc_hs__clkinv_1_35/A sky130_fd_sc_hs__clkinv_4_1/A
+ VSS VDD sky130_fd_sc_hs__clkbuf_2
Xsky130_fd_sc_hs__clkbuf_2_58 VDD VSS sky130_fd_sc_hs__clkinv_1_41/A sky130_fd_sc_hs__clkinv_4_1/A
+ VSS VDD sky130_fd_sc_hs__clkbuf_2
Xsky130_fd_sc_hs__clkbuf_2_69 VDD VSS sky130_fd_sc_hs__clkbuf_2_69/X sky130_fd_sc_hs__clkinv_4_2/A
+ VSS VDD sky130_fd_sc_hs__clkbuf_2
Xsky130_fd_sc_hs__nand4_1_8 VDD VSS sky130_fd_sc_hs__nor3_1_48/C sky130_fd_sc_hs__nand4_1_8/Y
+ sky130_fd_sc_hs__nand4_1_9/D sky130_fd_sc_hs__nor3_1_48/B sky130_fd_sc_hs__nor3_1_48/A
+ VSS VDD sky130_fd_sc_hs__nand4_1
Xsky130_fd_sc_hs__clkinv_2_3 VDD VSS sky130_fd_sc_hs__clkinv_2_3/Y sky130_fd_sc_hs__clkinv_2_3/A
+ VSS VDD sky130_fd_sc_hs__clkinv_2
Xsky130_fd_sc_hs__o21ai_1_110 VDD VSS sky130_fd_sc_hs__o21ai_1_110/Y sky130_fd_sc_hs__a21oi_1_202/Y
+ sky130_fd_sc_hs__xnor2_1_147/Y sky130_fd_sc_hs__nand2_1_223/Y VSS VDD sky130_fd_sc_hs__o21ai_1
Xsky130_fd_sc_hs__mux2_1_200 VDD VSS sky130_fd_sc_hs__mux2_1_200/X sky130_fd_sc_hs__nor2_1_66/B
+ sky130_fd_sc_hs__xor2_1_26/B sky130_fd_sc_hs__nor2_1_17/Y VSS VDD sky130_fd_sc_hs__mux2_1
Xsky130_fd_sc_hs__mux2_1_211 VDD VSS sky130_fd_sc_hs__mux2_1_211/X sky130_fd_sc_hs__mux2_1_94/S
+ sky130_fd_sc_hs__xor2_1_46/A sky130_fd_sc_hs__mux2_1_99/A0 VSS VDD sky130_fd_sc_hs__mux2_1
Xsky130_fd_sc_hs__nand2_1_14 VDD VSS sky130_fd_sc_hs__nand2_1_14/B sky130_fd_sc_hs__nand2_1_14/Y
+ sky130_fd_sc_hs__nand2_1_14/A VSS VDD sky130_fd_sc_hs__nand2_1
Xsky130_fd_sc_hs__mux2_1_222 VDD VSS sky130_fd_sc_hs__mux2_1_222/X sky130_fd_sc_hs__nor2_1_82/B
+ sky130_fd_sc_hs__xor2_1_41/A sky130_fd_sc_hs__a21oi_1_19/Y VSS VDD sky130_fd_sc_hs__mux2_1
Xsky130_fd_sc_hs__mux2_1_233 VDD VSS sky130_fd_sc_hs__mux2_1_233/X sky130_fd_sc_hs__nor2_1_82/B
+ sky130_fd_sc_hs__xor2_1_59/A sky130_fd_sc_hs__nor2_1_79/Y VSS VDD sky130_fd_sc_hs__mux2_1
Xsky130_fd_sc_hs__nand2_1_25 VDD VSS sky130_fd_sc_hs__nand2_1_25/B sky130_fd_sc_hs__nor3_1_8/A
+ sky130_fd_sc_hs__nand2_1_25/A VSS VDD sky130_fd_sc_hs__nand2_1
Xsky130_fd_sc_hs__mux2_1_244 VDD VSS sky130_fd_sc_hs__mux2_1_244/X sky130_fd_sc_hs__nor2_1_66/B
+ sky130_fd_sc_hs__xor2_1_67/B sky130_fd_sc_hs__nor2_1_185/Y VSS VDD sky130_fd_sc_hs__mux2_1
Xsky130_fd_sc_hs__nand2_1_36 VDD VSS sky130_fd_sc_hs__o311ai_1_3/Y sky130_fd_sc_hs__xnor2_1_39/B
+ sky130_fd_sc_hs__and2_1_10/B VSS VDD sky130_fd_sc_hs__nand2_1
Xsky130_fd_sc_hs__mux2_1_255 VDD VSS sky130_fd_sc_hs__mux2_1_255/X sky130_fd_sc_hs__o21a_1_29/B1
+ sky130_fd_sc_hs__buf_1_146/A sky130_fd_sc_hs__a22o_1_64/B2 VSS VDD sky130_fd_sc_hs__mux2_1
Xsky130_fd_sc_hs__nand2_1_47 VDD VSS sky130_fd_sc_hs__a31oi_1_0/Y sky130_fd_sc_hs__nand2_1_48/B
+ sky130_fd_sc_hs__xor2_1_19/X VSS VDD sky130_fd_sc_hs__nand2_1
Xsky130_fd_sc_hs__mux2_1_266 VDD VSS sky130_fd_sc_hs__mux2_1_266/X sky130_fd_sc_hs__o21a_1_29/B1
+ sky130_fd_sc_hs__buf_1_153/A sky130_fd_sc_hs__a22o_1_61/B2 VSS VDD sky130_fd_sc_hs__mux2_1
Xsky130_fd_sc_hs__nand2_1_58 VDD VSS sky130_fd_sc_hs__nor2_1_43/Y sky130_fd_sc_hs__nand2_1_59/B
+ sky130_fd_sc_hs__buf_1_20/A VSS VDD sky130_fd_sc_hs__nand2_1
Xsky130_fd_sc_hs__mux2_1_277 VDD VSS sky130_fd_sc_hs__mux2_1_277/X sky130_fd_sc_hs__nor2_2_8/Y
+ sky130_fd_sc_hs__mux2_1_277/A0 sky130_fd_sc_hs__a22o_1_84/B2 VSS VDD sky130_fd_sc_hs__mux2_1
Xsky130_fd_sc_hs__nand2_1_69 VDD VSS sky130_fd_sc_hs__a32o_1_4/B1 sky130_fd_sc_hs__nand2_1_69/Y
+ sky130_fd_sc_hs__nand2_1_69/A VSS VDD sky130_fd_sc_hs__nand2_1
Xsky130_fd_sc_hs__mux2_1_288 VDD VSS sky130_fd_sc_hs__mux2_1_288/X sky130_fd_sc_hs__o31ai_2_0/B1
+ sky130_fd_sc_hs__buf_1_29/A sky130_fd_sc_hs__a22o_1_88/B2 VSS VDD sky130_fd_sc_hs__mux2_1
Xsky130_fd_sc_hs__mux2_1_299 VDD VSS sky130_fd_sc_hs__mux2_1_299/X sky130_fd_sc_hs__buf_4_1/X
+ sky130_fd_sc_hs__mux2_1_355/A1 sky130_fd_sc_hs__mux2_1_299/A1 VSS VDD sky130_fd_sc_hs__mux2_1
Xsky130_fd_sc_hs__dlygate4sd3_1_15 VSS VDD raw_bits_i[19] sky130_fd_sc_hs__buf_1_89/A
+ VSS VDD sky130_fd_sc_hs__dlygate4sd3_1
Xsky130_fd_sc_hs__o21ai_1_15 VDD VSS sky130_fd_sc_hs__o21ai_1_15/Y sky130_fd_sc_hs__o21a_1_4/B1
+ sky130_fd_sc_hs__nor3_1_9/Y sky130_fd_sc_hs__a21oi_1_34/Y VSS VDD sky130_fd_sc_hs__o21ai_1
Xsky130_fd_sc_hs__o21ai_1_26 VDD VSS sky130_fd_sc_hs__o21ai_1_26/Y sky130_fd_sc_hs__o311ai_1_8/Y
+ sky130_fd_sc_hs__mux2_1_6/S sky130_fd_sc_hs__o41ai_1_3/A2 VSS VDD sky130_fd_sc_hs__o21ai_1
Xsky130_fd_sc_hs__o21ai_1_37 VDD VSS sky130_fd_sc_hs__o21ai_1_37/Y sky130_fd_sc_hs__a31o_1_3/A3
+ sky130_fd_sc_hs__nand2_1_72/Y sky130_fd_sc_hs__nor3_1_27/Y VSS VDD sky130_fd_sc_hs__o21ai_1
Xsky130_fd_sc_hs__o21ai_1_48 VDD VSS sky130_fd_sc_hs__o21ai_1_48/Y sky130_fd_sc_hs__o31a_1_2/A1
+ sky130_fd_sc_hs__or2_1_16/A sky130_fd_sc_hs__o31a_1_2/A2 VSS VDD sky130_fd_sc_hs__o21ai_1
Xsky130_fd_sc_hs__o21ai_1_59 VDD VSS sky130_fd_sc_hs__o21ai_1_59/Y sky130_fd_sc_hs__buf_8_37/A
+ sky130_fd_sc_hs__buf_8_36/A sky130_fd_sc_hs__xor2_1_80/A VSS VDD sky130_fd_sc_hs__o21ai_1
Xsky130_fd_sc_hs__clkbuf_8_13 VDD VSS sky130_fd_sc_hs__nand2_1_198/B sky130_fd_sc_hs__nor3_4_4/Y
+ VSS VDD sky130_fd_sc_hs__clkbuf_8
Xsky130_fd_sc_hs__o211ai_1_15 VDD VSS sky130_fd_sc_hs__nand2_1_229/Y sky130_fd_sc_hs__o211ai_1_15/Y
+ sky130_fd_sc_hs__buf_8_37/X sky130_fd_sc_hs__buf_8_36/X sky130_fd_sc_hs__xor2_1_89/A
+ VSS VDD sky130_fd_sc_hs__o211ai_1
Xsky130_fd_sc_hs__and4_1_3 VDD VSS sky130_fd_sc_hs__and4_1_3/A sky130_fd_sc_hs__and4_1_3/B
+ sky130_fd_sc_hs__and4_1_3/C sky130_fd_sc_hs__and4_1_3/D sky130_fd_sc_hs__and4_1_3/X
+ VSS VDD sky130_fd_sc_hs__and4_1
Xsky130_fd_sc_hs__dfrtp_1_806 sky130_fd_sc_hs__clkbuf_4_1/X VDD VSS sky130_fd_sc_hs__mux2_1_51/A0
+ sky130_fd_sc_hs__clkinv_1_7/A sky130_fd_sc_hs__mux2_1_51/X VSS VDD sky130_fd_sc_hs__dfrtp_1
Xsky130_fd_sc_hs__dfrtp_1_817 sky130_fd_sc_hs__clkbuf_4_5/X VDD VSS sky130_fd_sc_hs__mux2_1_474/A0
+ sky130_fd_sc_hs__clkinv_1_113/A sky130_fd_sc_hs__mux2_1_474/X VSS VDD sky130_fd_sc_hs__dfrtp_1
Xsky130_fd_sc_hs__dfrtp_1_828 sky130_fd_sc_hs__buf_8_7/A VDD VSS sky130_fd_sc_hs__maj3_1_18/C
+ sky130_fd_sc_hs__clkinv_1_59/A sky130_fd_sc_hs__a32o_1_15/X VSS VDD sky130_fd_sc_hs__dfrtp_1
Xsky130_fd_sc_hs__a21oi_1_103 VDD VSS sky130_fd_sc_hs__a31o_1_12/A1 sky130_fd_sc_hs__a21oi_1_103/Y
+ sky130_fd_sc_hs__and2_1_26/A sky130_fd_sc_hs__a31o_1_12/A2 VSS VDD sky130_fd_sc_hs__a21oi_1
Xsky130_fd_sc_hs__a21oi_1_114 VDD VSS sky130_fd_sc_hs__nand4_1_5/Y sky130_fd_sc_hs__a21o_1_6/B1
+ sky130_fd_sc_hs__or3_1_6/A sky130_fd_sc_hs__nor2_1_95/B VSS VDD sky130_fd_sc_hs__a21oi_1
Xsky130_fd_sc_hs__a21oi_1_125 VDD VSS sky130_fd_sc_hs__buf_8_12/A sky130_fd_sc_hs__a22o_1_99/B2
+ sky130_fd_sc_hs__or2_1_19/B sky130_fd_sc_hs__or2_1_19/A VSS VDD sky130_fd_sc_hs__a21oi_1
Xsky130_fd_sc_hs__a21oi_1_136 VDD VSS sky130_fd_sc_hs__nor2_1_116/Y sky130_fd_sc_hs__dfrtp_1_473/D
+ sky130_fd_sc_hs__nor2_1_66/B sky130_fd_sc_hs__o21ai_1_111/Y VSS VDD sky130_fd_sc_hs__a21oi_1
Xsky130_fd_sc_hs__a21oi_1_147 VDD VSS sky130_fd_sc_hs__a21oi_1_149/Y sky130_fd_sc_hs__a21oi_1_147/Y
+ sky130_fd_sc_hs__nand2_1_154/Y sky130_fd_sc_hs__nor2_1_179/Y VSS VDD sky130_fd_sc_hs__a21oi_1
Xsky130_fd_sc_hs__a21oi_1_158 VDD VSS sky130_fd_sc_hs__a21oi_1_152/Y sky130_fd_sc_hs__a21oi_1_158/Y
+ sky130_fd_sc_hs__xor2_1_75/X sky130_fd_sc_hs__o21a_1_27/B1 VSS VDD sky130_fd_sc_hs__a21oi_1
Xsky130_fd_sc_hs__a21oi_1_169 VDD VSS sky130_fd_sc_hs__nor2_1_137/Y sky130_fd_sc_hs__dfrtp_1_520/D
+ sky130_fd_sc_hs__buf_8_11/A sky130_fd_sc_hs__o21ai_1_93/Y VSS VDD sky130_fd_sc_hs__a21oi_1
Xsky130_fd_sc_hs__clkbuf_2_130 VDD VSS sky130_fd_sc_hs__clkinv_1_89/A sky130_fd_sc_hs__clkinv_4_5/A
+ VSS VDD sky130_fd_sc_hs__clkbuf_2
Xsky130_fd_sc_hs__clkbuf_2_141 VDD VSS sky130_fd_sc_hs__clkinv_1_101/A sky130_fd_sc_hs__clkinv_4_7/A
+ VSS VDD sky130_fd_sc_hs__clkbuf_2
Xsky130_fd_sc_hs__clkbuf_2_152 VDD VSS sky130_fd_sc_hs__clkbuf_2_152/X sky130_fd_sc_hs__clkinv_4_7/A
+ VSS VDD sky130_fd_sc_hs__clkbuf_2
Xsky130_fd_sc_hs__nand2_1_130 VDD VSS sky130_fd_sc_hs__nor2_1_128/B sky130_fd_sc_hs__o22ai_1_3/A2
+ sky130_fd_sc_hs__or2_1_30/B VSS VDD sky130_fd_sc_hs__nand2_1
Xsky130_fd_sc_hs__clkbuf_2_163 VDD VSS sky130_fd_sc_hs__clkinv_1_113/A sky130_fd_sc_hs__clkbuf_2_236/A
+ VSS VDD sky130_fd_sc_hs__clkbuf_2
Xsky130_fd_sc_hs__nand2_1_141 VDD VSS sky130_fd_sc_hs__nand2_1_142/Y sky130_fd_sc_hs__nand2_1_145/B
+ sky130_fd_sc_hs__nor2_1_132/B VSS VDD sky130_fd_sc_hs__nand2_1
Xsky130_fd_sc_hs__clkbuf_2_174 VDD VSS sky130_fd_sc_hs__clkinv_1_126/A sky130_fd_sc_hs__clkbuf_2_176/A
+ VSS VDD sky130_fd_sc_hs__clkbuf_2
Xsky130_fd_sc_hs__nand2_1_152 VDD VSS sky130_fd_sc_hs__and2_1_36/X sky130_fd_sc_hs__a31o_1_14/B1
+ sky130_fd_sc_hs__nor3_1_34/Y VSS VDD sky130_fd_sc_hs__nand2_1
Xsky130_fd_sc_hs__clkbuf_2_185 VDD VSS sky130_fd_sc_hs__clkbuf_2_185/X sky130_fd_sc_hs__clkinv_4_6/A
+ VSS VDD sky130_fd_sc_hs__clkbuf_2
Xsky130_fd_sc_hs__nand2_1_163 VDD VSS sky130_fd_sc_hs__nor3_1_40/Y sky130_fd_sc_hs__nand2_1_163/Y
+ sky130_fd_sc_hs__nor2b_1_48/Y VSS VDD sky130_fd_sc_hs__nand2_1
Xsky130_fd_sc_hs__clkbuf_2_196 VDD VSS sky130_fd_sc_hs__clkinv_1_142/A sky130_fd_sc_hs__clkbuf_2_236/A
+ VSS VDD sky130_fd_sc_hs__clkbuf_2
Xsky130_fd_sc_hs__nand2_1_174 VDD VSS sky130_fd_sc_hs__xnor2_1_122/Y sky130_fd_sc_hs__a31o_1_14/A2
+ sky130_fd_sc_hs__maj3_1_68/X VSS VDD sky130_fd_sc_hs__nand2_1
Xsky130_fd_sc_hs__nand2_1_185 VDD VSS sky130_fd_sc_hs__nand4_1_4/Y sky130_fd_sc_hs__o21ai_1_80/B1
+ sky130_fd_sc_hs__or2_1_21/B VSS VDD sky130_fd_sc_hs__nand2_1
Xsky130_fd_sc_hs__nand2_1_196 VDD VSS sky130_fd_sc_hs__nand2_1_196/B sky130_fd_sc_hs__and2_1_41/B
+ sky130_fd_sc_hs__nand2_1_196/A VSS VDD sky130_fd_sc_hs__nand2_1
Xsky130_fd_sc_hs__maj3_1_1 VDD VSS sky130_fd_sc_hs__maj3_1_1/A sky130_fd_sc_hs__maj3_1_1/B
+ sky130_fd_sc_hs__maj3_1_1/X sky130_fd_sc_hs__maj3_1_1/C VSS VDD sky130_fd_sc_hs__maj3_1
Xsky130_fd_sc_hs__clkinv_1_108 VDD VSS sky130_fd_sc_hs__clkinv_1_108/A sky130_fd_sc_hs__clkinv_1_108/Y
+ VSS VDD sky130_fd_sc_hs__clkinv_1
Xsky130_fd_sc_hs__clkinv_1_119 VDD VSS sky130_fd_sc_hs__nor3_1_48/C sky130_fd_sc_hs__nand4_1_9/C
+ VSS VDD sky130_fd_sc_hs__clkinv_1
Xsky130_fd_sc_hs__nor2_2_2 VDD VSS sky130_fd_sc_hs__nor2_2_2/B sky130_fd_sc_hs__nor2_2_2/Y
+ sky130_fd_sc_hs__nor2_2_2/A VSS VDD sky130_fd_sc_hs__nor2_2
Xsky130_fd_sc_hs__buf_8_20 VDD VSS sky130_fd_sc_hs__buf_8_20/X sky130_fd_sc_hs__nor2_2_2/Y
+ VSS VDD sky130_fd_sc_hs__buf_8
Xsky130_fd_sc_hs__buf_8_31 VDD VSS sky130_fd_sc_hs__buf_8_31/X sky130_fd_sc_hs__buf_8_31/A
+ VSS VDD sky130_fd_sc_hs__buf_8
Xsky130_fd_sc_hs__dfrtp_1_603 sky130_fd_sc_hs__clkbuf_4_30/X VDD VSS sky130_fd_sc_hs__mux2_1_307/A1
+ sky130_fd_sc_hs__clkinv_1_131/A sky130_fd_sc_hs__mux2_1_307/X VSS VDD sky130_fd_sc_hs__dfrtp_1
Xsky130_fd_sc_hs__dfrtp_1_614 sky130_fd_sc_hs__clkbuf_4_31/X VDD VSS sky130_fd_sc_hs__nor2_1_77/A
+ sky130_fd_sc_hs__clkbuf_2_185/X sky130_fd_sc_hs__a22o_1_119/X VSS VDD sky130_fd_sc_hs__dfrtp_1
Xsky130_fd_sc_hs__dfrtp_1_625 sky130_fd_sc_hs__clkbuf_4_31/X VDD VSS sky130_fd_sc_hs__mux2_1_329/A0
+ sky130_fd_sc_hs__clkbuf_2_192/A sky130_fd_sc_hs__mux2_1_329/X VSS VDD sky130_fd_sc_hs__dfrtp_1
Xsky130_fd_sc_hs__dfrtp_1_636 sky130_fd_sc_hs__buf_8_30/X VDD VSS sky130_fd_sc_hs__mux2_1_346/A0
+ sky130_fd_sc_hs__clkinv_1_145/A sky130_fd_sc_hs__mux2_1_346/X VSS VDD sky130_fd_sc_hs__dfrtp_1
Xsky130_fd_sc_hs__dfrtp_1_647 sky130_fd_sc_hs__clkbuf_4_31/X VDD VSS sky130_fd_sc_hs__maj3_1_52/B
+ sky130_fd_sc_hs__clkinv_1_143/A sky130_fd_sc_hs__mux2_1_331/X VSS VDD sky130_fd_sc_hs__dfrtp_1
Xsky130_fd_sc_hs__dfrtp_1_658 sky130_fd_sc_hs__clkbuf_4_33/X VDD VSS sky130_fd_sc_hs__xor2_1_83/A
+ sky130_fd_sc_hs__clkbuf_2_202/X sky130_fd_sc_hs__mux2_1_397/X VSS VDD sky130_fd_sc_hs__dfrtp_1
Xsky130_fd_sc_hs__dfrtp_1_669 sky130_fd_sc_hs__clkbuf_4_35/X VDD VSS sky130_fd_sc_hs__mux2_1_367/A1
+ sky130_fd_sc_hs__clkinv_1_155/A sky130_fd_sc_hs__mux2_1_367/X VSS VDD sky130_fd_sc_hs__dfrtp_1
Xsky130_fd_sc_hs__nor2_1_11 VDD VSS sky130_fd_sc_hs__or2_1_5/A sky130_fd_sc_hs__nor2_1_11/Y
+ sky130_fd_sc_hs__nor2_1_11/A VSS VDD sky130_fd_sc_hs__nor2_1
Xsky130_fd_sc_hs__nor2_1_22 VDD VSS sky130_fd_sc_hs__nor2_1_24/Y sky130_fd_sc_hs__nor2_1_22/Y
+ sky130_fd_sc_hs__and2_1_7/X VSS VDD sky130_fd_sc_hs__nor2_1
Xsky130_fd_sc_hs__nor2_1_33 VDD VSS sky130_fd_sc_hs__nor2_1_33/B sky130_fd_sc_hs__nor2_1_33/Y
+ sky130_fd_sc_hs__o21a_1_7/A1 VSS VDD sky130_fd_sc_hs__nor2_1
Xsky130_fd_sc_hs__nor2_1_44 VDD VSS sky130_fd_sc_hs__or2_1_8/B sky130_fd_sc_hs__nor2_1_44/Y
+ sky130_fd_sc_hs__nor2_1_44/A VSS VDD sky130_fd_sc_hs__nor2_1
Xsky130_fd_sc_hs__nor2_1_55 VDD VSS sky130_fd_sc_hs__nor3_1_17/Y sky130_fd_sc_hs__nor2_1_55/Y
+ sky130_fd_sc_hs__nor2_1_55/A VSS VDD sky130_fd_sc_hs__nor2_1
Xsky130_fd_sc_hs__nor2_1_66 VDD VSS sky130_fd_sc_hs__nor2_1_66/B sky130_fd_sc_hs__nor2_1_66/Y
+ sky130_fd_sc_hs__xor2_1_51/B VSS VDD sky130_fd_sc_hs__nor2_1
Xsky130_fd_sc_hs__nor2_1_77 VDD VSS sky130_fd_sc_hs__xor2_1_54/A sky130_fd_sc_hs__or2_1_14/B
+ sky130_fd_sc_hs__nor2_1_77/A VSS VDD sky130_fd_sc_hs__nor2_1
Xsky130_fd_sc_hs__nor2_1_88 VDD VSS sky130_fd_sc_hs__and4_1_5/X sky130_fd_sc_hs__nor2_1_88/Y
+ sky130_fd_sc_hs__nor2_1_88/A VSS VDD sky130_fd_sc_hs__nor2_1
Xsky130_fd_sc_hs__nor2_1_99 VDD VSS sky130_fd_sc_hs__nor2_1_99/B sky130_fd_sc_hs__nor2_1_99/Y
+ sky130_fd_sc_hs__nor2_1_99/A VSS VDD sky130_fd_sc_hs__nor2_1
Xsky130_fd_sc_hs__xnor2_1_100 VDD VSS sky130_fd_sc_hs__maj3_1_40/C sky130_fd_sc_hs__xnor2_1_101/B
+ sky130_fd_sc_hs__xor2_1_69/X VSS VDD sky130_fd_sc_hs__xnor2_1
Xsky130_fd_sc_hs__xnor2_1_111 VDD VSS sky130_fd_sc_hs__nor3_1_38/B sky130_fd_sc_hs__nor2_1_146/A
+ sky130_fd_sc_hs__nor2_1_141/B VSS VDD sky130_fd_sc_hs__xnor2_1
Xsky130_fd_sc_hs__xnor2_1_122 VDD VSS sky130_fd_sc_hs__maj3_1_52/X sky130_fd_sc_hs__xnor2_1_122/Y
+ sky130_fd_sc_hs__xnor2_1_137/Y VSS VDD sky130_fd_sc_hs__xnor2_1
Xsky130_fd_sc_hs__xnor2_1_133 VDD VSS sky130_fd_sc_hs__xor2_1_86/A sky130_fd_sc_hs__xnor2_1_133/Y
+ sky130_fd_sc_hs__xor2_1_82/X VSS VDD sky130_fd_sc_hs__xnor2_1
Xsky130_fd_sc_hs__xnor2_1_144 VDD VSS sky130_fd_sc_hs__xor2_1_89/A sky130_fd_sc_hs__xnor3_1_2/C
+ sky130_fd_sc_hs__xnor2_1_145/Y VSS VDD sky130_fd_sc_hs__xnor2_1
Xsky130_fd_sc_hs__mux2_1_40 VDD VSS sky130_fd_sc_hs__mux2_1_40/X sky130_fd_sc_hs__buf_16_3/X
+ sky130_fd_sc_hs__mux2_1_40/A0 sky130_fd_sc_hs__mux2_1_40/A1 VSS VDD sky130_fd_sc_hs__mux2_1
Xsky130_fd_sc_hs__mux2_1_51 VDD VSS sky130_fd_sc_hs__mux2_1_51/X sky130_fd_sc_hs__mux2_1_5/S
+ sky130_fd_sc_hs__mux2_1_51/A0 sky130_fd_sc_hs__mux2_1_85/A0 VSS VDD sky130_fd_sc_hs__mux2_1
Xsky130_fd_sc_hs__mux2_1_62 VDD VSS sky130_fd_sc_hs__mux2_1_62/X sky130_fd_sc_hs__mux2_1_1/S
+ sky130_fd_sc_hs__mux2_1_95/A1 sky130_fd_sc_hs__mux2_1_62/A1 VSS VDD sky130_fd_sc_hs__mux2_1
Xsky130_fd_sc_hs__mux2_1_73 VDD VSS sky130_fd_sc_hs__mux2_1_73/X sky130_fd_sc_hs__mux2_1_98/S
+ sky130_fd_sc_hs__mux2_1_73/A0 sky130_fd_sc_hs__mux2_1_94/A1 VSS VDD sky130_fd_sc_hs__mux2_1
Xsky130_fd_sc_hs__mux2_1_84 VDD VSS sky130_fd_sc_hs__mux2_1_84/X sky130_fd_sc_hs__buf_16_3/A
+ sky130_fd_sc_hs__mux2_1_96/A0 sky130_fd_sc_hs__a22o_1_9/A1 VSS VDD sky130_fd_sc_hs__mux2_1
Xsky130_fd_sc_hs__mux2_1_95 VDD VSS sky130_fd_sc_hs__mux2_1_95/X sky130_fd_sc_hs__buf_16_0/X
+ sky130_fd_sc_hs__xor2_1_1/B sky130_fd_sc_hs__mux2_1_95/A1 VSS VDD sky130_fd_sc_hs__mux2_1
Xsky130_fd_sc_hs__xnor2_1_8 VDD VSS sky130_fd_sc_hs__maj3_1_2/B sky130_fd_sc_hs__xnor2_1_8/Y
+ sky130_fd_sc_hs__maj3_1_2/C VSS VDD sky130_fd_sc_hs__xnor2_1
Xsky130_fd_sc_hs__nor2b_1_11 VDD VSS sky130_fd_sc_hs__maj3_1_13/X sky130_fd_sc_hs__o31ai_1_7/A3
+ sky130_fd_sc_hs__xnor2_1_52/Y VSS VDD sky130_fd_sc_hs__nor2b_1
Xsky130_fd_sc_hs__nor2b_1_22 VDD VSS sky130_fd_sc_hs__xnor2_1_80/Y sky130_fd_sc_hs__nor2b_1_22/Y
+ sky130_fd_sc_hs__maj3_1_34/X VSS VDD sky130_fd_sc_hs__nor2b_1
Xsky130_fd_sc_hs__nor2b_1_33 VDD VSS sky130_fd_sc_hs__o21ai_1_63/B1 sky130_fd_sc_hs__nor2b_1_33/Y
+ sky130_fd_sc_hs__nor2b_1_33/A VSS VDD sky130_fd_sc_hs__nor2b_1
Xsky130_fd_sc_hs__nor2b_1_44 VDD VSS sky130_fd_sc_hs__nor3_1_48/A sky130_fd_sc_hs__nor3_1_47/B
+ sky130_fd_sc_hs__nor3_1_48/B VSS VDD sky130_fd_sc_hs__nor2b_1
Xsky130_fd_sc_hs__o22ai_1_3 VDD VSS sky130_fd_sc_hs__o22ai_1_3/B2 sky130_fd_sc_hs__o22ai_1_3/B1
+ sky130_fd_sc_hs__o22ai_1_3/Y sky130_fd_sc_hs__o22ai_1_3/A2 sky130_fd_sc_hs__o22a_1_0/A1
+ VSS VDD sky130_fd_sc_hs__o22ai_1
Xsky130_fd_sc_hs__or2_1_7 VDD VSS sky130_fd_sc_hs__or2_1_7/B sky130_fd_sc_hs__or2_1_7/A
+ sky130_fd_sc_hs__or2_1_7/X VSS VDD sky130_fd_sc_hs__or2_1
Xsky130_fd_sc_hs__dfrtp_1_400 sky130_fd_sc_hs__clkbuf_4_15/X VDD VSS sky130_fd_sc_hs__mux2_1_40/A0
+ sky130_fd_sc_hs__dfrtp_2_1/CLK sky130_fd_sc_hs__a22o_1_141/X VSS VDD sky130_fd_sc_hs__dfrtp_1
Xsky130_fd_sc_hs__dfrtp_1_411 sky130_fd_sc_hs__clkbuf_4_16/X VDD VSS sky130_fd_sc_hs__a22o_1_84/B2
+ sky130_fd_sc_hs__clkbuf_2_112/X sky130_fd_sc_hs__a22o_1_84/X VSS VDD sky130_fd_sc_hs__dfrtp_1
Xsky130_fd_sc_hs__dfrtp_1_422 sky130_fd_sc_hs__clkbuf_4_16/X VDD VSS sky130_fd_sc_hs__a22o_1_91/B2
+ sky130_fd_sc_hs__clkinv_1_83/A sky130_fd_sc_hs__a22o_1_91/X VSS VDD sky130_fd_sc_hs__dfrtp_1
Xsky130_fd_sc_hs__dfrtp_1_433 sky130_fd_sc_hs__clkbuf_4_23/A VDD VSS sky130_fd_sc_hs__nor2_1_94/B
+ sky130_fd_sc_hs__clkbuf_2_129/A sky130_fd_sc_hs__nand4_1_3/Y VSS VDD sky130_fd_sc_hs__dfrtp_1
Xsky130_fd_sc_hs__dfrtp_1_444 sky130_fd_sc_hs__clkbuf_4_19/X VDD VSS sky130_fd_sc_hs__nor3_1_26/A
+ sky130_fd_sc_hs__clkinv_1_83/A sky130_fd_sc_hs__o2111ai_1_1/Y VSS VDD sky130_fd_sc_hs__dfrtp_1
Xsky130_fd_sc_hs__dfrtp_1_455 sky130_fd_sc_hs__clkbuf_4_22/X VDD VSS sky130_fd_sc_hs__buf_1_147/A
+ sky130_fd_sc_hs__clkbuf_2_132/X sky130_fd_sc_hs__buf_1_73/X VSS VDD sky130_fd_sc_hs__dfrtp_1
Xsky130_fd_sc_hs__dfrtp_1_466 sky130_fd_sc_hs__clkbuf_4_22/A VDD VSS sky130_fd_sc_hs__xor2_1_70/B
+ sky130_fd_sc_hs__clkbuf_2_139/X sky130_fd_sc_hs__dfrtp_1_466/D VSS VDD sky130_fd_sc_hs__dfrtp_1
Xsky130_fd_sc_hs__dfrtp_1_477 sky130_fd_sc_hs__clkbuf_4_22/A VDD VSS sky130_fd_sc_hs__maj3_1_47/C
+ sky130_fd_sc_hs__clkbuf_2_143/X sky130_fd_sc_hs__nand2_1_122/Y VSS VDD sky130_fd_sc_hs__dfrtp_1
Xsky130_fd_sc_hs__dfrtp_1_488 sky130_fd_sc_hs__clkbuf_4_23/X VDD VSS sky130_fd_sc_hs__nor3_1_38/B
+ sky130_fd_sc_hs__clkbuf_2_152/X sky130_fd_sc_hs__o21a_1_24/X VSS VDD sky130_fd_sc_hs__dfrtp_1
Xsky130_fd_sc_hs__dfrtp_1_499 sky130_fd_sc_hs__clkbuf_4_23/X VDD VSS sky130_fd_sc_hs__o32ai_1_0/A1
+ sky130_fd_sc_hs__clkbuf_2_157/A sky130_fd_sc_hs__dfrtp_1_499/D VSS VDD sky130_fd_sc_hs__dfrtp_1
Xsky130_fd_sc_hs__clkbuf_4_7 VDD VSS sky130_fd_sc_hs__nor3_4_1/Y sky130_fd_sc_hs__buf_16_0/A
+ VSS VDD sky130_fd_sc_hs__clkbuf_4
Xsky130_fd_sc_hs__clkinv_4_7 VDD VSS sky130_fd_sc_hs__clkinv_4_7/Y sky130_fd_sc_hs__clkinv_4_7/A
+ VSS VDD sky130_fd_sc_hs__clkinv_4
Xsky130_fd_sc_hs__mux2_1_404 VDD VSS sky130_fd_sc_hs__mux2_1_404/X sky130_fd_sc_hs__buf_4_0/A
+ sky130_fd_sc_hs__mux2_1_404/A0 sky130_fd_sc_hs__mux2_1_473/A1 VSS VDD sky130_fd_sc_hs__mux2_1
Xsky130_fd_sc_hs__mux2_1_415 VDD VSS sky130_fd_sc_hs__mux2_1_415/X sky130_fd_sc_hs__mux2_1_4/S
+ sky130_fd_sc_hs__dfrtp_2_2/Q sky130_fd_sc_hs__mux2_1_415/A1 VSS VDD sky130_fd_sc_hs__mux2_1
Xsky130_fd_sc_hs__mux2_1_426 VDD VSS sky130_fd_sc_hs__mux2_1_426/X sky130_fd_sc_hs__buf_16_12/A
+ sky130_fd_sc_hs__mux2_1_426/A0 sky130_fd_sc_hs__a22o_1_94/B2 VSS VDD sky130_fd_sc_hs__mux2_1
Xsky130_fd_sc_hs__mux2_1_437 VDD VSS sky130_fd_sc_hs__mux2_1_437/X sky130_fd_sc_hs__buf_16_16/A
+ sky130_fd_sc_hs__a22o_1_94/B2 sky130_fd_sc_hs__mux2_1_437/A1 VSS VDD sky130_fd_sc_hs__mux2_1
Xsky130_fd_sc_hs__mux2_1_448 VDD VSS sky130_fd_sc_hs__mux2_1_448/X sky130_fd_sc_hs__buf_16_1/X
+ sky130_fd_sc_hs__mux2_1_448/A0 sky130_fd_sc_hs__a22o_1_91/B2 VSS VDD sky130_fd_sc_hs__mux2_1
Xsky130_fd_sc_hs__mux2_1_459 VDD VSS sky130_fd_sc_hs__mux2_1_459/X sky130_fd_sc_hs__buf_16_12/A
+ sky130_fd_sc_hs__mux2_1_459/A0 sky130_fd_sc_hs__a22o_1_91/B2 VSS VDD sky130_fd_sc_hs__mux2_1
Xsky130_fd_sc_hs__a311oi_1_2 VDD VSS sky130_fd_sc_hs__and2_1_4/X sky130_fd_sc_hs__and2_1_3/X
+ sky130_fd_sc_hs__and2_1_5/B sky130_fd_sc_hs__nor2_1_15/Y sky130_fd_sc_hs__or2_1_1/X
+ sky130_fd_sc_hs__o21a_1_5/A2 VSS VDD sky130_fd_sc_hs__a311oi_1
Xsky130_fd_sc_hs__dfrtp_1_230 sky130_fd_sc_hs__buf_8_4/A VDD VSS sky130_fd_sc_hs__dfrtp_1_293/D
+ sky130_fd_sc_hs__clkbuf_2_69/X sky130_fd_sc_hs__nand4_1_2/B VSS VDD sky130_fd_sc_hs__dfrtp_1
Xsky130_fd_sc_hs__dfrtp_1_241 sky130_fd_sc_hs__buf_8_5/X VDD VSS sky130_fd_sc_hs__o211a_2_1/A1
+ sky130_fd_sc_hs__clkbuf_8_2/X sky130_fd_sc_hs__o211a_2_1/X VSS VDD sky130_fd_sc_hs__dfrtp_1
Xsky130_fd_sc_hs__dfrtp_1_252 sky130_fd_sc_hs__buf_8_5/X VDD VSS sky130_fd_sc_hs__a22o_1_29/A1
+ sky130_fd_sc_hs__clkbuf_8_4/X sky130_fd_sc_hs__a22o_1_29/X VSS VDD sky130_fd_sc_hs__dfrtp_1
Xsky130_fd_sc_hs__dfrtp_1_263 sky130_fd_sc_hs__buf_2_0/A VDD VSS sky130_fd_sc_hs__nor2_1_40/B
+ sky130_fd_sc_hs__clkbuf_2_78/X sky130_fd_sc_hs__or2_1_8/A VSS VDD sky130_fd_sc_hs__dfrtp_1
Xsky130_fd_sc_hs__dfrtp_1_274 sky130_fd_sc_hs__buf_2_0/A VDD VSS sky130_fd_sc_hs__nor2_1_55/A
+ sky130_fd_sc_hs__clkbuf_2_78/X sky130_fd_sc_hs__a21oi_1_68/Y VSS VDD sky130_fd_sc_hs__dfrtp_1
Xsky130_fd_sc_hs__dfrtp_1_285 sky130_fd_sc_hs__buf_2_0/A VDD VSS sky130_fd_sc_hs__xnor2_1_48/A
+ sky130_fd_sc_hs__clkbuf_2_73/X sky130_fd_sc_hs__dfrtp_1_285/D VSS VDD sky130_fd_sc_hs__dfrtp_1
Xsky130_fd_sc_hs__dfrtp_1_296 sky130_fd_sc_hs__clkbuf_4_14/X VDD VSS sky130_fd_sc_hs__mux2_1_61/A0
+ sky130_fd_sc_hs__clkinv_1_52/A sky130_fd_sc_hs__a22o_1_32/X VSS VDD sky130_fd_sc_hs__dfrtp_1
Xsky130_fd_sc_hs__clkinv_1_40 VDD VSS sky130_fd_sc_hs__clkinv_1_40/A sky130_fd_sc_hs__clkinv_1_40/Y
+ VSS VDD sky130_fd_sc_hs__clkinv_1
Xsky130_fd_sc_hs__clkinv_1_51 VDD VSS sky130_fd_sc_hs__clkinv_1_51/A sky130_fd_sc_hs__clkinv_1_51/Y
+ VSS VDD sky130_fd_sc_hs__clkinv_1
Xsky130_fd_sc_hs__clkbuf_2_4 VDD VSS sky130_fd_sc_hs__clkbuf_2_4/X sky130_fd_sc_hs__clkinv_4_0/A
+ VSS VDD sky130_fd_sc_hs__clkbuf_2
Xsky130_fd_sc_hs__clkinv_1_62 VDD VSS sky130_fd_sc_hs__a31o_1_6/B1 sky130_fd_sc_hs__nand2_1_74/B
+ VSS VDD sky130_fd_sc_hs__clkinv_1
Xsky130_fd_sc_hs__a22o_1_15 VDD VSS sky130_fd_sc_hs__a22o_1_15/X sky130_fd_sc_hs__a22o_1_15/B2
+ sky130_fd_sc_hs__nand3_1_11/Y sky130_fd_sc_hs__a32o_1_2/B1 sky130_fd_sc_hs__maj3_1_4/A
+ VSS VDD sky130_fd_sc_hs__a22o_1
Xsky130_fd_sc_hs__clkinv_1_73 VDD VSS sky130_fd_sc_hs__clkinv_1_73/A sky130_fd_sc_hs__clkinv_1_73/Y
+ VSS VDD sky130_fd_sc_hs__clkinv_1
Xsky130_fd_sc_hs__clkinv_1_84 VDD VSS sky130_fd_sc_hs__clkinv_1_84/A sky130_fd_sc_hs__clkinv_1_84/Y
+ VSS VDD sky130_fd_sc_hs__clkinv_1
Xsky130_fd_sc_hs__a22o_1_26 VDD VSS sky130_fd_sc_hs__a22o_1_26/X sky130_fd_sc_hs__nor2_1_7/A
+ sky130_fd_sc_hs__a22o_1_6/B1 sky130_fd_sc_hs__nor2_2_0/Y sky130_fd_sc_hs__buf_1_64/A
+ VSS VDD sky130_fd_sc_hs__a22o_1
Xsky130_fd_sc_hs__a22o_1_37 VDD VSS sky130_fd_sc_hs__a22o_1_37/X sky130_fd_sc_hs__mux2_1_85/A0
+ sky130_fd_sc_hs__buf_8_17/X sky130_fd_sc_hs__buf_8_15/X sky130_fd_sc_hs__a22o_1_47/B2
+ VSS VDD sky130_fd_sc_hs__a22o_1
Xsky130_fd_sc_hs__clkinv_1_95 VDD VSS sky130_fd_sc_hs__clkinv_1_95/A sky130_fd_sc_hs__clkinv_1_95/Y
+ VSS VDD sky130_fd_sc_hs__clkinv_1
Xsky130_fd_sc_hs__a22o_1_48 VDD VSS sky130_fd_sc_hs__a22o_1_48/X sky130_fd_sc_hs__a22o_1_48/B2
+ sky130_fd_sc_hs__a22o_1_93/B1 sky130_fd_sc_hs__a22o_1_93/A2 sky130_fd_sc_hs__maj3_1_22/C
+ VSS VDD sky130_fd_sc_hs__a22o_1
Xsky130_fd_sc_hs__o21ai_1_2 VDD VSS sky130_fd_sc_hs__o21ai_1_2/Y sky130_fd_sc_hs__buf_8_2/X
+ sky130_fd_sc_hs__buf_8_10/X sky130_fd_sc_hs__maj3_1_2/A VSS VDD sky130_fd_sc_hs__o21ai_1
Xsky130_fd_sc_hs__clkbuf_2_15 VDD VSS sky130_fd_sc_hs__clkbuf_2_15/X sky130_fd_sc_hs__clkbuf_2_3/A
+ VSS VDD sky130_fd_sc_hs__clkbuf_2
Xsky130_fd_sc_hs__a22o_1_59 VDD VSS sky130_fd_sc_hs__a22o_1_59/X sky130_fd_sc_hs__a22o_1_62/A1
+ sky130_fd_sc_hs__a22o_1_93/B1 sky130_fd_sc_hs__a22o_1_93/A2 sky130_fd_sc_hs__xor2_1_43/A
+ VSS VDD sky130_fd_sc_hs__a22o_1
Xsky130_fd_sc_hs__clkbuf_2_26 VDD VSS sky130_fd_sc_hs__clkinv_1_11/A sky130_fd_sc_hs__clkbuf_2_3/A
+ VSS VDD sky130_fd_sc_hs__clkbuf_2
Xsky130_fd_sc_hs__clkbuf_2_37 VDD VSS sky130_fd_sc_hs__clkbuf_2_37/X sky130_fd_sc_hs__clkinv_4_4/A
+ VSS VDD sky130_fd_sc_hs__clkbuf_2
Xsky130_fd_sc_hs__clkbuf_2_48 VDD VSS sky130_fd_sc_hs__clkinv_1_36/A sky130_fd_sc_hs__clkinv_4_1/A
+ VSS VDD sky130_fd_sc_hs__clkbuf_2
Xsky130_fd_sc_hs__clkbuf_2_59 VDD VSS sky130_fd_sc_hs__clkinv_2_2/A sky130_fd_sc_hs__clkinv_4_1/A
+ VSS VDD sky130_fd_sc_hs__clkbuf_2
Xsky130_fd_sc_hs__nand4_1_9 VDD VSS sky130_fd_sc_hs__nand4_1_9/C sky130_fd_sc_hs__nand4_1_9/Y
+ sky130_fd_sc_hs__nand4_1_9/D sky130_fd_sc_hs__nor3_1_48/B sky130_fd_sc_hs__nor3_1_48/A
+ VSS VDD sky130_fd_sc_hs__nand4_1
Xsky130_fd_sc_hs__clkinv_2_4 VDD VSS sky130_fd_sc_hs__clkinv_2_4/Y sky130_fd_sc_hs__clkinv_2_4/A
+ VSS VDD sky130_fd_sc_hs__clkinv_2
Xsky130_fd_sc_hs__o21ai_1_100 VDD VSS sky130_fd_sc_hs__o21ai_1_100/Y sky130_fd_sc_hs__o21a_1_4/B1
+ sky130_fd_sc_hs__a21oi_1_197/Y sky130_fd_sc_hs__a21oi_1_196/Y VSS VDD sky130_fd_sc_hs__o21ai_1
Xsky130_fd_sc_hs__o21ai_1_111 VDD VSS sky130_fd_sc_hs__o21ai_1_111/Y sky130_fd_sc_hs__a21oi_1_203/Y
+ sky130_fd_sc_hs__o2bb2ai_1_73/Y sky130_fd_sc_hs__nor2_1_180/A VSS VDD sky130_fd_sc_hs__o21ai_1
Xsky130_fd_sc_hs__mux2_1_201 VDD VSS sky130_fd_sc_hs__mux2_1_201/X sky130_fd_sc_hs__nor2_1_82/B
+ sky130_fd_sc_hs__xor2_1_30/A sky130_fd_sc_hs__o21a_1_15/X VSS VDD sky130_fd_sc_hs__mux2_1
Xsky130_fd_sc_hs__mux2_1_212 VDD VSS sky130_fd_sc_hs__mux2_1_212/X sky130_fd_sc_hs__mux2_1_94/S
+ sky130_fd_sc_hs__or2_1_1/B sky130_fd_sc_hs__mux2_1_98/A1 VSS VDD sky130_fd_sc_hs__mux2_1
Xsky130_fd_sc_hs__nand2_1_15 VDD VSS sky130_fd_sc_hs__xnor3_1_0/C sky130_fd_sc_hs__nand2_1_15/Y
+ sky130_fd_sc_hs__maj3_1_8/A VSS VDD sky130_fd_sc_hs__nand2_1
Xsky130_fd_sc_hs__mux2_1_223 VDD VSS sky130_fd_sc_hs__mux2_1_223/X sky130_fd_sc_hs__nor2_1_66/B
+ sky130_fd_sc_hs__xor2_1_41/B sky130_fd_sc_hs__a21oi_1_19/Y VSS VDD sky130_fd_sc_hs__mux2_1
Xsky130_fd_sc_hs__mux2_1_234 VDD VSS sky130_fd_sc_hs__mux2_1_234/X sky130_fd_sc_hs__nor2_1_66/B
+ sky130_fd_sc_hs__xor2_1_59/B sky130_fd_sc_hs__nor2_1_79/Y VSS VDD sky130_fd_sc_hs__mux2_1
Xsky130_fd_sc_hs__nand2_1_26 VDD VSS sky130_fd_sc_hs__nand2_1_26/B sky130_fd_sc_hs__nand2_1_26/Y
+ sky130_fd_sc_hs__nand2_1_26/A VSS VDD sky130_fd_sc_hs__nand2_1
Xsky130_fd_sc_hs__mux2_1_245 VDD VSS sky130_fd_sc_hs__mux2_1_245/X sky130_fd_sc_hs__nor2_1_66/B
+ sky130_fd_sc_hs__xor2_1_66/B sky130_fd_sc_hs__nor2_1_80/Y VSS VDD sky130_fd_sc_hs__mux2_1
Xsky130_fd_sc_hs__nand2_1_37 VDD VSS sky130_fd_sc_hs__nor2_1_25/B sky130_fd_sc_hs__nand3b_1_0/C
+ sky130_fd_sc_hs__xor2_1_18/X VSS VDD sky130_fd_sc_hs__nand2_1
Xsky130_fd_sc_hs__mux2_1_256 VDD VSS sky130_fd_sc_hs__mux2_1_256/X sky130_fd_sc_hs__o21a_1_29/B1
+ sky130_fd_sc_hs__buf_1_139/A sky130_fd_sc_hs__a22o_1_40/B2 VSS VDD sky130_fd_sc_hs__mux2_1
Xsky130_fd_sc_hs__nand2_1_48 VDD VSS sky130_fd_sc_hs__nand2_1_48/B sky130_fd_sc_hs__xnor2_1_36/A
+ sky130_fd_sc_hs__nand2_1_50/Y VSS VDD sky130_fd_sc_hs__nand2_1
Xsky130_fd_sc_hs__mux2_1_267 VDD VSS sky130_fd_sc_hs__mux2_1_267/X sky130_fd_sc_hs__mux2_1_98/S
+ sky130_fd_sc_hs__mux2_1_267/A0 sky130_fd_sc_hs__a22o_1_62/B2 VSS VDD sky130_fd_sc_hs__mux2_1
Xsky130_fd_sc_hs__nand2_1_59 VDD VSS sky130_fd_sc_hs__nand2_1_59/B sky130_fd_sc_hs__nand2_1_59/Y
+ sky130_fd_sc_hs__or2_1_0/B VSS VDD sky130_fd_sc_hs__nand2_1
Xsky130_fd_sc_hs__mux2_1_278 VDD VSS sky130_fd_sc_hs__mux2_1_278/X sky130_fd_sc_hs__mux2_1_7/S
+ sky130_fd_sc_hs__mux2_1_278/A0 sky130_fd_sc_hs__a22o_1_84/B2 VSS VDD sky130_fd_sc_hs__mux2_1
Xsky130_fd_sc_hs__mux2_1_289 VDD VSS sky130_fd_sc_hs__mux2_1_289/X sky130_fd_sc_hs__mux2_1_289/S
+ sky130_fd_sc_hs__buf_1_157/A sky130_fd_sc_hs__nor3_4_2/A VSS VDD sky130_fd_sc_hs__mux2_1
Xsky130_fd_sc_hs__xnor2_1_90 VDD VSS sky130_fd_sc_hs__maj3_1_33/C sky130_fd_sc_hs__xnor2_1_90/Y
+ sky130_fd_sc_hs__xor2_1_63/X VSS VDD sky130_fd_sc_hs__xnor2_1
Xsky130_fd_sc_hs__dlygate4sd3_1_16 VSS VDD sky130_fd_sc_hs__dlygate4sd3_1_21/X sky130_fd_sc_hs__buf_1_93/A
+ VSS VDD sky130_fd_sc_hs__dlygate4sd3_1
Xsky130_fd_sc_hs__o21ai_1_16 VDD VSS sky130_fd_sc_hs__o21ai_1_16/Y sky130_fd_sc_hs__a21oi_1_37/Y
+ sky130_fd_sc_hs__nor2b_1_5/Y sky130_fd_sc_hs__nand2_1_45/Y VSS VDD sky130_fd_sc_hs__o21ai_1
Xsky130_fd_sc_hs__o21ai_1_27 VDD VSS sky130_fd_sc_hs__o21ai_1_27/Y sky130_fd_sc_hs__a21oi_1_50/Y
+ sky130_fd_sc_hs__buf_1_22/X sky130_fd_sc_hs__maj3_1_8/A VSS VDD sky130_fd_sc_hs__o21ai_1
Xsky130_fd_sc_hs__o21ai_1_38 VDD VSS sky130_fd_sc_hs__o21ai_1_38/Y sky130_fd_sc_hs__o31a_1_1/A3
+ sky130_fd_sc_hs__o31a_1_1/A2 sky130_fd_sc_hs__o31a_1_1/A1 VSS VDD sky130_fd_sc_hs__o21ai_1
Xsky130_fd_sc_hs__o21ai_1_49 VDD VSS sky130_fd_sc_hs__o21ai_1_49/Y sky130_fd_sc_hs__o221ai_1_1/Y
+ sky130_fd_sc_hs__a31o_1_13/X sky130_fd_sc_hs__o21ai_1_49/A1 VSS VDD sky130_fd_sc_hs__o21ai_1
Xsky130_fd_sc_hs__clkbuf_8_14 VDD VSS sky130_fd_sc_hs__clkbuf_8_14/X sky130_fd_sc_hs__nor3_4_9/Y
+ VSS VDD sky130_fd_sc_hs__clkbuf_8
Xsky130_fd_sc_hs__o211ai_1_16 VDD VSS sky130_fd_sc_hs__o21ai_1_109/Y sky130_fd_sc_hs__o211ai_1_16/Y
+ sky130_fd_sc_hs__buf_8_2/A sky130_fd_sc_hs__buf_8_36/X sky130_fd_sc_hs__xnor3_1_1/A
+ VSS VDD sky130_fd_sc_hs__o211ai_1
Xsky130_fd_sc_hs__and4_1_4 VDD VSS sky130_fd_sc_hs__and4_1_4/A sky130_fd_sc_hs__and4_1_4/B
+ sky130_fd_sc_hs__and4_1_4/C sky130_fd_sc_hs__and4_1_4/D sky130_fd_sc_hs__and4_1_4/X
+ VSS VDD sky130_fd_sc_hs__and4_1
Xsky130_fd_sc_hs__dfrtp_1_807 sky130_fd_sc_hs__buf_8_8/A VDD VSS sky130_fd_sc_hs__mux2_1_207/A0
+ sky130_fd_sc_hs__clkinv_1_60/A sky130_fd_sc_hs__mux2_1_207/X VSS VDD sky130_fd_sc_hs__dfrtp_1
Xsky130_fd_sc_hs__dfrtp_1_818 sky130_fd_sc_hs__clkbuf_4_15/X VDD VSS sky130_fd_sc_hs__mux2_1_479/A0
+ sky130_fd_sc_hs__clkbuf_2_94/X sky130_fd_sc_hs__mux2_1_479/X VSS VDD sky130_fd_sc_hs__dfrtp_1
Xsky130_fd_sc_hs__dfrtp_1_829 sky130_fd_sc_hs__buf_8_1/A VDD VSS sky130_fd_sc_hs__maj3_1_5/A
+ sky130_fd_sc_hs__clkinv_2_0/A sky130_fd_sc_hs__a22o_1_16/X VSS VDD sky130_fd_sc_hs__dfrtp_1
Xsky130_fd_sc_hs__a21oi_1_104 VDD VSS sky130_fd_sc_hs__nor2_1_90/Y sky130_fd_sc_hs__dfrtp_1_424/D
+ sky130_fd_sc_hs__nand2_1_114/Y sky130_fd_sc_hs__buf_8_21/A VSS VDD sky130_fd_sc_hs__a21oi_1
Xsky130_fd_sc_hs__a21oi_1_115 VDD VSS sky130_fd_sc_hs__buf_8_12/X sky130_fd_sc_hs__a22o_1_81/B2
+ sky130_fd_sc_hs__or2_1_17/B sky130_fd_sc_hs__or2_1_17/A VSS VDD sky130_fd_sc_hs__a21oi_1
Xsky130_fd_sc_hs__a21oi_1_126 VDD VSS sky130_fd_sc_hs__nor2_1_110/Y sky130_fd_sc_hs__dfrtp_1_519/D
+ sky130_fd_sc_hs__o21ai_1_98/Y sky130_fd_sc_hs__buf_8_21/X VSS VDD sky130_fd_sc_hs__a21oi_1
Xsky130_fd_sc_hs__a21oi_1_137 VDD VSS sky130_fd_sc_hs__nor2_1_117/Y sky130_fd_sc_hs__dfrtp_1_474/D
+ sky130_fd_sc_hs__o21ai_1_111/Y sky130_fd_sc_hs__buf_8_21/X VSS VDD sky130_fd_sc_hs__a21oi_1
Xsky130_fd_sc_hs__a21oi_1_148 VDD VSS sky130_fd_sc_hs__or2_1_30/X sky130_fd_sc_hs__o22ai_1_2/A2
+ sky130_fd_sc_hs__nor3_1_44/B sky130_fd_sc_hs__or2_1_21/B VSS VDD sky130_fd_sc_hs__a21oi_1
Xsky130_fd_sc_hs__a21oi_1_159 VDD VSS sky130_fd_sc_hs__nor2_1_135/Y sky130_fd_sc_hs__dfrtp_1_484/D
+ sky130_fd_sc_hs__a21oi_1_158/Y sky130_fd_sc_hs__o21a_1_26/A2 VSS VDD sky130_fd_sc_hs__a21oi_1
Xsky130_fd_sc_hs__nand3b_1_0 VDD VSS sky130_fd_sc_hs__nor2_1_25/Y sky130_fd_sc_hs__nand3b_1_0/C
+ sky130_fd_sc_hs__nand3b_1_0/Y sky130_fd_sc_hs__o21ai_1_7/B1 VSS VDD sky130_fd_sc_hs__nand3b_1
Xsky130_fd_sc_hs__clkbuf_2_120 VDD VSS sky130_fd_sc_hs__clkinv_1_82/A sky130_fd_sc_hs__clkinv_4_5/A
+ VSS VDD sky130_fd_sc_hs__clkbuf_2
Xsky130_fd_sc_hs__clkbuf_2_131 VDD VSS sky130_fd_sc_hs__clkinv_2_9/A sky130_fd_sc_hs__clkinv_4_5/A
+ VSS VDD sky130_fd_sc_hs__clkbuf_2
Xsky130_fd_sc_hs__clkbuf_2_142 VDD VSS sky130_fd_sc_hs__clkbuf_2_142/X sky130_fd_sc_hs__clkinv_4_7/A
+ VSS VDD sky130_fd_sc_hs__clkbuf_2
Xsky130_fd_sc_hs__clkbuf_2_153 VDD VSS sky130_fd_sc_hs__clkinv_1_106/A sky130_fd_sc_hs__inv_8_1/A
+ VSS VDD sky130_fd_sc_hs__clkbuf_2
Xsky130_fd_sc_hs__nand2_1_120 VDD VSS sky130_fd_sc_hs__xor3_1_0/X sky130_fd_sc_hs__maj3_1_43/A
+ sky130_fd_sc_hs__maj3_1_48/X VSS VDD sky130_fd_sc_hs__nand2_1
Xsky130_fd_sc_hs__nand2_1_131 VDD VSS sky130_fd_sc_hs__nor2_1_121/Y sky130_fd_sc_hs__nand2_1_131/Y
+ sky130_fd_sc_hs__nor3_1_32/A VSS VDD sky130_fd_sc_hs__nand2_1
Xsky130_fd_sc_hs__clkbuf_2_164 VDD VSS sky130_fd_sc_hs__clkinv_1_114/A sky130_fd_sc_hs__clkbuf_2_176/A
+ VSS VDD sky130_fd_sc_hs__clkbuf_2
Xsky130_fd_sc_hs__nand2_1_142 VDD VSS sky130_fd_sc_hs__nor4b_1_1/B sky130_fd_sc_hs__nand2_1_142/Y
+ sky130_fd_sc_hs__or3_1_4/A VSS VDD sky130_fd_sc_hs__nand2_1
Xsky130_fd_sc_hs__clkbuf_2_175 VDD VSS sky130_fd_sc_hs__o31ai_2_0/B1 sky130_fd_sc_hs__buf_8_3/A
+ VSS VDD sky130_fd_sc_hs__clkbuf_2
Xsky130_fd_sc_hs__nand2_1_153 VDD VSS sky130_fd_sc_hs__nor2_1_127/Y sky130_fd_sc_hs__nand2_1_153/Y
+ sky130_fd_sc_hs__nor3_1_34/Y VSS VDD sky130_fd_sc_hs__nand2_1
Xsky130_fd_sc_hs__clkbuf_2_186 VDD VSS sky130_fd_sc_hs__clkinv_1_130/A sky130_fd_sc_hs__clkbuf_2_236/A
+ VSS VDD sky130_fd_sc_hs__clkbuf_2
Xsky130_fd_sc_hs__nand2_1_164 VDD VSS sky130_fd_sc_hs__nor3_1_40/Y sky130_fd_sc_hs__nand2_1_164/Y
+ sky130_fd_sc_hs__and2_1_36/X VSS VDD sky130_fd_sc_hs__nand2_1
Xsky130_fd_sc_hs__clkbuf_2_197 VDD VSS sky130_fd_sc_hs__clkinv_1_143/A sky130_fd_sc_hs__clkbuf_2_236/A
+ VSS VDD sky130_fd_sc_hs__clkbuf_2
Xsky130_fd_sc_hs__nand2_1_175 VDD VSS sky130_fd_sc_hs__nor2b_1_41/Y sky130_fd_sc_hs__nand2_2_2/B
+ sky130_fd_sc_hs__nor2_2_2/A VSS VDD sky130_fd_sc_hs__nand2_1
Xsky130_fd_sc_hs__nand2_1_186 VDD VSS sky130_fd_sc_hs__xnor2_1_119/Y sky130_fd_sc_hs__nor2_2_5/B
+ sky130_fd_sc_hs__nor2_1_161/Y VSS VDD sky130_fd_sc_hs__nand2_1
Xsky130_fd_sc_hs__nand2_1_197 VDD VSS sky130_fd_sc_hs__buf_4_5/A sky130_fd_sc_hs__nand4_1_10/A
+ sky130_fd_sc_hs__nand2_1_197/A VSS VDD sky130_fd_sc_hs__nand2_1
Xsky130_fd_sc_hs__maj3_1_2 VDD VSS sky130_fd_sc_hs__maj3_1_2/A sky130_fd_sc_hs__maj3_1_2/B
+ sky130_fd_sc_hs__maj3_1_2/X sky130_fd_sc_hs__maj3_1_2/C VSS VDD sky130_fd_sc_hs__maj3_1
Xsky130_fd_sc_hs__clkinv_1_109 VDD VSS sky130_fd_sc_hs__clkinv_1_109/A sky130_fd_sc_hs__clkinv_1_109/Y
+ VSS VDD sky130_fd_sc_hs__clkinv_1
Xsky130_fd_sc_hs__nor2_2_3 VDD VSS sky130_fd_sc_hs__nor2_2_3/B sky130_fd_sc_hs__buf_4_0/A
+ sky130_fd_sc_hs__nor2_2_3/A VSS VDD sky130_fd_sc_hs__nor2_2
Xsky130_fd_sc_hs__buf_8_10 VDD VSS sky130_fd_sc_hs__buf_8_10/X sky130_fd_sc_hs__buf_8_10/A
+ VSS VDD sky130_fd_sc_hs__buf_8
Xsky130_fd_sc_hs__buf_8_21 VDD VSS sky130_fd_sc_hs__buf_8_21/X sky130_fd_sc_hs__buf_8_21/A
+ VSS VDD sky130_fd_sc_hs__buf_8
Xsky130_fd_sc_hs__buf_8_32 VDD VSS sky130_fd_sc_hs__buf_8_32/X sky130_fd_sc_hs__nor3_4_6/Y
+ VSS VDD sky130_fd_sc_hs__buf_8
Xsky130_fd_sc_hs__dfrtp_1_604 sky130_fd_sc_hs__clkbuf_4_2/X VDD VSS sky130_fd_sc_hs__mux2_1_306/A1
+ sky130_fd_sc_hs__clkinv_1_128/A sky130_fd_sc_hs__mux2_1_306/X VSS VDD sky130_fd_sc_hs__dfrtp_1
Xsky130_fd_sc_hs__dfrtp_1_615 sky130_fd_sc_hs__clkbuf_4_31/X VDD VSS sky130_fd_sc_hs__mux2_1_314/A1
+ sky130_fd_sc_hs__clkinv_1_135/A sky130_fd_sc_hs__mux2_1_314/X VSS VDD sky130_fd_sc_hs__dfrtp_1
Xsky130_fd_sc_hs__dfrtp_1_626 sky130_fd_sc_hs__clkbuf_4_31/X VDD VSS sky130_fd_sc_hs__mux2_1_327/A1
+ sky130_fd_sc_hs__clkinv_1_135/A sky130_fd_sc_hs__mux2_1_327/X VSS VDD sky130_fd_sc_hs__dfrtp_1
Xsky130_fd_sc_hs__dfrtp_1_637 sky130_fd_sc_hs__buf_8_30/X VDD VSS sky130_fd_sc_hs__mux2_1_347/A1
+ sky130_fd_sc_hs__clkinv_1_144/A sky130_fd_sc_hs__mux2_1_347/X VSS VDD sky130_fd_sc_hs__dfrtp_1
Xsky130_fd_sc_hs__dfrtp_1_648 sky130_fd_sc_hs__clkbuf_4_30/X VDD VSS sky130_fd_sc_hs__mux2_1_352/A1
+ sky130_fd_sc_hs__clkinv_1_143/A sky130_fd_sc_hs__mux2_1_352/X VSS VDD sky130_fd_sc_hs__dfrtp_1
Xsky130_fd_sc_hs__dfrtp_1_659 sky130_fd_sc_hs__clkbuf_4_33/X VDD VSS sky130_fd_sc_hs__xor2_1_88/A
+ sky130_fd_sc_hs__clkinv_1_150/A sky130_fd_sc_hs__o31ai_1_19/Y VSS VDD sky130_fd_sc_hs__dfrtp_1
Xsky130_fd_sc_hs__nor2_1_12 VDD VSS sky130_fd_sc_hs__and2_1_2/B sky130_fd_sc_hs__nor2_1_13/B
+ sky130_fd_sc_hs__maj3_1_4/A VSS VDD sky130_fd_sc_hs__nor2_1
Xsky130_fd_sc_hs__nor2_1_23 VDD VSS sky130_fd_sc_hs__and2_1_6/B sky130_fd_sc_hs__nor2_1_23/Y
+ sky130_fd_sc_hs__and2_1_6/A VSS VDD sky130_fd_sc_hs__nor2_1
Xsky130_fd_sc_hs__nor2_1_34 VDD VSS sky130_fd_sc_hs__maj3_1_0/B sky130_fd_sc_hs__nor2_1_34/Y
+ sky130_fd_sc_hs__maj3_1_0/A VSS VDD sky130_fd_sc_hs__nor2_1
Xsky130_fd_sc_hs__nor2_1_45 VDD VSS sky130_fd_sc_hs__nor2_1_45/B sky130_fd_sc_hs__nor2_1_45/Y
+ sky130_fd_sc_hs__nor2_1_47/A VSS VDD sky130_fd_sc_hs__nor2_1
Xsky130_fd_sc_hs__nor2_1_56 VDD VSS sky130_fd_sc_hs__nor2_1_56/B sky130_fd_sc_hs__nor2_1_56/Y
+ sky130_fd_sc_hs__o32a_1_0/A2 VSS VDD sky130_fd_sc_hs__nor2_1
Xsky130_fd_sc_hs__nor2_1_67 VDD VSS sky130_fd_sc_hs__nor2_1_81/Y sky130_fd_sc_hs__or2_1_12/B
+ sky130_fd_sc_hs__or2_1_13/A VSS VDD sky130_fd_sc_hs__nor2_1
Xsky130_fd_sc_hs__nor2_1_78 VDD VSS sky130_fd_sc_hs__nor2_1_78/B sky130_fd_sc_hs__nor2_1_78/Y
+ sky130_fd_sc_hs__or2_1_14/B VSS VDD sky130_fd_sc_hs__nor2_1
Xsky130_fd_sc_hs__nor2_1_89 VDD VSS sky130_fd_sc_hs__buf_8_11/A sky130_fd_sc_hs__nor2_1_89/Y
+ sky130_fd_sc_hs__xor2_1_63/B VSS VDD sky130_fd_sc_hs__nor2_1
Xsky130_fd_sc_hs__xnor2_1_101 VDD VSS sky130_fd_sc_hs__maj3_1_41/X sky130_fd_sc_hs__or2_1_19/B
+ sky130_fd_sc_hs__xnor2_1_101/B VSS VDD sky130_fd_sc_hs__xnor2_1
Xsky130_fd_sc_hs__xnor2_1_112 VDD VSS sky130_fd_sc_hs__maj3_1_50/C sky130_fd_sc_hs__nor2b_1_29/A
+ sky130_fd_sc_hs__xor2_1_62/X VSS VDD sky130_fd_sc_hs__xnor2_1
Xsky130_fd_sc_hs__xnor2_1_123 VDD VSS sky130_fd_sc_hs__and3_1_13/A sky130_fd_sc_hs__xnor2_1_124/B
+ sky130_fd_sc_hs__xnor2_1_126/Y VSS VDD sky130_fd_sc_hs__xnor2_1
Xsky130_fd_sc_hs__xnor2_1_134 VDD VSS sky130_fd_sc_hs__maj3_1_58/X sky130_fd_sc_hs__xnor2_1_135/B
+ sky130_fd_sc_hs__xnor2_1_136/Y VSS VDD sky130_fd_sc_hs__xnor2_1
Xsky130_fd_sc_hs__xnor2_1_145 VDD VSS sky130_fd_sc_hs__xor2_1_89/B sky130_fd_sc_hs__xnor2_1_145/Y
+ sky130_fd_sc_hs__maj3_1_66/C VSS VDD sky130_fd_sc_hs__xnor2_1
Xsky130_fd_sc_hs__mux2_1_30 VDD VSS sky130_fd_sc_hs__mux2_1_30/X sky130_fd_sc_hs__mux2_1_4/S
+ sky130_fd_sc_hs__mux2_1_40/A0 sky130_fd_sc_hs__mux2_1_30/A1 VSS VDD sky130_fd_sc_hs__mux2_1
Xsky130_fd_sc_hs__mux2_1_41 VDD VSS sky130_fd_sc_hs__mux2_1_41/X sky130_fd_sc_hs__mux2_1_7/S
+ sky130_fd_sc_hs__mux2_1_41/A0 sky130_fd_sc_hs__mux2_1_99/A0 VSS VDD sky130_fd_sc_hs__mux2_1
Xsky130_fd_sc_hs__mux2_1_52 VDD VSS sky130_fd_sc_hs__mux2_1_52/X sky130_fd_sc_hs__mux2_1_8/S
+ sky130_fd_sc_hs__mux2_1_52/A0 sky130_fd_sc_hs__mux2_1_61/A0 VSS VDD sky130_fd_sc_hs__mux2_1
Xsky130_fd_sc_hs__mux2_1_63 VDD VSS sky130_fd_sc_hs__mux2_1_63/X sky130_fd_sc_hs__mux2_1_98/S
+ sky130_fd_sc_hs__mux2_1_63/A0 sky130_fd_sc_hs__mux2_1_95/A1 VSS VDD sky130_fd_sc_hs__mux2_1
Xsky130_fd_sc_hs__mux2_1_74 VDD VSS sky130_fd_sc_hs__mux2_1_74/X sky130_fd_sc_hs__buf_16_5/X
+ sky130_fd_sc_hs__mux2_1_74/A0 sky130_fd_sc_hs__mux2_1_94/A1 VSS VDD sky130_fd_sc_hs__mux2_1
Xsky130_fd_sc_hs__mux2_1_85 VDD VSS sky130_fd_sc_hs__mux2_1_85/X sky130_fd_sc_hs__mux2_1_1/S
+ sky130_fd_sc_hs__mux2_1_85/A0 sky130_fd_sc_hs__mux2_1_85/A1 VSS VDD sky130_fd_sc_hs__mux2_1
Xsky130_fd_sc_hs__mux2_1_96 VDD VSS sky130_fd_sc_hs__mux2_1_96/X sky130_fd_sc_hs__mux2_1_1/S
+ sky130_fd_sc_hs__mux2_1_96/A0 sky130_fd_sc_hs__mux2_1_96/A1 VSS VDD sky130_fd_sc_hs__mux2_1
Xsky130_fd_sc_hs__xnor2_1_9 VDD VSS sky130_fd_sc_hs__maj3_1_1/X sky130_fd_sc_hs__xor2_1_7/A
+ sky130_fd_sc_hs__xnor2_1_9/B VSS VDD sky130_fd_sc_hs__xnor2_1
Xsky130_fd_sc_hs__nor2b_1_12 VDD VSS sky130_fd_sc_hs__o31ai_1_7/B1 sky130_fd_sc_hs__o31a_1_1/A3
+ sky130_fd_sc_hs__o31ai_1_7/A3 VSS VDD sky130_fd_sc_hs__nor2b_1
Xsky130_fd_sc_hs__nor2b_1_23 VDD VSS sky130_fd_sc_hs__maj3_1_30/X sky130_fd_sc_hs__nor2b_1_23/Y
+ sky130_fd_sc_hs__xnor2_1_82/Y VSS VDD sky130_fd_sc_hs__nor2b_1
Xsky130_fd_sc_hs__nor2b_1_34 VDD VSS sky130_fd_sc_hs__nor2_1_132/B sky130_fd_sc_hs__o21a_1_26/A2
+ sky130_fd_sc_hs__nor4b_1_1/B VSS VDD sky130_fd_sc_hs__nor2b_1
Xsky130_fd_sc_hs__nor2b_1_45 VDD VSS sky130_fd_sc_hs__nor3_4_2/A sky130_fd_sc_hs__nor2b_1_45/Y
+ sky130_fd_sc_hs__nor2b_1_45/A VSS VDD sky130_fd_sc_hs__nor2b_1
Xsky130_fd_sc_hs__o22ai_1_4 VDD VSS sky130_fd_sc_hs__o22ai_1_5/B1 sky130_fd_sc_hs__nand4_1_5/D
+ sky130_fd_sc_hs__o22ai_1_4/Y sky130_fd_sc_hs__buf_8_37/A sky130_fd_sc_hs__nand4_1_5/C
+ VSS VDD sky130_fd_sc_hs__o22ai_1
Xsky130_fd_sc_hs__conb_1_0 VDD VSS sky130_fd_sc_hs__conb_1_0/LO sky130_fd_sc_hs__conb_1_0/HI
+ VSS VDD sky130_fd_sc_hs__conb_1
Xsky130_fd_sc_hs__or2_1_8 VDD VSS sky130_fd_sc_hs__or2_1_8/B sky130_fd_sc_hs__or2_1_8/A
+ sky130_fd_sc_hs__or2_1_8/X VSS VDD sky130_fd_sc_hs__or2_1
Xsky130_fd_sc_hs__o22ai_1_10 VDD VSS sky130_fd_sc_hs__nand4_1_5/C sky130_fd_sc_hs__o22ai_1_9/B2
+ sky130_fd_sc_hs__buf_1_102/A sky130_fd_sc_hs__nand4_1_5/D sky130_fd_sc_hs__o22ai_1_9/A1
+ VSS VDD sky130_fd_sc_hs__o22ai_1
Xsky130_fd_sc_hs__dfrtp_1_401 sky130_fd_sc_hs__clkbuf_4_19/X VDD VSS sky130_fd_sc_hs__nor2_1_81/B
+ sky130_fd_sc_hs__dfrtp_2_3/CLK sky130_fd_sc_hs__o31ai_1_9/Y VSS VDD sky130_fd_sc_hs__dfrtp_1
Xsky130_fd_sc_hs__dfrtp_1_412 sky130_fd_sc_hs__clkbuf_4_16/X VDD VSS sky130_fd_sc_hs__maj3_1_49/C
+ sky130_fd_sc_hs__clkinv_1_77/A sky130_fd_sc_hs__a22o_1_81/X VSS VDD sky130_fd_sc_hs__dfrtp_1
Xsky130_fd_sc_hs__dfrtp_1_423 sky130_fd_sc_hs__clkbuf_4_16/X VDD VSS sky130_fd_sc_hs__a22o_1_88/A1
+ sky130_fd_sc_hs__clkinv_1_82/A sky130_fd_sc_hs__a22o_1_112/X VSS VDD sky130_fd_sc_hs__dfrtp_1
Xsky130_fd_sc_hs__dfrtp_1_434 sky130_fd_sc_hs__clkbuf_4_56/X VDD VSS sky130_fd_sc_hs__nor2_1_81/A
+ sky130_fd_sc_hs__clkbuf_2_112/X sky130_fd_sc_hs__o31ai_1_11/Y VSS VDD sky130_fd_sc_hs__dfrtp_1
Xsky130_fd_sc_hs__dfrtp_1_445 sky130_fd_sc_hs__buf_8_7/A VDD VSS sky130_fd_sc_hs__maj3_1_36/C
+ sky130_fd_sc_hs__clkinv_1_89/A sky130_fd_sc_hs__a22o_1_98/X VSS VDD sky130_fd_sc_hs__dfrtp_1
Xsky130_fd_sc_hs__dfrtp_1_456 sky130_fd_sc_hs__clkbuf_4_13/X VDD VSS sky130_fd_sc_hs__buf_1_145/A
+ sky130_fd_sc_hs__clkbuf_2_132/X sky130_fd_sc_hs__buf_1_90/X VSS VDD sky130_fd_sc_hs__dfrtp_1
Xsky130_fd_sc_hs__dfrtp_1_467 sky130_fd_sc_hs__clkbuf_4_22/X VDD VSS sky130_fd_sc_hs__xor2_1_69/B
+ sky130_fd_sc_hs__clkbuf_2_139/X sky130_fd_sc_hs__dfrtp_1_467/D VSS VDD sky130_fd_sc_hs__dfrtp_1
Xsky130_fd_sc_hs__dfrtp_1_478 sky130_fd_sc_hs__clkbuf_4_23/A VDD VSS sky130_fd_sc_hs__or3b_1_1/B
+ sky130_fd_sc_hs__clkbuf_2_147/A sky130_fd_sc_hs__a32o_1_9/X VSS VDD sky130_fd_sc_hs__dfrtp_1
Xsky130_fd_sc_hs__dfrtp_1_489 sky130_fd_sc_hs__clkbuf_4_23/X VDD VSS sky130_fd_sc_hs__o22ai_1_2/B2
+ sky130_fd_sc_hs__clkbuf_2_155/X sky130_fd_sc_hs__dfrtp_1_489/D VSS VDD sky130_fd_sc_hs__dfrtp_1
Xsky130_fd_sc_hs__clkbuf_4_8 VDD VSS sky130_fd_sc_hs__nor2_2_7/Y sky130_fd_sc_hs__buf_16_14/A
+ VSS VDD sky130_fd_sc_hs__clkbuf_4
Xsky130_fd_sc_hs__mux2_1_405 VDD VSS sky130_fd_sc_hs__mux2_1_405/X sky130_fd_sc_hs__buf_16_4/A
+ sky130_fd_sc_hs__a211o_1_2/A1 sky130_fd_sc_hs__a22o_1_88/B2 VSS VDD sky130_fd_sc_hs__mux2_1
Xsky130_fd_sc_hs__mux2_1_416 VDD VSS sky130_fd_sc_hs__mux2_1_416/X sky130_fd_sc_hs__buf_16_15/A
+ sky130_fd_sc_hs__dfrtp_2_2/Q sky130_fd_sc_hs__mux2_1_416/A1 VSS VDD sky130_fd_sc_hs__mux2_1
Xsky130_fd_sc_hs__mux2_1_427 VDD VSS sky130_fd_sc_hs__mux2_1_427/X sky130_fd_sc_hs__buf_16_6/A
+ sky130_fd_sc_hs__mux2_1_427/A0 sky130_fd_sc_hs__a22o_1_88/B2 VSS VDD sky130_fd_sc_hs__mux2_1
Xsky130_fd_sc_hs__mux2_1_438 VDD VSS sky130_fd_sc_hs__mux2_1_438/X sky130_fd_sc_hs__buf_16_5/A
+ sky130_fd_sc_hs__mux2_1_438/A0 sky130_fd_sc_hs__a22o_1_94/B2 VSS VDD sky130_fd_sc_hs__mux2_1
Xsky130_fd_sc_hs__mux2_1_449 VDD VSS sky130_fd_sc_hs__mux2_1_449/X sky130_fd_sc_hs__buf_16_16/A
+ sky130_fd_sc_hs__a22o_1_91/B2 sky130_fd_sc_hs__mux2_1_449/A1 VSS VDD sky130_fd_sc_hs__mux2_1
Xsky130_fd_sc_hs__a311oi_1_3 VDD VSS sky130_fd_sc_hs__nor2_1_48/A sky130_fd_sc_hs__a21oi_1_60/Y
+ sky130_fd_sc_hs__and2_1_16/X sky130_fd_sc_hs__and3_1_7/X sky130_fd_sc_hs__nand4_1_2/B
+ sky130_fd_sc_hs__a311oi_1_3/Y VSS VDD sky130_fd_sc_hs__a311oi_1
Xsky130_fd_sc_hs__dfrtp_1_220 sky130_fd_sc_hs__buf_8_4/X VDD VSS sky130_fd_sc_hs__a22o_1_25/A1
+ sky130_fd_sc_hs__clkbuf_2_67/X sky130_fd_sc_hs__a22o_1_25/X VSS VDD sky130_fd_sc_hs__dfrtp_1
Xsky130_fd_sc_hs__dfrtp_1_231 sky130_fd_sc_hs__buf_8_4/A VDD VSS sky130_fd_sc_hs__dfrtp_1_231/Q
+ sky130_fd_sc_hs__clkbuf_2_69/X sky130_fd_sc_hs__a21o_1_1/A1 VSS VDD sky130_fd_sc_hs__dfrtp_1
Xsky130_fd_sc_hs__dfrtp_1_242 sky130_fd_sc_hs__buf_8_4/A VDD VSS sky130_fd_sc_hs__dfrtp_1_294/D
+ sky130_fd_sc_hs__clkbuf_2_72/X sky130_fd_sc_hs__and2_1_15/A VSS VDD sky130_fd_sc_hs__dfrtp_1
Xsky130_fd_sc_hs__dfrtp_1_253 sky130_fd_sc_hs__buf_8_5/X VDD VSS sky130_fd_sc_hs__a22o_1_28/A1
+ sky130_fd_sc_hs__clkbuf_8_4/X sky130_fd_sc_hs__a22o_1_28/X VSS VDD sky130_fd_sc_hs__dfrtp_1
Xsky130_fd_sc_hs__dfrtp_1_264 sky130_fd_sc_hs__buf_2_0/A VDD VSS sky130_fd_sc_hs__o32a_1_0/A1
+ sky130_fd_sc_hs__clkbuf_2_81/X sky130_fd_sc_hs__nor2_1_56/Y VSS VDD sky130_fd_sc_hs__dfrtp_1
Xsky130_fd_sc_hs__dfrtp_1_275 sky130_fd_sc_hs__buf_2_0/A VDD VSS sky130_fd_sc_hs__buf_1_62/A
+ sky130_fd_sc_hs__clkinv_1_51/A sky130_fd_sc_hs__nor2_1_54/Y VSS VDD sky130_fd_sc_hs__dfrtp_1
Xsky130_fd_sc_hs__dfrtp_1_286 sky130_fd_sc_hs__buf_8_4/X VDD VSS sky130_fd_sc_hs__and3_1_5/A
+ sky130_fd_sc_hs__clkbuf_2_71/X sky130_fd_sc_hs__nor2_1_50/Y VSS VDD sky130_fd_sc_hs__dfrtp_1
Xsky130_fd_sc_hs__dfrtp_1_297 sky130_fd_sc_hs__buf_8_6/X VDD VSS sky130_fd_sc_hs__dfrtp_2_0/D
+ sky130_fd_sc_hs__clkbuf_8_4/X sky130_fd_sc_hs__conb_1_1/HI VSS VDD sky130_fd_sc_hs__dfrtp_1
Xsky130_fd_sc_hs__clkinv_1_30 VDD VSS sky130_fd_sc_hs__nor2b_1_5/A sky130_fd_sc_hs__o311ai_1_2/B1
+ VSS VDD sky130_fd_sc_hs__clkinv_1
Xsky130_fd_sc_hs__clkinv_1_41 VDD VSS sky130_fd_sc_hs__clkinv_1_41/A sky130_fd_sc_hs__clkinv_1_41/Y
+ VSS VDD sky130_fd_sc_hs__clkinv_1
Xsky130_fd_sc_hs__clkinv_1_52 VDD VSS sky130_fd_sc_hs__clkinv_1_52/A sky130_fd_sc_hs__clkinv_1_52/Y
+ VSS VDD sky130_fd_sc_hs__clkinv_1
Xsky130_fd_sc_hs__clkbuf_2_5 VDD VSS sky130_fd_sc_hs__clkbuf_2_5/X sky130_fd_sc_hs__clkinv_4_0/A
+ VSS VDD sky130_fd_sc_hs__clkbuf_2
Xsky130_fd_sc_hs__clkinv_1_63 VDD VSS sky130_fd_sc_hs__clkinv_1_63/A sky130_fd_sc_hs__clkinv_1_63/Y
+ VSS VDD sky130_fd_sc_hs__clkinv_1
Xsky130_fd_sc_hs__a22o_1_16 VDD VSS sky130_fd_sc_hs__a22o_1_16/X sky130_fd_sc_hs__a22o_1_16/B2
+ sky130_fd_sc_hs__or2_1_4/X sky130_fd_sc_hs__a32o_1_2/B1 sky130_fd_sc_hs__maj3_1_5/A
+ VSS VDD sky130_fd_sc_hs__a22o_1
Xsky130_fd_sc_hs__clkinv_1_74 VDD VSS sky130_fd_sc_hs__dfrtp_2_2/CLK sky130_fd_sc_hs__clkinv_1_74/Y
+ VSS VDD sky130_fd_sc_hs__clkinv_1
Xsky130_fd_sc_hs__clkinv_1_85 VDD VSS sky130_fd_sc_hs__clkinv_1_85/A sky130_fd_sc_hs__clkinv_1_85/Y
+ VSS VDD sky130_fd_sc_hs__clkinv_1
Xsky130_fd_sc_hs__a22o_1_27 VDD VSS sky130_fd_sc_hs__a22o_1_27/X sky130_fd_sc_hs__and2_1_15/X
+ sky130_fd_sc_hs__xor2_1_23/X sky130_fd_sc_hs__nor2_1_48/Y sky130_fd_sc_hs__and3_1_6/B
+ VSS VDD sky130_fd_sc_hs__a22o_1
Xsky130_fd_sc_hs__clkinv_1_96 VDD VSS sky130_fd_sc_hs__nand2b_1_45/Y sky130_fd_sc_hs__clkinv_1_96/Y
+ VSS VDD sky130_fd_sc_hs__clkinv_1
Xsky130_fd_sc_hs__a22o_1_38 VDD VSS sky130_fd_sc_hs__a22o_1_38/X sky130_fd_sc_hs__mux2_1_94/A1
+ sky130_fd_sc_hs__buf_8_17/X sky130_fd_sc_hs__buf_8_15/X sky130_fd_sc_hs__a22o_1_39/B2
+ VSS VDD sky130_fd_sc_hs__a22o_1
Xsky130_fd_sc_hs__a22o_1_49 VDD VSS sky130_fd_sc_hs__a22o_1_49/X sky130_fd_sc_hs__a22o_1_49/B2
+ sky130_fd_sc_hs__a31o_1_5/A2 sky130_fd_sc_hs__a32o_1_7/B1 sky130_fd_sc_hs__maj3_1_23/C
+ VSS VDD sky130_fd_sc_hs__a22o_1
Xsky130_fd_sc_hs__o21ai_1_3 VDD VSS sky130_fd_sc_hs__o21ai_1_3/Y sky130_fd_sc_hs__o21ai_1_3/B1
+ sky130_fd_sc_hs__nor2_1_11/Y sky130_fd_sc_hs__o21ai_1_3/A1 VSS VDD sky130_fd_sc_hs__o21ai_1
Xsky130_fd_sc_hs__clkbuf_2_16 VDD VSS sky130_fd_sc_hs__clkinv_1_6/A sky130_fd_sc_hs__clkbuf_2_92/A
+ VSS VDD sky130_fd_sc_hs__clkbuf_2
Xsky130_fd_sc_hs__clkbuf_2_27 VDD VSS sky130_fd_sc_hs__clkbuf_2_27/X sky130_fd_sc_hs__clkbuf_2_3/A
+ VSS VDD sky130_fd_sc_hs__clkbuf_2
Xsky130_fd_sc_hs__clkbuf_2_38 VDD VSS sky130_fd_sc_hs__clkinv_1_24/A sky130_fd_sc_hs__clkbuf_2_92/A
+ VSS VDD sky130_fd_sc_hs__clkbuf_2
Xsky130_fd_sc_hs__clkbuf_2_49 VDD VSS sky130_fd_sc_hs__clkinv_1_37/A sky130_fd_sc_hs__clkinv_4_1/A
+ VSS VDD sky130_fd_sc_hs__clkbuf_2
Xsky130_fd_sc_hs__clkinv_2_5 VDD VSS sky130_fd_sc_hs__clkinv_2_5/Y sky130_fd_sc_hs__clkinv_2_5/A
+ VSS VDD sky130_fd_sc_hs__clkinv_2
Xsky130_fd_sc_hs__o21ai_1_101 VDD VSS sky130_fd_sc_hs__o21ai_1_101/Y sky130_fd_sc_hs__buf_8_37/X
+ sky130_fd_sc_hs__buf_8_36/X sky130_fd_sc_hs__xor2_1_86/A VSS VDD sky130_fd_sc_hs__o21ai_1
Xsky130_fd_sc_hs__o21ai_1_112 VDD VSS sky130_fd_sc_hs__maj3_1_62/C sky130_fd_sc_hs__nand2_1_224/Y
+ sky130_fd_sc_hs__xnor2_1_147/Y sky130_fd_sc_hs__nand2_1_223/Y VSS VDD sky130_fd_sc_hs__o21ai_1
Xsky130_fd_sc_hs__mux2_1_202 VDD VSS sky130_fd_sc_hs__mux2_1_202/X sky130_fd_sc_hs__nor2_1_66/B
+ sky130_fd_sc_hs__xor2_1_30/B sky130_fd_sc_hs__o21a_1_15/X VSS VDD sky130_fd_sc_hs__mux2_1
Xsky130_fd_sc_hs__mux2_1_213 VDD VSS sky130_fd_sc_hs__mux2_1_213/X sky130_fd_sc_hs__buf_16_0/X
+ sky130_fd_sc_hs__xor2_1_46/B sky130_fd_sc_hs__mux2_1_99/A0 VSS VDD sky130_fd_sc_hs__mux2_1
Xsky130_fd_sc_hs__mux2_1_224 VDD VSS sky130_fd_sc_hs__mux2_1_224/X sky130_fd_sc_hs__buf_16_5/X
+ sky130_fd_sc_hs__mux2_1_224/A0 sky130_fd_sc_hs__a22o_1_64/B2 VSS VDD sky130_fd_sc_hs__mux2_1
Xsky130_fd_sc_hs__nand2_1_16 VDD VSS sky130_fd_sc_hs__nand2_1_16/B sky130_fd_sc_hs__nand2_1_16/Y
+ sky130_fd_sc_hs__nand2_1_16/A VSS VDD sky130_fd_sc_hs__nand2_1
Xsky130_fd_sc_hs__mux2_1_235 VDD VSS sky130_fd_sc_hs__mux2_1_235/X sky130_fd_sc_hs__nor2_1_82/B
+ sky130_fd_sc_hs__xor2_1_60/A sky130_fd_sc_hs__nor2_1_76/Y VSS VDD sky130_fd_sc_hs__mux2_1
Xsky130_fd_sc_hs__nand2_1_27 VDD VSS sky130_fd_sc_hs__o21ai_1_19/Y sky130_fd_sc_hs__nand2_1_27/Y
+ sky130_fd_sc_hs__nand2_1_28/Y VSS VDD sky130_fd_sc_hs__nand2_1
Xsky130_fd_sc_hs__mux2_1_246 VDD VSS sky130_fd_sc_hs__mux2_1_246/X sky130_fd_sc_hs__nor2_1_82/B
+ sky130_fd_sc_hs__xor2_1_66/A sky130_fd_sc_hs__nor2_1_80/Y VSS VDD sky130_fd_sc_hs__mux2_1
Xsky130_fd_sc_hs__nand2_1_38 VDD VSS sky130_fd_sc_hs__or2_1_3/X sky130_fd_sc_hs__xnor2_1_20/B
+ sky130_fd_sc_hs__nand2_1_39/Y VSS VDD sky130_fd_sc_hs__nand2_1
Xsky130_fd_sc_hs__mux2_1_257 VDD VSS sky130_fd_sc_hs__mux2_1_257/X sky130_fd_sc_hs__o21a_1_29/B1
+ sky130_fd_sc_hs__buf_1_129/A sky130_fd_sc_hs__a22o_1_84/B2 VSS VDD sky130_fd_sc_hs__mux2_1
Xsky130_fd_sc_hs__nand2_1_49 VDD VSS sky130_fd_sc_hs__maj3_1_0/B sky130_fd_sc_hs__nand2_1_49/Y
+ sky130_fd_sc_hs__maj3_1_0/A VSS VDD sky130_fd_sc_hs__nand2_1
Xsky130_fd_sc_hs__mux2_1_268 VDD VSS sky130_fd_sc_hs__mux2_1_268/X sky130_fd_sc_hs__o21a_1_29/B1
+ sky130_fd_sc_hs__buf_1_144/A sky130_fd_sc_hs__a22o_1_95/B2 VSS VDD sky130_fd_sc_hs__mux2_1
Xsky130_fd_sc_hs__mux2_1_279 VDD VSS sky130_fd_sc_hs__mux2_1_279/X sky130_fd_sc_hs__o21a_1_29/B1
+ sky130_fd_sc_hs__buf_1_152/A sky130_fd_sc_hs__a22o_1_89/B2 VSS VDD sky130_fd_sc_hs__mux2_1
Xsky130_fd_sc_hs__xnor2_1_80 VDD VSS sky130_fd_sc_hs__nor2_1_77/A sky130_fd_sc_hs__xnor2_1_80/Y
+ sky130_fd_sc_hs__xor2_1_54/X VSS VDD sky130_fd_sc_hs__xnor2_1
Xsky130_fd_sc_hs__xnor2_1_91 VDD VSS sky130_fd_sc_hs__xnor2_1_91/A sky130_fd_sc_hs__xnor2_1_91/Y
+ sky130_fd_sc_hs__xor2_1_64/X VSS VDD sky130_fd_sc_hs__xnor2_1
Xsky130_fd_sc_hs__dlygate4sd3_1_17 VSS VDD raw_bits_i[18] sky130_fd_sc_hs__buf_1_179/A
+ VSS VDD sky130_fd_sc_hs__dlygate4sd3_1
Xsky130_fd_sc_hs__o21ai_1_17 VDD VSS sky130_fd_sc_hs__o21ai_1_17/Y sky130_fd_sc_hs__xnor2_1_16/A
+ sky130_fd_sc_hs__nor2_1_30/Y sky130_fd_sc_hs__and2_1_9/X VSS VDD sky130_fd_sc_hs__o21ai_1
Xsky130_fd_sc_hs__o21ai_1_28 VDD VSS sky130_fd_sc_hs__o21ai_1_28/Y sky130_fd_sc_hs__a21oi_1_51/Y
+ sky130_fd_sc_hs__buf_1_22/X sky130_fd_sc_hs__maj3_1_7/A VSS VDD sky130_fd_sc_hs__o21ai_1
Xsky130_fd_sc_hs__o21ai_1_39 VDD VSS sky130_fd_sc_hs__o21ai_1_39/Y sky130_fd_sc_hs__o21ai_1_39/B1
+ sky130_fd_sc_hs__nor2b_1_18/Y sky130_fd_sc_hs__xnor2_1_73/A VSS VDD sky130_fd_sc_hs__o21ai_1
Xsky130_fd_sc_hs__clkbuf_8_15 VDD VSS sky130_fd_sc_hs__clkbuf_8_15/X sky130_fd_sc_hs__nor3_4_7/Y
+ VSS VDD sky130_fd_sc_hs__clkbuf_8
Xsky130_fd_sc_hs__and4_1_5 VDD VSS sky130_fd_sc_hs__and4_1_5/A sky130_fd_sc_hs__and4_1_5/B
+ sky130_fd_sc_hs__and4_1_5/C sky130_fd_sc_hs__and4_1_5/D sky130_fd_sc_hs__and4_1_5/X
+ VSS VDD sky130_fd_sc_hs__and4_1
Xsky130_fd_sc_hs__dfrtp_1_808 sky130_fd_sc_hs__clkbuf_4_35/X VDD VSS sky130_fd_sc_hs__or3b_1_0/A
+ sky130_fd_sc_hs__clkinv_1_154/A sky130_fd_sc_hs__a32o_1_14/X VSS VDD sky130_fd_sc_hs__dfrtp_1
Xsky130_fd_sc_hs__dfrtp_1_819 sky130_fd_sc_hs__clkbuf_16_5/X VDD VSS sky130_fd_sc_hs__buf_1_178/A
+ sky130_fd_sc_hs__clkinv_1_108/A sky130_fd_sc_hs__o21ai_1_68/Y VSS VDD sky130_fd_sc_hs__dfrtp_1
Xsky130_fd_sc_hs__a21oi_1_105 VDD VSS sky130_fd_sc_hs__nor2_1_84/Y sky130_fd_sc_hs__dfrtp_1_515/D
+ sky130_fd_sc_hs__buf_8_11/A sky130_fd_sc_hs__o21ai_1_91/Y VSS VDD sky130_fd_sc_hs__a21oi_1
Xsky130_fd_sc_hs__a32o_1_10 VDD VSS sky130_fd_sc_hs__a32o_1_10/X sky130_fd_sc_hs__or2_1_30/A
+ sky130_fd_sc_hs__nand4_1_4/Y sky130_fd_sc_hs__a32o_1_10/A2 sky130_fd_sc_hs__buf_8_3/A
+ sky130_fd_sc_hs__a32o_1_10/A3 VSS VDD sky130_fd_sc_hs__a32o_1
Xsky130_fd_sc_hs__a21oi_1_116 VDD VSS sky130_fd_sc_hs__a21oi_1_96/Y sky130_fd_sc_hs__nor2_1_76/B
+ sky130_fd_sc_hs__xnor2_1_78/Y sky130_fd_sc_hs__o21ai_1_7/B1 VSS VDD sky130_fd_sc_hs__a21oi_1
Xsky130_fd_sc_hs__a21oi_1_127 VDD VSS sky130_fd_sc_hs__nor2_1_109/Y sky130_fd_sc_hs__dfrtp_1_468/D
+ sky130_fd_sc_hs__o21ai_1_100/Y sky130_fd_sc_hs__buf_8_21/X VSS VDD sky130_fd_sc_hs__a21oi_1
Xsky130_fd_sc_hs__a21oi_1_138 VDD VSS sky130_fd_sc_hs__nor2_1_175/Y sky130_fd_sc_hs__a32o_1_9/B1
+ sky130_fd_sc_hs__o21a_1_23/A2 sky130_fd_sc_hs__or3b_1_1/A VSS VDD sky130_fd_sc_hs__a21oi_1
Xsky130_fd_sc_hs__a21oi_1_149 VDD VSS sky130_fd_sc_hs__nor3_4_8/C sky130_fd_sc_hs__a21oi_1_149/Y
+ sky130_fd_sc_hs__a22oi_1_60/Y sky130_fd_sc_hs__a22oi_1_65/Y VSS VDD sky130_fd_sc_hs__a21oi_1
Xsky130_fd_sc_hs__nand3b_1_1 VDD VSS sky130_fd_sc_hs__nor2_1_30/Y sky130_fd_sc_hs__nand3b_1_1/C
+ sky130_fd_sc_hs__nand3b_1_1/Y sky130_fd_sc_hs__nor2_1_26/A VSS VDD sky130_fd_sc_hs__nand3b_1
Xsky130_fd_sc_hs__clkbuf_2_110 VDD VSS sky130_fd_sc_hs__dfrtp_2_2/CLK sky130_fd_sc_hs__clkinv_4_6/A
+ VSS VDD sky130_fd_sc_hs__clkbuf_2
Xsky130_fd_sc_hs__clkbuf_2_121 VDD VSS sky130_fd_sc_hs__clkbuf_2_121/X sky130_fd_sc_hs__clkinv_4_7/A
+ VSS VDD sky130_fd_sc_hs__clkbuf_2
Xsky130_fd_sc_hs__clkbuf_2_132 VDD VSS sky130_fd_sc_hs__clkbuf_2_132/X sky130_fd_sc_hs__clkinv_4_5/A
+ VSS VDD sky130_fd_sc_hs__clkbuf_2
Xsky130_fd_sc_hs__clkbuf_2_143 VDD VSS sky130_fd_sc_hs__clkbuf_2_143/X sky130_fd_sc_hs__clkinv_4_7/A
+ VSS VDD sky130_fd_sc_hs__clkbuf_2
Xsky130_fd_sc_hs__nand2_1_110 VDD VSS sky130_fd_sc_hs__nor2_1_94/B sky130_fd_sc_hs__nor2_1_97/A
+ sky130_fd_sc_hs__nor2_1_94/A VSS VDD sky130_fd_sc_hs__nand2_1
Xsky130_fd_sc_hs__clkbuf_2_154 VDD VSS sky130_fd_sc_hs__clkbuf_2_154/X sky130_fd_sc_hs__clkinv_4_7/A
+ VSS VDD sky130_fd_sc_hs__clkbuf_2
Xsky130_fd_sc_hs__nand2_1_121 VDD VSS sky130_fd_sc_hs__buf_8_13/X sky130_fd_sc_hs__nand2_1_122/A
+ sky130_fd_sc_hs__maj3_1_47/C VSS VDD sky130_fd_sc_hs__nand2_1
Xsky130_fd_sc_hs__nand2_1_132 VDD VSS sky130_fd_sc_hs__nor2_1_125/Y sky130_fd_sc_hs__nor2_4_2/B
+ sky130_fd_sc_hs__or2_1_30/B VSS VDD sky130_fd_sc_hs__nand2_1
Xsky130_fd_sc_hs__clkbuf_2_165 VDD VSS sky130_fd_sc_hs__clkinv_1_116/A sky130_fd_sc_hs__clkbuf_2_176/A
+ VSS VDD sky130_fd_sc_hs__clkbuf_2
Xsky130_fd_sc_hs__nand2_1_143 VDD VSS sky130_fd_sc_hs__nand2_1_144/Y sky130_fd_sc_hs__o31ai_1_14/B1
+ sky130_fd_sc_hs__or3_1_4/C VSS VDD sky130_fd_sc_hs__nand2_1
Xsky130_fd_sc_hs__clkbuf_2_176 VDD VSS sky130_fd_sc_hs__clkinv_1_125/A sky130_fd_sc_hs__clkbuf_2_176/A
+ VSS VDD sky130_fd_sc_hs__clkbuf_2
Xsky130_fd_sc_hs__nand2_1_154 VDD VSS sky130_fd_sc_hs__a22oi_1_62/Y sky130_fd_sc_hs__nand2_1_154/Y
+ sky130_fd_sc_hs__a22oi_1_66/Y VSS VDD sky130_fd_sc_hs__nand2_1
Xsky130_fd_sc_hs__clkbuf_2_187 VDD VSS sky130_fd_sc_hs__clkbuf_2_187/X sky130_fd_sc_hs__clkbuf_2_239/X
+ VSS VDD sky130_fd_sc_hs__clkbuf_2
Xsky130_fd_sc_hs__nand2_1_165 VDD VSS sky130_fd_sc_hs__and2_1_37/X sky130_fd_sc_hs__nand2_1_165/Y
+ sky130_fd_sc_hs__and2_1_36/X VSS VDD sky130_fd_sc_hs__nand2_1
Xsky130_fd_sc_hs__clkbuf_2_198 VDD VSS sky130_fd_sc_hs__clkinv_1_144/A sky130_fd_sc_hs__clkbuf_2_236/A
+ VSS VDD sky130_fd_sc_hs__clkbuf_2
Xsky130_fd_sc_hs__nand2_1_176 VDD VSS sky130_fd_sc_hs__nor2_1_159/Y sky130_fd_sc_hs__nor2_2_3/B
+ sky130_fd_sc_hs__xor2_1_79/X VSS VDD sky130_fd_sc_hs__nand2_1
Xsky130_fd_sc_hs__nand2_1_187 VDD VSS sky130_fd_sc_hs__buf_4_2/A sky130_fd_sc_hs__nand2_1_187/Y
+ sky130_fd_sc_hs__buf_4_6/X VSS VDD sky130_fd_sc_hs__nand2_1
Xsky130_fd_sc_hs__nand2_1_198 VDD VSS sky130_fd_sc_hs__nand2_1_198/B sky130_fd_sc_hs__o2111a_1_0/B1
+ sky130_fd_sc_hs__nand2_1_198/A VSS VDD sky130_fd_sc_hs__nand2_1
Xsky130_fd_sc_hs__maj3_1_3 VDD VSS sky130_fd_sc_hs__or2_1_1/A sky130_fd_sc_hs__or2_1_1/B
+ sky130_fd_sc_hs__xor2_1_2/A sky130_fd_sc_hs__maj3_1_3/C VSS VDD sky130_fd_sc_hs__maj3_1
Xsky130_fd_sc_hs__nor2_2_4 VDD VSS sky130_fd_sc_hs__or2_1_26/X sky130_fd_sc_hs__nor2_2_4/Y
+ sky130_fd_sc_hs__or3_1_6/A VSS VDD sky130_fd_sc_hs__nor2_2
Xsky130_fd_sc_hs__buf_8_11 VDD VSS sky130_fd_sc_hs__buf_8_11/X sky130_fd_sc_hs__buf_8_11/A
+ VSS VDD sky130_fd_sc_hs__buf_8
Xsky130_fd_sc_hs__buf_8_22 VDD VSS sky130_fd_sc_hs__buf_8_22/X sky130_fd_sc_hs__nor3_4_0/Y
+ VSS VDD sky130_fd_sc_hs__buf_8
Xsky130_fd_sc_hs__buf_8_33 VDD VSS sky130_fd_sc_hs__buf_8_33/X sky130_fd_sc_hs__nor3_4_8/Y
+ VSS VDD sky130_fd_sc_hs__buf_8
Xsky130_fd_sc_hs__dfrtp_1_605 sky130_fd_sc_hs__clkbuf_4_30/X VDD VSS sky130_fd_sc_hs__mux2_1_309/A0
+ sky130_fd_sc_hs__clkinv_1_131/A sky130_fd_sc_hs__mux2_1_309/X VSS VDD sky130_fd_sc_hs__dfrtp_1
Xsky130_fd_sc_hs__dfrtp_1_616 sky130_fd_sc_hs__clkbuf_4_31/X VDD VSS sky130_fd_sc_hs__mux2_1_312/A1
+ sky130_fd_sc_hs__clkinv_1_133/A sky130_fd_sc_hs__mux2_1_312/X VSS VDD sky130_fd_sc_hs__dfrtp_1
Xsky130_fd_sc_hs__dfrtp_1_627 sky130_fd_sc_hs__clkbuf_4_31/X VDD VSS sky130_fd_sc_hs__mux2_1_332/A0
+ sky130_fd_sc_hs__clkbuf_2_192/A sky130_fd_sc_hs__mux2_1_332/X VSS VDD sky130_fd_sc_hs__dfrtp_1
Xsky130_fd_sc_hs__dfrtp_1_638 sky130_fd_sc_hs__clkbuf_4_30/X VDD VSS sky130_fd_sc_hs__mux2_1_342/A1
+ sky130_fd_sc_hs__clkinv_1_144/A sky130_fd_sc_hs__mux2_1_342/X VSS VDD sky130_fd_sc_hs__dfrtp_1
Xsky130_fd_sc_hs__dfrtp_1_649 sky130_fd_sc_hs__clkbuf_4_31/X VDD VSS sky130_fd_sc_hs__mux2_1_321/A0
+ sky130_fd_sc_hs__clkinv_1_130/A sky130_fd_sc_hs__mux2_1_321/X VSS VDD sky130_fd_sc_hs__dfrtp_1
Xsky130_fd_sc_hs__nor2_1_13 VDD VSS sky130_fd_sc_hs__nor2_1_13/B sky130_fd_sc_hs__nor2_1_13/Y
+ sky130_fd_sc_hs__and2_1_2/X VSS VDD sky130_fd_sc_hs__nor2_1
Xsky130_fd_sc_hs__nor2_1_24 VDD VSS sky130_fd_sc_hs__and2_1_7/B sky130_fd_sc_hs__nor2_1_24/Y
+ sky130_fd_sc_hs__and2_1_7/A VSS VDD sky130_fd_sc_hs__nor2_1
Xsky130_fd_sc_hs__nor2_1_35 VDD VSS sky130_fd_sc_hs__buf_1_22/X sky130_fd_sc_hs__nor2_1_35/Y
+ sky130_fd_sc_hs__maj3_1_9/A VSS VDD sky130_fd_sc_hs__nor2_1
Xsky130_fd_sc_hs__nor2_1_46 VDD VSS sky130_fd_sc_hs__nor2_1_46/B sky130_fd_sc_hs__nor2_1_46/Y
+ sky130_fd_sc_hs__nor2_2_1/B VSS VDD sky130_fd_sc_hs__nor2_1
Xsky130_fd_sc_hs__nor2_1_57 VDD VSS sky130_fd_sc_hs__nor2_1_57/B sky130_fd_sc_hs__nor2_1_57/Y
+ sky130_fd_sc_hs__nor2_1_57/A VSS VDD sky130_fd_sc_hs__nor2_1
Xsky130_fd_sc_hs__nor2_1_68 VDD VSS sky130_fd_sc_hs__or2_1_12/B sky130_fd_sc_hs__nor2_1_68/Y
+ sky130_fd_sc_hs__nor2_1_68/A VSS VDD sky130_fd_sc_hs__nor2_1
Xsky130_fd_sc_hs__nor2_1_79 VDD VSS sky130_fd_sc_hs__nor2_1_79/B sky130_fd_sc_hs__nor2_1_79/Y
+ sky130_fd_sc_hs__buf_8_19/X VSS VDD sky130_fd_sc_hs__nor2_1
Xsky130_fd_sc_hs__xnor2_1_102 VDD VSS sky130_fd_sc_hs__xnor2_1_102/A sky130_fd_sc_hs__xnor2_1_102/Y
+ sky130_fd_sc_hs__nor2_1_108/Y VSS VDD sky130_fd_sc_hs__xnor2_1
Xsky130_fd_sc_hs__xnor2_1_113 VDD VSS sky130_fd_sc_hs__maj3_1_68/X sky130_fd_sc_hs__xnor2_1_113/Y
+ sky130_fd_sc_hs__xnor2_1_122/Y VSS VDD sky130_fd_sc_hs__xnor2_1
Xsky130_fd_sc_hs__xnor2_1_124 VDD VSS sky130_fd_sc_hs__maj3_1_68/B sky130_fd_sc_hs__xnor2_1_125/B
+ sky130_fd_sc_hs__xnor2_1_124/B VSS VDD sky130_fd_sc_hs__xnor2_1
Xsky130_fd_sc_hs__xnor2_1_135 VDD VSS sky130_fd_sc_hs__maj3_1_64/X sky130_fd_sc_hs__xnor2_1_135/Y
+ sky130_fd_sc_hs__xnor2_1_135/B VSS VDD sky130_fd_sc_hs__xnor2_1
Xsky130_fd_sc_hs__xnor2_1_146 VDD VSS sky130_fd_sc_hs__nor2_1_183/A sky130_fd_sc_hs__xnor2_1_146/Y
+ sky130_fd_sc_hs__nor2_1_183/B VSS VDD sky130_fd_sc_hs__xnor2_1
Xsky130_fd_sc_hs__mux2_1_20 VDD VSS sky130_fd_sc_hs__mux2_1_20/X sky130_fd_sc_hs__mux2_1_8/S
+ sky130_fd_sc_hs__mux2_1_20/A0 sky130_fd_sc_hs__mux2_1_95/A1 VSS VDD sky130_fd_sc_hs__mux2_1
Xsky130_fd_sc_hs__mux2_1_31 VDD VSS sky130_fd_sc_hs__mux2_1_31/X sky130_fd_sc_hs__mux2_1_8/S
+ sky130_fd_sc_hs__mux2_1_31/A0 sky130_fd_sc_hs__mux2_1_40/A0 VSS VDD sky130_fd_sc_hs__mux2_1
Xsky130_fd_sc_hs__mux2_1_42 VDD VSS sky130_fd_sc_hs__mux2_1_42/X sky130_fd_sc_hs__mux2_1_6/S
+ sky130_fd_sc_hs__mux2_1_99/A0 sky130_fd_sc_hs__mux2_1_42/A1 VSS VDD sky130_fd_sc_hs__mux2_1
Xsky130_fd_sc_hs__mux2_1_53 VDD VSS sky130_fd_sc_hs__mux2_1_53/X sky130_fd_sc_hs__mux2_1_98/S
+ sky130_fd_sc_hs__nand2_1_10/A sky130_fd_sc_hs__mux2_1_85/A0 VSS VDD sky130_fd_sc_hs__mux2_1
Xsky130_fd_sc_hs__mux2_1_64 VDD VSS sky130_fd_sc_hs__mux2_1_64/X sky130_fd_sc_hs__mux2_1_9/S
+ sky130_fd_sc_hs__mux2_1_64/A0 sky130_fd_sc_hs__mux2_1_85/A0 VSS VDD sky130_fd_sc_hs__mux2_1
Xsky130_fd_sc_hs__mux2_1_75 VDD VSS sky130_fd_sc_hs__mux2_1_75/X sky130_fd_sc_hs__mux2_1_1/S
+ sky130_fd_sc_hs__mux2_1_94/A1 sky130_fd_sc_hs__mux2_1_75/A1 VSS VDD sky130_fd_sc_hs__mux2_1
Xsky130_fd_sc_hs__mux2_1_86 VDD VSS sky130_fd_sc_hs__mux2_1_86/X sky130_fd_sc_hs__buf_16_3/A
+ sky130_fd_sc_hs__mux2_1_94/A1 sky130_fd_sc_hs__mux2_1_86/A1 VSS VDD sky130_fd_sc_hs__mux2_1
Xsky130_fd_sc_hs__mux2_1_97 VDD VSS sky130_fd_sc_hs__mux2_1_97/X sky130_fd_sc_hs__buf_16_0/X
+ sky130_fd_sc_hs__maj3_1_3/C sky130_fd_sc_hs__mux2_1_98/A1 VSS VDD sky130_fd_sc_hs__mux2_1
Xsky130_fd_sc_hs__nor2b_1_13 VDD VSS sky130_fd_sc_hs__xor2_1_27/B sky130_fd_sc_hs__a21o_1_2/B1
+ sky130_fd_sc_hs__xor2_1_27/A VSS VDD sky130_fd_sc_hs__nor2b_1
Xsky130_fd_sc_hs__nor2b_1_24 VDD VSS sky130_fd_sc_hs__nor3_1_26/B sky130_fd_sc_hs__nand2_2_1/B
+ sky130_fd_sc_hs__nor3_1_26/A VSS VDD sky130_fd_sc_hs__nor2b_1
Xsky130_fd_sc_hs__nor2b_1_35 VDD VSS sky130_fd_sc_hs__xor2_1_75/A sky130_fd_sc_hs__nand4_1_7/D
+ sky130_fd_sc_hs__nor3_1_38/B VSS VDD sky130_fd_sc_hs__nor2b_1
Xsky130_fd_sc_hs__nor2b_1_46 VDD VSS sky130_fd_sc_hs__xor2_1_79/B sky130_fd_sc_hs__nor2b_1_46/Y
+ sky130_fd_sc_hs__nor3_4_2/A VSS VDD sky130_fd_sc_hs__nor2b_1
Xsky130_fd_sc_hs__o22ai_1_5 VDD VSS sky130_fd_sc_hs__nand4_1_5/C sky130_fd_sc_hs__o22ai_1_5/B1
+ sky130_fd_sc_hs__o22ai_1_5/Y sky130_fd_sc_hs__nand4_1_5/D sky130_fd_sc_hs__buf_8_37/A
+ VSS VDD sky130_fd_sc_hs__o22ai_1
Xsky130_fd_sc_hs__conb_1_1 VDD VSS sky130_fd_sc_hs__conb_1_1/LO sky130_fd_sc_hs__conb_1_1/HI
+ VSS VDD sky130_fd_sc_hs__conb_1
Xsky130_fd_sc_hs__or2_1_9 VDD VSS sky130_fd_sc_hs__or2_1_9/B sky130_fd_sc_hs__or2_1_9/A
+ sky130_fd_sc_hs__or2_1_9/X VSS VDD sky130_fd_sc_hs__or2_1
Xsky130_fd_sc_hs__o22ai_1_11 VDD VSS sky130_fd_sc_hs__nand4_1_5/C sky130_fd_sc_hs__o22ai_1_6/B2
+ sky130_fd_sc_hs__buf_1_116/A sky130_fd_sc_hs__nand4_1_5/D sky130_fd_sc_hs__o22ai_1_6/A1
+ VSS VDD sky130_fd_sc_hs__o22ai_1
Xsky130_fd_sc_hs__dfrtp_1_402 sky130_fd_sc_hs__clkbuf_4_19/X VDD VSS sky130_fd_sc_hs__xor2_1_54/A
+ sky130_fd_sc_hs__dfrtp_2_2/CLK sky130_fd_sc_hs__mux2_1_229/X VSS VDD sky130_fd_sc_hs__dfrtp_1
Xsky130_fd_sc_hs__dfrtp_1_413 sky130_fd_sc_hs__clkbuf_4_16/X VDD VSS sky130_fd_sc_hs__xor2_1_59/A
+ sky130_fd_sc_hs__clkinv_1_77/A sky130_fd_sc_hs__mux2_1_233/X VSS VDD sky130_fd_sc_hs__dfrtp_1
Xsky130_fd_sc_hs__dfrtp_1_424 sky130_fd_sc_hs__clkbuf_4_16/X VDD VSS sky130_fd_sc_hs__xor2_1_63/A
+ sky130_fd_sc_hs__clkbuf_2_121/X sky130_fd_sc_hs__dfrtp_1_424/D VSS VDD sky130_fd_sc_hs__dfrtp_1
Xsky130_fd_sc_hs__dfrtp_1_435 sky130_fd_sc_hs__clkbuf_4_16/X VDD VSS sky130_fd_sc_hs__xor2_1_61/B
+ sky130_fd_sc_hs__clkbuf_2_118/A sky130_fd_sc_hs__mux2_1_237/X VSS VDD sky130_fd_sc_hs__dfrtp_1
Xsky130_fd_sc_hs__dfrtp_1_446 sky130_fd_sc_hs__clkbuf_4_22/X VDD VSS sky130_fd_sc_hs__xor2_1_66/A
+ sky130_fd_sc_hs__clkinv_2_9/A sky130_fd_sc_hs__mux2_1_246/X VSS VDD sky130_fd_sc_hs__dfrtp_1
Xsky130_fd_sc_hs__dfrtp_1_457 sky130_fd_sc_hs__clkbuf_4_22/X VDD VSS sky130_fd_sc_hs__buf_1_160/A
+ sky130_fd_sc_hs__clkinv_1_92/A sky130_fd_sc_hs__buf_1_186/X VSS VDD sky130_fd_sc_hs__dfrtp_1
Xsky130_fd_sc_hs__dfrtp_1_468 sky130_fd_sc_hs__clkbuf_4_22/A VDD VSS sky130_fd_sc_hs__xor2_1_70/A
+ sky130_fd_sc_hs__clkinv_1_98/A sky130_fd_sc_hs__dfrtp_1_468/D VSS VDD sky130_fd_sc_hs__dfrtp_1
Xsky130_fd_sc_hs__dfrtp_1_479 sky130_fd_sc_hs__clkbuf_4_23/X VDD VSS sky130_fd_sc_hs__buf_1_175/A
+ sky130_fd_sc_hs__clkbuf_2_147/A sky130_fd_sc_hs__nand2_1_135/Y VSS VDD sky130_fd_sc_hs__dfrtp_1
Xsky130_fd_sc_hs__clkbuf_4_9 VDD VSS sky130_fd_sc_hs__nor3_4_0/Y sky130_fd_sc_hs__buf_16_1/A
+ VSS VDD sky130_fd_sc_hs__clkbuf_4
Xsky130_fd_sc_hs__mux2_1_406 VDD VSS sky130_fd_sc_hs__mux2_1_406/X sky130_fd_sc_hs__buf_16_14/A
+ sky130_fd_sc_hs__mux2_1_406/A0 sky130_fd_sc_hs__a22o_1_88/B2 VSS VDD sky130_fd_sc_hs__mux2_1
Xsky130_fd_sc_hs__mux2_1_417 VDD VSS sky130_fd_sc_hs__mux2_1_417/X sky130_fd_sc_hs__or2_1_25/X
+ sky130_fd_sc_hs__a22o_1_84/B2 sky130_fd_sc_hs__mux2_1_417/A1 VSS VDD sky130_fd_sc_hs__mux2_1
Xsky130_fd_sc_hs__mux2_1_428 VDD VSS sky130_fd_sc_hs__mux2_1_428/X sky130_fd_sc_hs__buf_16_10/A
+ sky130_fd_sc_hs__mux2_1_428/A0 sky130_fd_sc_hs__a22o_1_94/B2 VSS VDD sky130_fd_sc_hs__mux2_1
Xsky130_fd_sc_hs__mux2_1_439 VDD VSS sky130_fd_sc_hs__mux2_1_439/X sky130_fd_sc_hs__buf_16_2/A
+ sky130_fd_sc_hs__a22o_1_94/B2 sky130_fd_sc_hs__mux2_1_439/A1 VSS VDD sky130_fd_sc_hs__mux2_1
Xsky130_fd_sc_hs__a311oi_1_4 VDD VSS sky130_fd_sc_hs__xor2_1_28/X sky130_fd_sc_hs__a21o_1_2/B1
+ sky130_fd_sc_hs__a21o_1_2/A2 sky130_fd_sc_hs__a31o_1_2/A2 sky130_fd_sc_hs__a31o_1_2/A1
+ sky130_fd_sc_hs__o31a_1_1/A2 VSS VDD sky130_fd_sc_hs__a311oi_1
Xsky130_fd_sc_hs__or2_1_30 VDD VSS sky130_fd_sc_hs__or2_1_30/B sky130_fd_sc_hs__or2_1_30/A
+ sky130_fd_sc_hs__or2_1_30/X VSS VDD sky130_fd_sc_hs__or2_1
Xsky130_fd_sc_hs__dfrtp_1_210 sky130_fd_sc_hs__clkbuf_4_1/X VDD VSS sky130_fd_sc_hs__mux2_1_184/A1
+ sky130_fd_sc_hs__clkinv_1_24/A sky130_fd_sc_hs__mux2_1_184/X VSS VDD sky130_fd_sc_hs__dfrtp_1
Xsky130_fd_sc_hs__dfrtp_1_221 sky130_fd_sc_hs__buf_8_4/A VDD VSS sky130_fd_sc_hs__xor2_1_21/A
+ sky130_fd_sc_hs__dfstp_1_0/CLK sky130_fd_sc_hs__dfrtp_1_231/Q VSS VDD sky130_fd_sc_hs__dfrtp_1
Xsky130_fd_sc_hs__dfrtp_1_232 sky130_fd_sc_hs__buf_8_4/A VDD VSS sky130_fd_sc_hs__dfrtp_1_282/D
+ sky130_fd_sc_hs__clkbuf_2_69/X sky130_fd_sc_hs__dfrtp_1_240/Q VSS VDD sky130_fd_sc_hs__dfrtp_1
Xsky130_fd_sc_hs__dfrtp_1_243 sky130_fd_sc_hs__buf_8_5/X VDD VSS sky130_fd_sc_hs__buf_1_67/A
+ sky130_fd_sc_hs__clkbuf_8_4/X sky130_fd_sc_hs__dfrtp_1_243/D VSS VDD sky130_fd_sc_hs__dfrtp_1
Xsky130_fd_sc_hs__dfrtp_1_254 sky130_fd_sc_hs__clkbuf_4_14/X VDD VSS sky130_fd_sc_hs__a22o_1_48/B2
+ sky130_fd_sc_hs__clkinv_1_63/A sky130_fd_sc_hs__a22o_1_48/X VSS VDD sky130_fd_sc_hs__dfrtp_1
Xsky130_fd_sc_hs__dfrtp_1_265 sky130_fd_sc_hs__clkbuf_4_14/X VDD VSS sky130_fd_sc_hs__mux2_1_96/A0
+ sky130_fd_sc_hs__clkinv_1_52/A sky130_fd_sc_hs__a22o_1_72/X VSS VDD sky130_fd_sc_hs__dfrtp_1
Xsky130_fd_sc_hs__dfrtp_1_276 sky130_fd_sc_hs__buf_2_0/A VDD VSS sky130_fd_sc_hs__xnor2_1_5/A
+ sky130_fd_sc_hs__clkinv_1_51/A sky130_fd_sc_hs__dfrtp_1_276/D VSS VDD sky130_fd_sc_hs__dfrtp_1
Xsky130_fd_sc_hs__dfrtp_1_287 sky130_fd_sc_hs__buf_2_0/A VDD VSS sky130_fd_sc_hs__xnor2_1_50/A
+ sky130_fd_sc_hs__clkbuf_2_73/X sky130_fd_sc_hs__dfrtp_1_287/D VSS VDD sky130_fd_sc_hs__dfrtp_1
Xsky130_fd_sc_hs__dfrtp_1_298 sky130_fd_sc_hs__buf_8_6/X VDD VSS sky130_fd_sc_hs__xor2_1_25/A
+ sky130_fd_sc_hs__clkinv_2_4/A sky130_fd_sc_hs__a21oi_1_70/Y VSS VDD sky130_fd_sc_hs__dfrtp_1
Xsky130_fd_sc_hs__clkinv_1_20 VDD VSS sky130_fd_sc_hs__nand3_1_11/A sky130_fd_sc_hs__o21a_1_2/A2
+ VSS VDD sky130_fd_sc_hs__clkinv_1
Xsky130_fd_sc_hs__clkinv_1_31 VDD VSS sky130_fd_sc_hs__nor2_1_26/A sky130_fd_sc_hs__xnor2_1_16/A
+ VSS VDD sky130_fd_sc_hs__clkinv_1
Xsky130_fd_sc_hs__clkinv_1_42 VDD VSS sky130_fd_sc_hs__clkinv_1_42/A sky130_fd_sc_hs__clkinv_1_42/Y
+ VSS VDD sky130_fd_sc_hs__clkinv_1
Xsky130_fd_sc_hs__clkinv_1_53 VDD VSS sky130_fd_sc_hs__clkinv_1_53/A sky130_fd_sc_hs__clkinv_1_53/Y
+ VSS VDD sky130_fd_sc_hs__clkinv_1
Xsky130_fd_sc_hs__clkbuf_2_6 VDD VSS sky130_fd_sc_hs__clkinv_1_3/A sky130_fd_sc_hs__clkinv_4_0/A
+ VSS VDD sky130_fd_sc_hs__clkbuf_2
Xsky130_fd_sc_hs__clkinv_1_64 VDD VSS sky130_fd_sc_hs__clkinv_1_64/A sky130_fd_sc_hs__clkinv_1_64/Y
+ VSS VDD sky130_fd_sc_hs__clkinv_1
Xsky130_fd_sc_hs__clkinv_1_75 VDD VSS sky130_fd_sc_hs__nor2b_1_22/Y sky130_fd_sc_hs__and2_1_24/A
+ VSS VDD sky130_fd_sc_hs__clkinv_1
Xsky130_fd_sc_hs__a22o_1_17 VDD VSS sky130_fd_sc_hs__a22o_1_17/X sky130_fd_sc_hs__xnor2_1_30/Y
+ sky130_fd_sc_hs__nor2_4_3/Y sky130_fd_sc_hs__a32o_1_2/B1 sky130_fd_sc_hs__maj3_1_0/A
+ VSS VDD sky130_fd_sc_hs__a22o_1
Xsky130_fd_sc_hs__a22o_1_28 VDD VSS sky130_fd_sc_hs__a22o_1_28/X sky130_fd_sc_hs__xnor2_1_46/Y
+ sky130_fd_sc_hs__and2_1_14/X sky130_fd_sc_hs__a32o_1_4/B1 sky130_fd_sc_hs__a22o_1_28/A1
+ VSS VDD sky130_fd_sc_hs__a22o_1
Xsky130_fd_sc_hs__clkinv_1_86 VDD VSS sky130_fd_sc_hs__nor2_1_94/B sky130_fd_sc_hs__nor2_1_98/B
+ VSS VDD sky130_fd_sc_hs__clkinv_1
Xsky130_fd_sc_hs__a22o_1_39 VDD VSS sky130_fd_sc_hs__a22o_1_39/X sky130_fd_sc_hs__a22o_1_39/B2
+ sky130_fd_sc_hs__a22o_1_93/B1 sky130_fd_sc_hs__a22o_1_93/A2 sky130_fd_sc_hs__maj3_1_21/C
+ VSS VDD sky130_fd_sc_hs__a22o_1
Xsky130_fd_sc_hs__clkinv_1_97 VDD VSS sky130_fd_sc_hs__clkinv_1_97/A sky130_fd_sc_hs__clkinv_1_97/Y
+ VSS VDD sky130_fd_sc_hs__clkinv_1
Xsky130_fd_sc_hs__o21ai_1_4 VDD VSS sky130_fd_sc_hs__o21ai_1_4/Y sky130_fd_sc_hs__o21ai_1_4/B1
+ sky130_fd_sc_hs__a31oi_1_0/Y sky130_fd_sc_hs__xor2_1_19/X VSS VDD sky130_fd_sc_hs__o21ai_1
Xsky130_fd_sc_hs__clkbuf_2_17 VDD VSS sky130_fd_sc_hs__clkinv_1_5/A sky130_fd_sc_hs__clkbuf_2_92/A
+ VSS VDD sky130_fd_sc_hs__clkbuf_2
Xsky130_fd_sc_hs__clkbuf_2_28 VDD VSS sky130_fd_sc_hs__clkbuf_2_28/X sky130_fd_sc_hs__clkbuf_2_3/A
+ VSS VDD sky130_fd_sc_hs__clkbuf_2
Xsky130_fd_sc_hs__clkbuf_2_39 VDD VSS sky130_fd_sc_hs__clkbuf_2_39/X sky130_fd_sc_hs__clkinv_4_4/A
+ VSS VDD sky130_fd_sc_hs__clkbuf_2
Xsky130_fd_sc_hs__clkinv_2_6 VDD VSS sky130_fd_sc_hs__clkinv_2_6/Y sky130_fd_sc_hs__clkinv_2_6/A
+ VSS VDD sky130_fd_sc_hs__clkinv_2
Xsky130_fd_sc_hs__o21ai_1_102 VDD VSS sky130_fd_sc_hs__o21ai_1_102/Y sky130_fd_sc_hs__a21oi_1_206/Y
+ sky130_fd_sc_hs__xor2_1_89/X sky130_fd_sc_hs__maj3_1_62/C VSS VDD sky130_fd_sc_hs__o21ai_1
Xsky130_fd_sc_hs__o21ai_1_113 VDD VSS sky130_fd_sc_hs__a32o_1_15/A2 sky130_fd_sc_hs__or3_1_9/B
+ sky130_fd_sc_hs__or3_1_9/C sky130_fd_sc_hs__or3_1_9/A VSS VDD sky130_fd_sc_hs__o21ai_1
Xsky130_fd_sc_hs__mux2_1_203 VDD VSS sky130_fd_sc_hs__mux2_1_203/X sky130_fd_sc_hs__nor2_1_82/B
+ sky130_fd_sc_hs__xor2_1_32/A sky130_fd_sc_hs__o21a_1_4/X VSS VDD sky130_fd_sc_hs__mux2_1
Xsky130_fd_sc_hs__mux2_1_214 VDD VSS sky130_fd_sc_hs__mux2_1_214/X sky130_fd_sc_hs__buf_16_5/X
+ sky130_fd_sc_hs__mux2_1_214/A0 sky130_fd_sc_hs__mux2_1_99/A0 VSS VDD sky130_fd_sc_hs__mux2_1
Xsky130_fd_sc_hs__nand2_1_17 VDD VSS sky130_fd_sc_hs__nand2_1_17/B sky130_fd_sc_hs__nand2_1_17/Y
+ sky130_fd_sc_hs__nand2_1_17/A VSS VDD sky130_fd_sc_hs__nand2_1
Xsky130_fd_sc_hs__mux2_1_225 VDD VSS sky130_fd_sc_hs__mux2_1_225/X sky130_fd_sc_hs__nor2_1_66/B
+ sky130_fd_sc_hs__xor2_1_39/B sky130_fd_sc_hs__a21oi_1_43/Y VSS VDD sky130_fd_sc_hs__mux2_1
Xsky130_fd_sc_hs__mux2_1_236 VDD VSS sky130_fd_sc_hs__mux2_1_236/X sky130_fd_sc_hs__nor2_1_66/B
+ sky130_fd_sc_hs__xor2_1_60/B sky130_fd_sc_hs__nor2_1_76/Y VSS VDD sky130_fd_sc_hs__mux2_1
Xsky130_fd_sc_hs__nand2_1_28 VDD VSS sky130_fd_sc_hs__a32o_1_2/B1 sky130_fd_sc_hs__nand2_1_28/Y
+ sky130_fd_sc_hs__maj3_1_1/A VSS VDD sky130_fd_sc_hs__nand2_1
Xsky130_fd_sc_hs__mux2_1_247 VDD VSS sky130_fd_sc_hs__mux2_1_247/X sky130_fd_sc_hs__buf_8_21/X
+ sky130_fd_sc_hs__xor3_1_0/A sky130_fd_sc_hs__mux2_1_248/A1 VSS VDD sky130_fd_sc_hs__mux2_1
Xsky130_fd_sc_hs__nand2_1_39 VDD VSS sky130_fd_sc_hs__or2_1_3/B sky130_fd_sc_hs__nand2_1_39/Y
+ sky130_fd_sc_hs__or2_1_3/A VSS VDD sky130_fd_sc_hs__nand2_1
Xsky130_fd_sc_hs__mux2_1_258 VDD VSS sky130_fd_sc_hs__mux2_1_258/X sky130_fd_sc_hs__buf_16_3/A
+ sky130_fd_sc_hs__a22o_1_62/B2 sky130_fd_sc_hs__mux2_1_258/A1 VSS VDD sky130_fd_sc_hs__mux2_1
Xsky130_fd_sc_hs__mux2_1_269 VDD VSS sky130_fd_sc_hs__mux2_1_269/X sky130_fd_sc_hs__nor2_2_7/Y
+ sky130_fd_sc_hs__mux2_1_269/A0 sky130_fd_sc_hs__a22o_1_62/B2 VSS VDD sky130_fd_sc_hs__mux2_1
Xsky130_fd_sc_hs__nand3_1_0 VDD VSS sky130_fd_sc_hs__nand3_1_0/C sky130_fd_sc_hs__nand3_1_0/Y
+ sky130_fd_sc_hs__nand3_1_0/B sky130_fd_sc_hs__nand3_1_0/A VSS VDD sky130_fd_sc_hs__nand3_1
Xsky130_fd_sc_hs__xnor2_1_70 VDD VSS sky130_fd_sc_hs__and2_1_7/A sky130_fd_sc_hs__xnor2_1_70/Y
+ sky130_fd_sc_hs__xor2_1_46/X VSS VDD sky130_fd_sc_hs__xnor2_1
Xsky130_fd_sc_hs__xnor2_1_81 VDD VSS sky130_fd_sc_hs__xnor2_1_81/A sky130_fd_sc_hs__xnor2_1_81/Y
+ sky130_fd_sc_hs__and2_1_24/X VSS VDD sky130_fd_sc_hs__xnor2_1
Xsky130_fd_sc_hs__xnor2_1_92 VDD VSS sky130_fd_sc_hs__maj3_1_34/A sky130_fd_sc_hs__xor2_1_64/B
+ sky130_fd_sc_hs__xor2_1_65/X VSS VDD sky130_fd_sc_hs__xnor2_1
Xsky130_fd_sc_hs__dlygate4sd3_1_18 VSS VDD raw_bits_i[9] sky130_fd_sc_hs__buf_1_88/A
+ VSS VDD sky130_fd_sc_hs__dlygate4sd3_1
Xsky130_fd_sc_hs__o21ai_1_18 VDD VSS sky130_fd_sc_hs__o21ai_1_18/Y sky130_fd_sc_hs__buf_8_2/X
+ sky130_fd_sc_hs__buf_8_10/X sky130_fd_sc_hs__or2_1_3/A VSS VDD sky130_fd_sc_hs__o21ai_1
Xsky130_fd_sc_hs__o21ai_1_29 VDD VSS sky130_fd_sc_hs__o41ai_1_0/A4 sky130_fd_sc_hs__nor2_1_44/A
+ sky130_fd_sc_hs__nor2_2_1/B sky130_fd_sc_hs__nor2_2_1/A VSS VDD sky130_fd_sc_hs__o21ai_1
Xsky130_fd_sc_hs__clkbuf_8_16 VDD VSS sky130_fd_sc_hs__a222o_1_7/B1 sky130_fd_sc_hs__nor3b_4_0/Y
+ VSS VDD sky130_fd_sc_hs__clkbuf_8
Xsky130_fd_sc_hs__and4_1_6 VDD VSS sky130_fd_sc_hs__and4_1_6/A sky130_fd_sc_hs__and4_1_6/B
+ sky130_fd_sc_hs__and4_1_6/C sky130_fd_sc_hs__and4_1_6/D sky130_fd_sc_hs__and4_1_6/X
+ VSS VDD sky130_fd_sc_hs__and4_1
Xsky130_fd_sc_hs__dfrtp_1_809 sky130_fd_sc_hs__clkbuf_4_5/X VDD VSS sky130_fd_sc_hs__buf_1_190/A
+ sky130_fd_sc_hs__clkinv_1_112/A sky130_fd_sc_hs__mux2_1_477/X VSS VDD sky130_fd_sc_hs__dfrtp_1
Xsky130_fd_sc_hs__a21oi_1_106 VDD VSS sky130_fd_sc_hs__nor2_1_85/Y sky130_fd_sc_hs__dfrtp_1_418/D
+ sky130_fd_sc_hs__o21ai_1_91/Y sky130_fd_sc_hs__buf_8_21/A VSS VDD sky130_fd_sc_hs__a21oi_1
Xsky130_fd_sc_hs__a32o_1_11 VDD VSS sky130_fd_sc_hs__a32o_1_11/X sky130_fd_sc_hs__buf_1_159/A
+ sky130_fd_sc_hs__o21ai_1_81/Y sky130_fd_sc_hs__o31ai_2_0/B1 sky130_fd_sc_hs__nand4_1_9/D
+ sky130_fd_sc_hs__nor2_1_162/Y VSS VDD sky130_fd_sc_hs__a32o_1
Xsky130_fd_sc_hs__a21oi_1_117 VDD VSS sky130_fd_sc_hs__xnor2_1_97/Y sky130_fd_sc_hs__a21oi_1_117/Y
+ sky130_fd_sc_hs__nand3_1_22/C sky130_fd_sc_hs__nand3_1_22/A VSS VDD sky130_fd_sc_hs__a21oi_1
Xsky130_fd_sc_hs__a21oi_1_128 VDD VSS sky130_fd_sc_hs__nor3_1_26/Y sky130_fd_sc_hs__o21ai_1_54/B1
+ sky130_fd_sc_hs__buf_8_13/X sky130_fd_sc_hs__maj3_1_41/C VSS VDD sky130_fd_sc_hs__a21oi_1
Xsky130_fd_sc_hs__a21oi_1_139 VDD VSS sky130_fd_sc_hs__o21ai_1_59/Y sky130_fd_sc_hs__o21ai_1_66/A1
+ sky130_fd_sc_hs__xnor2_1_113/Y sky130_fd_sc_hs__buf_8_36/A VSS VDD sky130_fd_sc_hs__a21oi_1
Xsky130_fd_sc_hs__nand3b_1_2 VDD VSS sky130_fd_sc_hs__nor3_1_33/C sky130_fd_sc_hs__or2_1_30/X
+ sky130_fd_sc_hs__nand3b_1_2/Y sky130_fd_sc_hs__nor3_1_33/A VSS VDD sky130_fd_sc_hs__nand3b_1
Xsky130_fd_sc_hs__clkbuf_2_100 VDD VSS sky130_fd_sc_hs__clkinv_1_69/A sky130_fd_sc_hs__clkinv_4_3/A
+ VSS VDD sky130_fd_sc_hs__clkbuf_2
Xsky130_fd_sc_hs__clkbuf_2_111 VDD VSS sky130_fd_sc_hs__dfrtp_2_3/CLK sky130_fd_sc_hs__clkinv_4_6/A
+ VSS VDD sky130_fd_sc_hs__clkbuf_2
Xsky130_fd_sc_hs__clkbuf_2_122 VDD VSS sky130_fd_sc_hs__buf_8_17/A sky130_fd_sc_hs__o211ai_1_8/Y
+ VSS VDD sky130_fd_sc_hs__clkbuf_2
Xsky130_fd_sc_hs__clkbuf_2_133 VDD VSS sky130_fd_sc_hs__clkinv_1_92/A sky130_fd_sc_hs__clkinv_4_5/A
+ VSS VDD sky130_fd_sc_hs__clkbuf_2
Xsky130_fd_sc_hs__nand2_1_100 VDD VSS sky130_fd_sc_hs__o21ai_1_85/Y sky130_fd_sc_hs__nand2_1_100/Y
+ sky130_fd_sc_hs__nand2_1_234/Y VSS VDD sky130_fd_sc_hs__nand2_1
Xsky130_fd_sc_hs__clkbuf_2_144 VDD VSS sky130_fd_sc_hs__clkbuf_2_144/X sky130_fd_sc_hs__clkinv_4_7/A
+ VSS VDD sky130_fd_sc_hs__clkbuf_2
Xsky130_fd_sc_hs__nand2_1_111 VDD VSS sky130_fd_sc_hs__nor2_1_94/B sky130_fd_sc_hs__nor3_1_26/C
+ sky130_fd_sc_hs__nor2_1_98/A VSS VDD sky130_fd_sc_hs__nand2_1
Xsky130_fd_sc_hs__clkbuf_2_155 VDD VSS sky130_fd_sc_hs__clkbuf_2_155/X sky130_fd_sc_hs__clkinv_4_7/A
+ VSS VDD sky130_fd_sc_hs__clkbuf_2
Xsky130_fd_sc_hs__nand2_1_122 VDD VSS sky130_fd_sc_hs__o21ai_1_55/Y sky130_fd_sc_hs__nand2_1_122/Y
+ sky130_fd_sc_hs__nand2_1_122/A VSS VDD sky130_fd_sc_hs__nand2_1
Xsky130_fd_sc_hs__nand2_1_133 VDD VSS sky130_fd_sc_hs__or3b_1_1/B sky130_fd_sc_hs__nor3_4_7/C
+ sky130_fd_sc_hs__or3b_1_1/A VSS VDD sky130_fd_sc_hs__nand2_1
Xsky130_fd_sc_hs__clkbuf_2_166 VDD VSS sky130_fd_sc_hs__dfstp_1_1/CLK sky130_fd_sc_hs__clkbuf_2_176/A
+ VSS VDD sky130_fd_sc_hs__clkbuf_2
Xsky130_fd_sc_hs__nand2_1_144 VDD VSS sky130_fd_sc_hs__o21ai_1_64/Y sky130_fd_sc_hs__nand2_1_144/Y
+ sky130_fd_sc_hs__nor2_1_132/B VSS VDD sky130_fd_sc_hs__nand2_1
Xsky130_fd_sc_hs__clkbuf_2_177 VDD VSS sky130_fd_sc_hs__clkinv_1_128/A sky130_fd_sc_hs__clkbuf_2_236/A
+ VSS VDD sky130_fd_sc_hs__clkbuf_2
Xsky130_fd_sc_hs__nand2_1_155 VDD VSS sky130_fd_sc_hs__and2_1_37/X sky130_fd_sc_hs__nand2_1_155/Y
+ sky130_fd_sc_hs__nor2_1_127/Y VSS VDD sky130_fd_sc_hs__nand2_1
Xsky130_fd_sc_hs__clkbuf_2_188 VDD VSS sky130_fd_sc_hs__clkinv_1_135/A sky130_fd_sc_hs__clkinv_4_6/A
+ VSS VDD sky130_fd_sc_hs__clkbuf_2
Xsky130_fd_sc_hs__nand2_1_166 VDD VSS sky130_fd_sc_hs__nor2_1_177/Y sky130_fd_sc_hs__nand2_1_166/Y
+ sky130_fd_sc_hs__nor2b_1_50/Y VSS VDD sky130_fd_sc_hs__nand2_1
Xsky130_fd_sc_hs__clkbuf_2_199 VDD VSS sky130_fd_sc_hs__clkinv_1_145/A sky130_fd_sc_hs__clkbuf_2_236/A
+ VSS VDD sky130_fd_sc_hs__clkbuf_2
Xsky130_fd_sc_hs__nand2_1_177 VDD VSS sky130_fd_sc_hs__nor3_1_47/C sky130_fd_sc_hs__or3_1_6/B
+ sky130_fd_sc_hs__nor3_1_48/C VSS VDD sky130_fd_sc_hs__nand2_1
Xsky130_fd_sc_hs__nand2_1_188 VDD VSS sky130_fd_sc_hs__nor2b_1_45/Y sky130_fd_sc_hs__nor2_2_8/B
+ sky130_fd_sc_hs__nor2_1_160/Y VSS VDD sky130_fd_sc_hs__nand2_1
Xsky130_fd_sc_hs__nand2_1_199 VDD VSS sky130_fd_sc_hs__nand2_1_199/B sky130_fd_sc_hs__nand2_1_199/Y
+ sky130_fd_sc_hs__nand2_1_199/A VSS VDD sky130_fd_sc_hs__nand2_1
Xsky130_fd_sc_hs__maj3_1_4 VDD VSS sky130_fd_sc_hs__maj3_1_4/A sky130_fd_sc_hs__xor2_1_1/A
+ sky130_fd_sc_hs__maj3_1_4/X sky130_fd_sc_hs__xor2_1_1/B VSS VDD sky130_fd_sc_hs__maj3_1
Xsky130_fd_sc_hs__nor2_2_5 VDD VSS sky130_fd_sc_hs__nor2_2_5/B sky130_fd_sc_hs__nor2_2_5/Y
+ sky130_fd_sc_hs__or2_1_26/A VSS VDD sky130_fd_sc_hs__nor2_2
Xsky130_fd_sc_hs__buf_8_12 VDD VSS sky130_fd_sc_hs__buf_8_12/X sky130_fd_sc_hs__buf_8_12/A
+ VSS VDD sky130_fd_sc_hs__buf_8
Xsky130_fd_sc_hs__buf_8_23 VDD VSS sky130_fd_sc_hs__buf_8_23/X sky130_fd_sc_hs__nor2_2_4/Y
+ VSS VDD sky130_fd_sc_hs__buf_8
Xsky130_fd_sc_hs__buf_8_34 VDD VSS sky130_fd_sc_hs__buf_8_34/X sky130_fd_sc_hs__buf_8_34/A
+ VSS VDD sky130_fd_sc_hs__buf_8
Xsky130_fd_sc_hs__dfrtp_1_606 sky130_fd_sc_hs__clkbuf_4_30/X VDD VSS sky130_fd_sc_hs__mux2_1_296/A0
+ sky130_fd_sc_hs__clkbuf_2_179/X sky130_fd_sc_hs__mux2_1_296/X VSS VDD sky130_fd_sc_hs__dfrtp_1
Xsky130_fd_sc_hs__dfrtp_1_617 sky130_fd_sc_hs__clkbuf_4_31/X VDD VSS sky130_fd_sc_hs__mux2_1_320/A0
+ sky130_fd_sc_hs__clkbuf_2_185/X sky130_fd_sc_hs__mux2_1_320/X VSS VDD sky130_fd_sc_hs__dfrtp_1
Xsky130_fd_sc_hs__dfrtp_1_628 sky130_fd_sc_hs__clkbuf_4_30/X VDD VSS sky130_fd_sc_hs__mux2_1_333/A1
+ sky130_fd_sc_hs__clkinv_1_141/A sky130_fd_sc_hs__mux2_1_333/X VSS VDD sky130_fd_sc_hs__dfrtp_1
Xsky130_fd_sc_hs__dfrtp_1_639 sky130_fd_sc_hs__clkbuf_4_30/X VDD VSS sky130_fd_sc_hs__mux2_1_338/A0
+ sky130_fd_sc_hs__clkinv_1_141/A sky130_fd_sc_hs__mux2_1_338/X VSS VDD sky130_fd_sc_hs__dfrtp_1
Xsky130_fd_sc_hs__nor2_1_14 VDD VSS sky130_fd_sc_hs__and3_1_4/X sky130_fd_sc_hs__nor2_1_14/Y
+ sky130_fd_sc_hs__nor2_1_14/A VSS VDD sky130_fd_sc_hs__nor2_1
Xsky130_fd_sc_hs__nor2_1_25 VDD VSS sky130_fd_sc_hs__nor2_1_25/B sky130_fd_sc_hs__nor2_1_25/Y
+ sky130_fd_sc_hs__xor2_1_18/X VSS VDD sky130_fd_sc_hs__nor2_1
Xsky130_fd_sc_hs__nor2_1_36 VDD VSS sky130_fd_sc_hs__buf_8_3/X sky130_fd_sc_hs__nor2_1_36/Y
+ sky130_fd_sc_hs__buf_1_58/A VSS VDD sky130_fd_sc_hs__nor2_1
Xsky130_fd_sc_hs__nor2_1_47 VDD VSS sky130_fd_sc_hs__o32a_1_0/A2 sky130_fd_sc_hs__nor2_1_47/Y
+ sky130_fd_sc_hs__nor2_1_47/A VSS VDD sky130_fd_sc_hs__nor2_1
Xsky130_fd_sc_hs__nor2_1_58 VDD VSS sky130_fd_sc_hs__nor2_1_66/B sky130_fd_sc_hs__nor2_1_58/Y
+ sky130_fd_sc_hs__xor2_1_25/B VSS VDD sky130_fd_sc_hs__nor2_1
Xsky130_fd_sc_hs__nor2_1_69 VDD VSS sky130_fd_sc_hs__xor2_1_46/A sky130_fd_sc_hs__nor3_1_20/A
+ sky130_fd_sc_hs__and2_1_7/A VSS VDD sky130_fd_sc_hs__nor2_1
Xsky130_fd_sc_hs__o311ai_1_0 VDD VSS sky130_fd_sc_hs__or3_1_0/B sky130_fd_sc_hs__or3_1_0/A
+ sky130_fd_sc_hs__nand2_1_32/A sky130_fd_sc_hs__o311ai_1_0/B1 sky130_fd_sc_hs__and3_1_1/C
+ sky130_fd_sc_hs__or3_1_0/C VSS VDD sky130_fd_sc_hs__o311ai_1
Xsky130_fd_sc_hs__xnor2_1_103 VDD VSS sky130_fd_sc_hs__maj3_1_42/A sky130_fd_sc_hs__xnor2_1_103/Y
+ sky130_fd_sc_hs__xnor2_1_105/Y VSS VDD sky130_fd_sc_hs__xnor2_1
Xsky130_fd_sc_hs__xnor2_1_114 VDD VSS sky130_fd_sc_hs__xor2_1_80/A sky130_fd_sc_hs__nor3_1_25/B
+ sky130_fd_sc_hs__xor2_1_91/A VSS VDD sky130_fd_sc_hs__xnor2_1
Xsky130_fd_sc_hs__xnor2_1_125 VDD VSS sky130_fd_sc_hs__maj3_1_68/A sky130_fd_sc_hs__xnor2_1_125/Y
+ sky130_fd_sc_hs__xnor2_1_125/B VSS VDD sky130_fd_sc_hs__xnor2_1
Xsky130_fd_sc_hs__xnor2_1_136 VDD VSS sky130_fd_sc_hs__maj3_1_56/A sky130_fd_sc_hs__xnor2_1_136/Y
+ sky130_fd_sc_hs__xor2_1_83/X VSS VDD sky130_fd_sc_hs__xnor2_1
Xsky130_fd_sc_hs__xnor2_1_147 VDD VSS sky130_fd_sc_hs__xnor3_1_1/A sky130_fd_sc_hs__xnor2_1_147/Y
+ sky130_fd_sc_hs__xnor3_1_1/B VSS VDD sky130_fd_sc_hs__xnor2_1
Xsky130_fd_sc_hs__mux2_1_10 VDD VSS sky130_fd_sc_hs__mux2_1_10/X sky130_fd_sc_hs__mux2_1_98/S
+ sky130_fd_sc_hs__dfrtp_1_7/Q sky130_fd_sc_hs__mux2_1_9/A1 VSS VDD sky130_fd_sc_hs__mux2_1
Xsky130_fd_sc_hs__mux2_1_21 VDD VSS sky130_fd_sc_hs__mux2_1_21/X sky130_fd_sc_hs__buf_16_1/A
+ sky130_fd_sc_hs__mux2_1_21/A0 sky130_fd_sc_hs__mux2_1_95/A1 VSS VDD sky130_fd_sc_hs__mux2_1
Xsky130_fd_sc_hs__mux2_1_32 VDD VSS sky130_fd_sc_hs__mux2_1_32/X sky130_fd_sc_hs__mux2_1_99/S
+ sky130_fd_sc_hs__mux2_1_40/A0 sky130_fd_sc_hs__mux2_1_32/A1 VSS VDD sky130_fd_sc_hs__mux2_1
Xsky130_fd_sc_hs__mux2_1_43 VDD VSS sky130_fd_sc_hs__mux2_1_43/X sky130_fd_sc_hs__mux2_1_6/S
+ sky130_fd_sc_hs__mux2_1_85/A0 sky130_fd_sc_hs__mux2_1_43/A1 VSS VDD sky130_fd_sc_hs__mux2_1
Xsky130_fd_sc_hs__mux2_1_54 VDD VSS sky130_fd_sc_hs__mux2_1_54/X sky130_fd_sc_hs__mux2_1_99/S
+ sky130_fd_sc_hs__mux2_1_85/A0 sky130_fd_sc_hs__mux2_1_54/A1 VSS VDD sky130_fd_sc_hs__mux2_1
Xsky130_fd_sc_hs__mux2_1_65 VDD VSS sky130_fd_sc_hs__mux2_1_65/X sky130_fd_sc_hs__buf_16_3/X
+ sky130_fd_sc_hs__mux2_1_9/A1 sky130_fd_sc_hs__mux2_1_65/A1 VSS VDD sky130_fd_sc_hs__mux2_1
Xsky130_fd_sc_hs__mux2_1_76 VDD VSS sky130_fd_sc_hs__mux2_1_76/X sky130_fd_sc_hs__mux2_1_8/S
+ sky130_fd_sc_hs__mux2_1_76/A0 sky130_fd_sc_hs__mux2_1_94/A1 VSS VDD sky130_fd_sc_hs__mux2_1
Xsky130_fd_sc_hs__mux2_1_87 VDD VSS sky130_fd_sc_hs__mux2_1_87/X sky130_fd_sc_hs__mux2_1_9/S
+ sky130_fd_sc_hs__mux2_1_87/A0 sky130_fd_sc_hs__mux2_1_94/A1 VSS VDD sky130_fd_sc_hs__mux2_1
Xsky130_fd_sc_hs__mux2_1_98 VDD VSS sky130_fd_sc_hs__mux2_1_98/X sky130_fd_sc_hs__mux2_1_98/S
+ sky130_fd_sc_hs__mux2_1_98/A0 sky130_fd_sc_hs__mux2_1_98/A1 VSS VDD sky130_fd_sc_hs__mux2_1
Xsky130_fd_sc_hs__nor2b_1_14 VDD VSS sky130_fd_sc_hs__xor2_1_28/A sky130_fd_sc_hs__o31a_1_1/A1
+ sky130_fd_sc_hs__xor2_1_28/B VSS VDD sky130_fd_sc_hs__nor2b_1
Xsky130_fd_sc_hs__nor2b_1_25 VDD VSS sky130_fd_sc_hs__xnor2_1_87/Y sky130_fd_sc_hs__or2_1_16/A
+ sky130_fd_sc_hs__maj3_1_32/X VSS VDD sky130_fd_sc_hs__nor2b_1
Xsky130_fd_sc_hs__nor2b_1_36 VDD VSS sky130_fd_sc_hs__xor2_1_75/B sky130_fd_sc_hs__nor2b_1_36/Y
+ sky130_fd_sc_hs__xor2_1_75/A VSS VDD sky130_fd_sc_hs__nor2b_1
Xsky130_fd_sc_hs__nor2b_1_47 VDD VSS sky130_fd_sc_hs__or3b_1_1/A sky130_fd_sc_hs__a32o_1_9/A3
+ sky130_fd_sc_hs__or3b_1_1/B VSS VDD sky130_fd_sc_hs__nor2b_1
Xsky130_fd_sc_hs__a31o_1_10 VDD VSS sky130_fd_sc_hs__a31o_1_10/X sky130_fd_sc_hs__nand2_1_74/Y
+ sky130_fd_sc_hs__a32o_1_5/A3 sky130_fd_sc_hs__a31o_1_6/A1 sky130_fd_sc_hs__buf_8_12/X
+ VSS VDD sky130_fd_sc_hs__a31o_1
Xsky130_fd_sc_hs__o22ai_1_6 VDD VSS sky130_fd_sc_hs__o22ai_1_6/B2 sky130_fd_sc_hs__nand4_1_5/D
+ sky130_fd_sc_hs__o22ai_1_6/Y sky130_fd_sc_hs__nand4_1_5/C sky130_fd_sc_hs__o22ai_1_6/A1
+ VSS VDD sky130_fd_sc_hs__o22ai_1
Xsky130_fd_sc_hs__o22ai_1_12 VDD VSS sky130_fd_sc_hs__and2_1_29/B sky130_fd_sc_hs__nand2_2_2/A
+ sky130_fd_sc_hs__nor2_1_87/B sky130_fd_sc_hs__nand4_1_5/A sky130_fd_sc_hs__nor2_2_2/A
+ VSS VDD sky130_fd_sc_hs__o22ai_1
Xsky130_fd_sc_hs__dfrtp_1_403 sky130_fd_sc_hs__buf_8_9/X VDD VSS sky130_fd_sc_hs__xnor2_1_84/A
+ sky130_fd_sc_hs__clkbuf_2_112/X sky130_fd_sc_hs__dfrtp_1_403/D VSS VDD sky130_fd_sc_hs__dfrtp_1
Xsky130_fd_sc_hs__dfrtp_1_414 sky130_fd_sc_hs__clkbuf_4_16/X VDD VSS sky130_fd_sc_hs__xor2_1_59/B
+ sky130_fd_sc_hs__clkinv_1_77/A sky130_fd_sc_hs__mux2_1_234/X VSS VDD sky130_fd_sc_hs__dfrtp_1
Xsky130_fd_sc_hs__dfrtp_1_425 sky130_fd_sc_hs__clkbuf_4_16/X VDD VSS sky130_fd_sc_hs__xor2_1_63/B
+ sky130_fd_sc_hs__clkinv_1_81/A sky130_fd_sc_hs__dfrtp_1_425/D VSS VDD sky130_fd_sc_hs__dfrtp_1
Xsky130_fd_sc_hs__dfrtp_1_436 sky130_fd_sc_hs__clkbuf_4_16/X VDD VSS sky130_fd_sc_hs__xor2_1_60/B
+ sky130_fd_sc_hs__clkinv_1_79/A sky130_fd_sc_hs__mux2_1_236/X VSS VDD sky130_fd_sc_hs__dfrtp_1
Xsky130_fd_sc_hs__dfrtp_1_447 sky130_fd_sc_hs__clkbuf_4_22/X VDD VSS sky130_fd_sc_hs__xor2_1_66/B
+ sky130_fd_sc_hs__clkinv_2_9/A sky130_fd_sc_hs__mux2_1_245/X VSS VDD sky130_fd_sc_hs__dfrtp_1
Xsky130_fd_sc_hs__dfrtp_1_458 sky130_fd_sc_hs__clkbuf_4_22/X VDD VSS sky130_fd_sc_hs__maj3_1_39/C
+ sky130_fd_sc_hs__clkinv_1_94/A sky130_fd_sc_hs__a32o_1_8/X VSS VDD sky130_fd_sc_hs__dfrtp_1
Xsky130_fd_sc_hs__dfrtp_1_469 sky130_fd_sc_hs__clkbuf_4_22/A VDD VSS sky130_fd_sc_hs__xor3_1_0/C
+ sky130_fd_sc_hs__clkbuf_2_142/X sky130_fd_sc_hs__dfrtp_1_469/D VSS VDD sky130_fd_sc_hs__dfrtp_1
Xsky130_fd_sc_hs__mux2_1_407 VDD VSS sky130_fd_sc_hs__mux2_1_407/X sky130_fd_sc_hs__buf_16_3/X
+ sky130_fd_sc_hs__a22o_1_88/B2 sky130_fd_sc_hs__mux2_1_407/A1 VSS VDD sky130_fd_sc_hs__mux2_1
Xsky130_fd_sc_hs__mux2_1_418 VDD VSS sky130_fd_sc_hs__mux2_1_418/X sky130_fd_sc_hs__buf_16_14/A
+ sky130_fd_sc_hs__mux2_1_418/A0 sky130_fd_sc_hs__a22o_1_84/B2 VSS VDD sky130_fd_sc_hs__mux2_1
Xsky130_fd_sc_hs__mux2_1_429 VDD VSS sky130_fd_sc_hs__mux2_1_429/X sky130_fd_sc_hs__buf_16_0/A
+ sky130_fd_sc_hs__maj3_1_66/C sky130_fd_sc_hs__a22o_1_88/B2 VSS VDD sky130_fd_sc_hs__mux2_1
Xsky130_fd_sc_hs__a311oi_1_5 VDD VSS sky130_fd_sc_hs__or2_1_11/A sky130_fd_sc_hs__a31o_1_4/B1
+ sky130_fd_sc_hs__a31o_1_4/A3 sky130_fd_sc_hs__a31o_1_5/A2 sky130_fd_sc_hs__a31o_1_5/A1
+ sky130_fd_sc_hs__a311oi_1_5/Y VSS VDD sky130_fd_sc_hs__a311oi_1
Xsky130_fd_sc_hs__or2_1_20 VDD VSS sky130_fd_sc_hs__or2_1_20/B sky130_fd_sc_hs__or2_1_20/A
+ sky130_fd_sc_hs__or2_1_20/X VSS VDD sky130_fd_sc_hs__or2_1
Xsky130_fd_sc_hs__dfrtp_1_200 sky130_fd_sc_hs__clkbuf_4_3/A VDD VSS sky130_fd_sc_hs__xor2_1_9/A
+ sky130_fd_sc_hs__clkinv_2_1/A sky130_fd_sc_hs__o2bb2ai_1_6/Y VSS VDD sky130_fd_sc_hs__dfrtp_1
Xsky130_fd_sc_hs__or2_1_31 VDD VSS sky130_fd_sc_hs__or2_1_31/B sky130_fd_sc_hs__or2_1_31/A
+ sky130_fd_sc_hs__or2_1_31/X VSS VDD sky130_fd_sc_hs__or2_1
Xsky130_fd_sc_hs__dfrtp_1_211 sky130_fd_sc_hs__clkbuf_4_4/X VDD VSS sky130_fd_sc_hs__mux2_1_82/A0
+ sky130_fd_sc_hs__clkinv_1_4/A sky130_fd_sc_hs__mux2_1_82/X VSS VDD sky130_fd_sc_hs__dfrtp_1
Xsky130_fd_sc_hs__dfrtp_1_222 sky130_fd_sc_hs__buf_8_4/X VDD VSS sky130_fd_sc_hs__nor2_1_44/A
+ sky130_fd_sc_hs__dfstp_1_0/CLK sky130_fd_sc_hs__nor2_1_42/A VSS VDD sky130_fd_sc_hs__dfrtp_1
Xsky130_fd_sc_hs__dfrtp_1_233 sky130_fd_sc_hs__buf_8_5/X VDD VSS sky130_fd_sc_hs__and3_1_6/B
+ sky130_fd_sc_hs__clkbuf_8_2/X sky130_fd_sc_hs__a22o_1_27/X VSS VDD sky130_fd_sc_hs__dfrtp_1
Xsky130_fd_sc_hs__dfrtp_1_244 sky130_fd_sc_hs__buf_8_4/A VDD VSS sky130_fd_sc_hs__dfrtp_1_281/D
+ sky130_fd_sc_hs__clkbuf_2_72/X sky130_fd_sc_hs__dfrtp_1_245/Q VSS VDD sky130_fd_sc_hs__dfrtp_1
Xsky130_fd_sc_hs__dfrtp_1_255 sky130_fd_sc_hs__clkbuf_4_14/X VDD VSS sky130_fd_sc_hs__dfrtp_1_259/D
+ sky130_fd_sc_hs__clkinv_2_3/A sky130_fd_sc_hs__conb_1_0/HI VSS VDD sky130_fd_sc_hs__dfrtp_1
Xsky130_fd_sc_hs__dfrtp_1_266 sky130_fd_sc_hs__buf_2_0/A VDD VSS sky130_fd_sc_hs__and3_1_10/B
+ sky130_fd_sc_hs__clkbuf_2_78/X sky130_fd_sc_hs__nor3_1_18/Y VSS VDD sky130_fd_sc_hs__dfrtp_1
Xsky130_fd_sc_hs__dfrtp_1_277 sky130_fd_sc_hs__buf_2_0/A VDD VSS sky130_fd_sc_hs__nor2_1_7/A
+ sky130_fd_sc_hs__clkbuf_2_81/X sky130_fd_sc_hs__dfrtp_1_277/D VSS VDD sky130_fd_sc_hs__dfrtp_1
Xsky130_fd_sc_hs__dfrtp_1_288 sky130_fd_sc_hs__clkbuf_4_12/A VDD VSS sky130_fd_sc_hs__and2_1_0/A
+ sky130_fd_sc_hs__clkinv_1_49/A sky130_fd_sc_hs__a22o_1_34/X VSS VDD sky130_fd_sc_hs__dfrtp_1
Xsky130_fd_sc_hs__dfrtp_1_299 sky130_fd_sc_hs__buf_8_7/X VDD VSS sky130_fd_sc_hs__xor2_1_32/B
+ sky130_fd_sc_hs__clkinv_1_57/A sky130_fd_sc_hs__mux2_1_197/X VSS VDD sky130_fd_sc_hs__dfrtp_1
Xsky130_fd_sc_hs__clkinv_1_10 VDD VSS sky130_fd_sc_hs__nor3_1_3/C sky130_fd_sc_hs__o211ai_1_2/A2
+ VSS VDD sky130_fd_sc_hs__clkinv_1
Xsky130_fd_sc_hs__clkinv_1_21 VDD VSS sky130_fd_sc_hs__or2_1_1/A sky130_fd_sc_hs__xnor2_1_11/A
+ VSS VDD sky130_fd_sc_hs__clkinv_1
Xsky130_fd_sc_hs__clkinv_1_32 VDD VSS sky130_fd_sc_hs__clkinv_1_32/A sky130_fd_sc_hs__clkinv_1_32/Y
+ VSS VDD sky130_fd_sc_hs__clkinv_1
Xsky130_fd_sc_hs__clkinv_1_43 VDD VSS sky130_fd_sc_hs__clkinv_1_43/A sky130_fd_sc_hs__clkinv_1_43/Y
+ VSS VDD sky130_fd_sc_hs__clkinv_1
Xsky130_fd_sc_hs__clkbuf_2_7 VDD VSS sky130_fd_sc_hs__clkbuf_2_7/X sky130_fd_sc_hs__clkinv_4_0/A
+ VSS VDD sky130_fd_sc_hs__clkbuf_2
Xsky130_fd_sc_hs__clkinv_1_54 VDD VSS sky130_fd_sc_hs__clkinv_1_54/A sky130_fd_sc_hs__clkinv_1_54/Y
+ VSS VDD sky130_fd_sc_hs__clkinv_1
Xsky130_fd_sc_hs__clkinv_1_65 VDD VSS sky130_fd_sc_hs__clkinv_1_65/A sky130_fd_sc_hs__clkinv_1_65/Y
+ VSS VDD sky130_fd_sc_hs__clkinv_1
Xsky130_fd_sc_hs__clkinv_1_76 VDD VSS sky130_fd_sc_hs__clkinv_1_76/A sky130_fd_sc_hs__clkinv_1_76/Y
+ VSS VDD sky130_fd_sc_hs__clkinv_1
Xsky130_fd_sc_hs__a22o_1_18 VDD VSS sky130_fd_sc_hs__a22o_1_18/X sky130_fd_sc_hs__a22o_1_18/B2
+ sky130_fd_sc_hs__a22o_1_6/B1 sky130_fd_sc_hs__nor2_2_0/Y sky130_fd_sc_hs__buf_1_61/A
+ VSS VDD sky130_fd_sc_hs__a22o_1
Xsky130_fd_sc_hs__clkinv_1_87 VDD VSS sky130_fd_sc_hs__nor2_1_82/B sky130_fd_sc_hs__nand2_1_96/B
+ VSS VDD sky130_fd_sc_hs__clkinv_1
Xsky130_fd_sc_hs__a22o_1_29 VDD VSS sky130_fd_sc_hs__a22o_1_29/X sky130_fd_sc_hs__xnor2_1_45/Y
+ sky130_fd_sc_hs__and2_1_14/X sky130_fd_sc_hs__a32o_1_4/B1 sky130_fd_sc_hs__a22o_1_29/A1
+ VSS VDD sky130_fd_sc_hs__a22o_1
Xsky130_fd_sc_hs__clkinv_1_98 VDD VSS sky130_fd_sc_hs__clkinv_1_98/A sky130_fd_sc_hs__clkinv_1_98/Y
+ VSS VDD sky130_fd_sc_hs__clkinv_1
Xsky130_fd_sc_hs__o21ai_1_5 VDD VSS sky130_fd_sc_hs__o21ai_1_5/Y sky130_fd_sc_hs__o21a_1_4/B1
+ sky130_fd_sc_hs__o21ai_1_5/A2 sky130_fd_sc_hs__o21ai_1_5/A1 VSS VDD sky130_fd_sc_hs__o21ai_1
Xsky130_fd_sc_hs__clkbuf_2_18 VDD VSS sky130_fd_sc_hs__clkbuf_2_18/X sky130_fd_sc_hs__clkbuf_2_92/A
+ VSS VDD sky130_fd_sc_hs__clkbuf_2
Xsky130_fd_sc_hs__clkbuf_2_29 VDD VSS sky130_fd_sc_hs__clkbuf_2_29/X sky130_fd_sc_hs__clkbuf_2_3/A
+ VSS VDD sky130_fd_sc_hs__clkbuf_2
Xsky130_fd_sc_hs__clkinv_2_7 VDD VSS sky130_fd_sc_hs__clkinv_2_7/Y sky130_fd_sc_hs__clkinv_2_7/A
+ VSS VDD sky130_fd_sc_hs__clkinv_2
Xsky130_fd_sc_hs__o21ai_1_103 VDD VSS sky130_fd_sc_hs__o21ai_1_103/Y sky130_fd_sc_hs__o21a_1_4/B1
+ sky130_fd_sc_hs__a21oi_1_199/Y sky130_fd_sc_hs__a21oi_1_198/Y VSS VDD sky130_fd_sc_hs__o21ai_1
Xsky130_fd_sc_hs__o21ai_1_114 VDD VSS sky130_fd_sc_hs__o22ai_1_15/B2 sky130_fd_sc_hs__buf_8_2/X
+ sky130_fd_sc_hs__buf_8_10/X sky130_fd_sc_hs__or2_1_1/A VSS VDD sky130_fd_sc_hs__o21ai_1
Xsky130_fd_sc_hs__mux2_1_204 VDD VSS sky130_fd_sc_hs__mux2_1_204/X sky130_fd_sc_hs__buf_16_1/X
+ sky130_fd_sc_hs__mux2_1_204/A0 sky130_fd_sc_hs__mux2_1_99/A0 VSS VDD sky130_fd_sc_hs__mux2_1
Xsky130_fd_sc_hs__mux2_1_215 VDD VSS sky130_fd_sc_hs__mux2_1_215/X sky130_fd_sc_hs__buf_16_5/X
+ sky130_fd_sc_hs__a22o_1_70/A1 sky130_fd_sc_hs__mux2_1_98/A1 VSS VDD sky130_fd_sc_hs__mux2_1
Xsky130_fd_sc_hs__mux2_1_226 VDD VSS sky130_fd_sc_hs__mux2_1_226/X sky130_fd_sc_hs__buf_16_0/X
+ sky130_fd_sc_hs__xor2_1_50/B sky130_fd_sc_hs__mux2_1_61/A0 VSS VDD sky130_fd_sc_hs__mux2_1
Xsky130_fd_sc_hs__nand2_1_18 VDD VSS sky130_fd_sc_hs__a32o_1_2/B1 sky130_fd_sc_hs__nand2_1_19/A
+ sky130_fd_sc_hs__or2_1_3/A VSS VDD sky130_fd_sc_hs__nand2_1
Xsky130_fd_sc_hs__mux2_1_237 VDD VSS sky130_fd_sc_hs__mux2_1_237/X sky130_fd_sc_hs__buf_8_11/A
+ sky130_fd_sc_hs__xor2_1_61/B sky130_fd_sc_hs__nor2_1_91/Y VSS VDD sky130_fd_sc_hs__mux2_1
Xsky130_fd_sc_hs__nand2_1_29 VDD VSS sky130_fd_sc_hs__a31o_1_1/A3 sky130_fd_sc_hs__xor2_1_7/B
+ sky130_fd_sc_hs__a31o_1_1/A1 VSS VDD sky130_fd_sc_hs__nand2_1
Xsky130_fd_sc_hs__mux2_1_248 VDD VSS sky130_fd_sc_hs__mux2_1_248/X sky130_fd_sc_hs__buf_8_11/X
+ sky130_fd_sc_hs__xor3_1_0/B sky130_fd_sc_hs__mux2_1_248/A1 VSS VDD sky130_fd_sc_hs__mux2_1
Xsky130_fd_sc_hs__mux2_1_259 VDD VSS sky130_fd_sc_hs__mux2_1_259/X sky130_fd_sc_hs__mux2_1_4/S
+ sky130_fd_sc_hs__a22o_1_62/B2 sky130_fd_sc_hs__mux2_1_259/A1 VSS VDD sky130_fd_sc_hs__mux2_1
Xsky130_fd_sc_hs__nand3_1_1 VDD VSS sky130_fd_sc_hs__nand3_1_1/C sky130_fd_sc_hs__xor2_1_20/B
+ sky130_fd_sc_hs__nand3_1_1/B sky130_fd_sc_hs__nand3_1_1/A VSS VDD sky130_fd_sc_hs__nand3_1
Xsky130_fd_sc_hs__xnor2_1_60 VDD VSS sky130_fd_sc_hs__and2_1_6/A sky130_fd_sc_hs__xnor2_1_61/B
+ sky130_fd_sc_hs__xor2_1_35/X VSS VDD sky130_fd_sc_hs__xnor2_1
Xsky130_fd_sc_hs__xnor2_1_71 VDD VSS sky130_fd_sc_hs__xor2_1_3/A sky130_fd_sc_hs__xor2_1_48/B
+ sky130_fd_sc_hs__xor2_1_50/X VSS VDD sky130_fd_sc_hs__xnor2_1
Xsky130_fd_sc_hs__xnor2_1_82 VDD VSS sky130_fd_sc_hs__xor2_1_53/A sky130_fd_sc_hs__xnor2_1_82/Y
+ sky130_fd_sc_hs__xor2_1_56/X VSS VDD sky130_fd_sc_hs__xnor2_1
Xsky130_fd_sc_hs__xnor2_1_93 VDD VSS sky130_fd_sc_hs__or2_1_18/B sky130_fd_sc_hs__xnor2_1_93/Y
+ sky130_fd_sc_hs__maj3_1_35/C VSS VDD sky130_fd_sc_hs__xnor2_1
Xsky130_fd_sc_hs__o32ai_1_0 VDD VSS sky130_fd_sc_hs__nor4_1_0/A sky130_fd_sc_hs__o32ai_1_0/B2
+ sky130_fd_sc_hs__o32ai_1_0/B1 sky130_fd_sc_hs__nor3_1_41/B sky130_fd_sc_hs__nor3_1_44/Y
+ sky130_fd_sc_hs__o32ai_1_0/A1 VSS VDD sky130_fd_sc_hs__o32ai_1
Xsky130_fd_sc_hs__dlygate4sd3_1_19 VSS VDD raw_bits_i[11] sky130_fd_sc_hs__buf_1_91/A
+ VSS VDD sky130_fd_sc_hs__dlygate4sd3_1
Xsky130_fd_sc_hs__o21ai_1_19 VDD VSS sky130_fd_sc_hs__o21ai_1_19/Y sky130_fd_sc_hs__a21oi_1_23/Y
+ sky130_fd_sc_hs__nor2_1_14/Y sky130_fd_sc_hs__nand2b_1_6/Y VSS VDD sky130_fd_sc_hs__o21ai_1
Xsky130_fd_sc_hs__clkbuf_8_17 VDD VSS sky130_fd_sc_hs__clkbuf_8_17/X sky130_fd_sc_hs__clkbuf_8_17/A
+ VSS VDD sky130_fd_sc_hs__clkbuf_8
Xsky130_fd_sc_hs__and4_1_7 VDD VSS sky130_fd_sc_hs__and4_1_7/A sky130_fd_sc_hs__and4_1_7/B
+ sky130_fd_sc_hs__and4_1_7/C sky130_fd_sc_hs__and4_1_7/D sky130_fd_sc_hs__and4_1_7/X
+ VSS VDD sky130_fd_sc_hs__and4_1
Xsky130_fd_sc_hs__a21oi_1_107 VDD VSS sky130_fd_sc_hs__nor2_1_89/Y sky130_fd_sc_hs__dfrtp_1_425/D
+ sky130_fd_sc_hs__buf_8_11/A sky130_fd_sc_hs__nand2_1_114/Y VSS VDD sky130_fd_sc_hs__a21oi_1
Xsky130_fd_sc_hs__a32o_1_12 VDD VSS sky130_fd_sc_hs__a32o_1_12/X sky130_fd_sc_hs__maj3_1_34/A
+ sky130_fd_sc_hs__o31ai_4_0/Y sky130_fd_sc_hs__o21ai_1_87/Y sky130_fd_sc_hs__buf_8_26/X
+ sky130_fd_sc_hs__or3_1_7/X VSS VDD sky130_fd_sc_hs__a32o_1
Xsky130_fd_sc_hs__a21oi_1_118 VDD VSS sky130_fd_sc_hs__nor2_1_158/Y sky130_fd_sc_hs__dfrtp_1_516/D
+ sky130_fd_sc_hs__nor2_1_66/B sky130_fd_sc_hs__o21ai_1_115/Y VSS VDD sky130_fd_sc_hs__a21oi_1
Xsky130_fd_sc_hs__a21oi_1_129 VDD VSS sky130_fd_sc_hs__nor2_1_111/Y sky130_fd_sc_hs__dfrtp_1_466/D
+ sky130_fd_sc_hs__buf_8_11/X sky130_fd_sc_hs__o21ai_1_100/Y VSS VDD sky130_fd_sc_hs__a21oi_1
Xsky130_fd_sc_hs__nand3b_1_3 VDD VSS sky130_fd_sc_hs__nor3_1_44/Y sky130_fd_sc_hs__o32ai_1_0/A1
+ sky130_fd_sc_hs__nand3b_1_3/Y sky130_fd_sc_hs__or2_1_30/X VSS VDD sky130_fd_sc_hs__nand3b_1
Xsky130_fd_sc_hs__clkbuf_2_101 VDD VSS sky130_fd_sc_hs__clkinv_1_71/A sky130_fd_sc_hs__clkinv_4_3/A
+ VSS VDD sky130_fd_sc_hs__clkbuf_2
Xsky130_fd_sc_hs__clkbuf_2_112 VDD VSS sky130_fd_sc_hs__clkbuf_2_112/X sky130_fd_sc_hs__clkinv_4_5/A
+ VSS VDD sky130_fd_sc_hs__clkbuf_2
Xsky130_fd_sc_hs__clkbuf_2_123 VDD VSS sky130_fd_sc_hs__clkinv_1_83/A sky130_fd_sc_hs__clkinv_4_5/A
+ VSS VDD sky130_fd_sc_hs__clkbuf_2
Xsky130_fd_sc_hs__clkbuf_2_134 VDD VSS sky130_fd_sc_hs__clkbuf_4_21/A sky130_fd_sc_hs__buf_8_6/A
+ VSS VDD sky130_fd_sc_hs__clkbuf_2
Xsky130_fd_sc_hs__nand2_1_101 VDD VSS sky130_fd_sc_hs__nor2_1_81/B sky130_fd_sc_hs__nand2_1_85/A
+ sky130_fd_sc_hs__nor2_1_81/A VSS VDD sky130_fd_sc_hs__nand2_1
Xsky130_fd_sc_hs__clkbuf_2_145 VDD VSS sky130_fd_sc_hs__buf_8_36/A sky130_fd_sc_hs__nor2_1_126/Y
+ VSS VDD sky130_fd_sc_hs__clkbuf_2
Xsky130_fd_sc_hs__nand2_1_112 VDD VSS sky130_fd_sc_hs__xor2_1_91/A sky130_fd_sc_hs__o31ai_1_10/B1
+ sky130_fd_sc_hs__xor2_1_80/A VSS VDD sky130_fd_sc_hs__nand2_1
Xsky130_fd_sc_hs__clkbuf_2_156 VDD VSS sky130_fd_sc_hs__clkbuf_2_157/A sky130_fd_sc_hs__inv_8_1/A
+ VSS VDD sky130_fd_sc_hs__clkbuf_2
Xsky130_fd_sc_hs__nand2_1_123 VDD VSS sky130_fd_sc_hs__nand3_1_30/C sky130_fd_sc_hs__o31ai_1_13/B1
+ sky130_fd_sc_hs__nand2_1_123/A VSS VDD sky130_fd_sc_hs__nand2_1
Xsky130_fd_sc_hs__nand2_1_134 VDD VSS sky130_fd_sc_hs__or2_1_21/B sky130_fd_sc_hs__nor2_1_149/A
+ sky130_fd_sc_hs__or2_1_21/A VSS VDD sky130_fd_sc_hs__nand2_1
Xsky130_fd_sc_hs__clkbuf_2_167 VDD VSS sky130_fd_sc_hs__dfstp_1_2/CLK sky130_fd_sc_hs__clkbuf_2_176/A
+ VSS VDD sky130_fd_sc_hs__clkbuf_2
Xsky130_fd_sc_hs__nand2_1_145 VDD VSS sky130_fd_sc_hs__nand2_1_145/B sky130_fd_sc_hs__o41ai_1_1/B1
+ sky130_fd_sc_hs__or3_1_4/B VSS VDD sky130_fd_sc_hs__nand2_1
Xsky130_fd_sc_hs__clkbuf_2_178 VDD VSS sky130_fd_sc_hs__clkinv_1_129/A sky130_fd_sc_hs__clkbuf_2_236/A
+ VSS VDD sky130_fd_sc_hs__clkbuf_2
Xsky130_fd_sc_hs__nand2_1_156 VDD VSS sky130_fd_sc_hs__nand2_1_157/Y sky130_fd_sc_hs__nand2_1_156/Y
+ sky130_fd_sc_hs__nand2_1_156/A VSS VDD sky130_fd_sc_hs__nand2_1
Xsky130_fd_sc_hs__clkbuf_2_189 VDD VSS sky130_fd_sc_hs__clkbuf_2_189/X sky130_fd_sc_hs__clkbuf_2_236/A
+ VSS VDD sky130_fd_sc_hs__clkbuf_2
Xsky130_fd_sc_hs__nand2_1_167 VDD VSS sky130_fd_sc_hs__nor2_1_177/Y sky130_fd_sc_hs__nand2_1_167/Y
+ sky130_fd_sc_hs__and2_1_36/X VSS VDD sky130_fd_sc_hs__nand2_1
Xsky130_fd_sc_hs__nand2_1_178 VDD VSS sky130_fd_sc_hs__nor3_1_47/C sky130_fd_sc_hs__nor3_4_1/C
+ sky130_fd_sc_hs__nand4_1_9/C VSS VDD sky130_fd_sc_hs__nand2_1
Xsky130_fd_sc_hs__nand2_1_189 VDD VSS sky130_fd_sc_hs__buf_4_6/X sky130_fd_sc_hs__o31a_1_5/B1
+ sky130_fd_sc_hs__or3_1_6/A VSS VDD sky130_fd_sc_hs__nand2_1
Xsky130_fd_sc_hs__maj3_1_5 VDD VSS sky130_fd_sc_hs__maj3_1_5/A sky130_fd_sc_hs__xor2_1_5/A
+ sky130_fd_sc_hs__maj3_1_5/X sky130_fd_sc_hs__xor2_1_5/B VSS VDD sky130_fd_sc_hs__maj3_1
Xsky130_fd_sc_hs__nor2_2_6 VDD VSS sky130_fd_sc_hs__nor2_2_6/B sky130_fd_sc_hs__nor2_2_6/Y
+ sky130_fd_sc_hs__or3_1_6/A VSS VDD sky130_fd_sc_hs__nor2_2
Xsky130_fd_sc_hs__buf_8_13 VDD VSS sky130_fd_sc_hs__buf_8_13/X sky130_fd_sc_hs__buf_8_13/A
+ VSS VDD sky130_fd_sc_hs__buf_8
Xsky130_fd_sc_hs__buf_8_24 VDD VSS sky130_fd_sc_hs__buf_8_24/X sky130_fd_sc_hs__or3_1_5/X
+ VSS VDD sky130_fd_sc_hs__buf_8
Xsky130_fd_sc_hs__buf_8_35 VDD VSS sky130_fd_sc_hs__buf_8_35/X sky130_fd_sc_hs__buf_8_35/A
+ VSS VDD sky130_fd_sc_hs__buf_8
Xsky130_fd_sc_hs__dfrtp_1_607 sky130_fd_sc_hs__clkbuf_4_2/X VDD VSS sky130_fd_sc_hs__mux2_1_294/A1
+ sky130_fd_sc_hs__clkinv_1_128/A sky130_fd_sc_hs__mux2_1_294/X VSS VDD sky130_fd_sc_hs__dfrtp_1
Xsky130_fd_sc_hs__dfrtp_1_618 sky130_fd_sc_hs__clkbuf_4_2/X VDD VSS sky130_fd_sc_hs__mux2_1_313/A1
+ sky130_fd_sc_hs__clkinv_1_133/A sky130_fd_sc_hs__mux2_1_313/X VSS VDD sky130_fd_sc_hs__dfrtp_1
Xsky130_fd_sc_hs__dfrtp_1_629 sky130_fd_sc_hs__buf_8_30/X VDD VSS sky130_fd_sc_hs__mux2_1_334/A0
+ sky130_fd_sc_hs__clkinv_1_141/A sky130_fd_sc_hs__mux2_1_334/X VSS VDD sky130_fd_sc_hs__dfrtp_1
Xsky130_fd_sc_hs__nor2_1_15 VDD VSS sky130_fd_sc_hs__nor2_1_19/Y sky130_fd_sc_hs__nor2_1_15/Y
+ sky130_fd_sc_hs__and2_1_4/X VSS VDD sky130_fd_sc_hs__nor2_1
Xsky130_fd_sc_hs__nor2_1_26 VDD VSS sky130_fd_sc_hs__and2_1_9/A sky130_fd_sc_hs__nor2_1_26/Y
+ sky130_fd_sc_hs__nor2_1_26/A VSS VDD sky130_fd_sc_hs__nor2_1
Xsky130_fd_sc_hs__nor2_1_37 VDD VSS sky130_fd_sc_hs__buf_8_3/X sky130_fd_sc_hs__nor2_1_37/Y
+ sky130_fd_sc_hs__buf_1_53/A VSS VDD sky130_fd_sc_hs__nor2_1
Xsky130_fd_sc_hs__nor2_1_48 VDD VSS sky130_fd_sc_hs__and3_1_7/X sky130_fd_sc_hs__nor2_1_48/Y
+ sky130_fd_sc_hs__nor2_1_48/A VSS VDD sky130_fd_sc_hs__nor2_1
Xsky130_fd_sc_hs__nor2_1_59 VDD VSS sky130_fd_sc_hs__nor2_1_82/B sky130_fd_sc_hs__nor2_1_59/Y
+ sky130_fd_sc_hs__xor2_1_25/A VSS VDD sky130_fd_sc_hs__nor2_1
Xsky130_fd_sc_hs__o311ai_1_1 VDD VSS sky130_fd_sc_hs__o21a_1_5/B1 sky130_fd_sc_hs__o21a_1_5/A1
+ sky130_fd_sc_hs__o31ai_1_3/B1 sky130_fd_sc_hs__nand2_1_39/Y sky130_fd_sc_hs__and3_1_2/C
+ sky130_fd_sc_hs__o21a_1_5/A2 VSS VDD sky130_fd_sc_hs__o311ai_1
Xsky130_fd_sc_hs__xnor2_1_104 VDD VSS sky130_fd_sc_hs__maj3_1_41/C sky130_fd_sc_hs__xnor2_1_105/B
+ sky130_fd_sc_hs__xor2_1_70/X VSS VDD sky130_fd_sc_hs__xnor2_1
Xsky130_fd_sc_hs__xnor2_1_115 VDD VSS sky130_fd_sc_hs__maj3_1_46/C sky130_fd_sc_hs__xor2_1_72/B
+ sky130_fd_sc_hs__xor2_1_77/X VSS VDD sky130_fd_sc_hs__xnor2_1
Xsky130_fd_sc_hs__xnor2_1_126 VDD VSS sky130_fd_sc_hs__maj3_1_52/B sky130_fd_sc_hs__xnor2_1_126/Y
+ sky130_fd_sc_hs__maj3_1_52/C VSS VDD sky130_fd_sc_hs__xnor2_1
Xsky130_fd_sc_hs__xnor2_1_137 VDD VSS sky130_fd_sc_hs__xor2_1_80/A sky130_fd_sc_hs__xnor2_1_137/Y
+ sky130_fd_sc_hs__xor2_1_91/X VSS VDD sky130_fd_sc_hs__xnor2_1
Xsky130_fd_sc_hs__xnor2_1_148 VDD VSS sky130_fd_sc_hs__and3_1_12/A sky130_fd_sc_hs__nor2_1_99/B
+ sky130_fd_sc_hs__xnor2_1_93/Y VSS VDD sky130_fd_sc_hs__xnor2_1
Xsky130_fd_sc_hs__mux2_1_11 VDD VSS sky130_fd_sc_hs__mux2_1_11/X sky130_fd_sc_hs__mux2_1_99/S
+ sky130_fd_sc_hs__mux2_1_9/A1 sky130_fd_sc_hs__mux2_1_11/A1 VSS VDD sky130_fd_sc_hs__mux2_1
Xsky130_fd_sc_hs__mux2_1_22 VDD VSS sky130_fd_sc_hs__mux2_1_22/X sky130_fd_sc_hs__mux2_1_99/S
+ sky130_fd_sc_hs__mux2_1_95/A1 sky130_fd_sc_hs__mux2_1_22/A1 VSS VDD sky130_fd_sc_hs__mux2_1
Xsky130_fd_sc_hs__mux2_1_33 VDD VSS sky130_fd_sc_hs__mux2_1_33/X sky130_fd_sc_hs__mux2_1_7/S
+ sky130_fd_sc_hs__mux2_1_33/A0 sky130_fd_sc_hs__mux2_1_40/A0 VSS VDD sky130_fd_sc_hs__mux2_1
Xsky130_fd_sc_hs__mux2_1_44 VDD VSS sky130_fd_sc_hs__mux2_1_44/X sky130_fd_sc_hs__buf_16_2/X
+ sky130_fd_sc_hs__mux2_1_85/A0 sky130_fd_sc_hs__mux2_1_44/A1 VSS VDD sky130_fd_sc_hs__mux2_1
Xsky130_fd_sc_hs__mux2_1_55 VDD VSS sky130_fd_sc_hs__mux2_1_55/X sky130_fd_sc_hs__mux2_1_9/S
+ sky130_fd_sc_hs__mux2_1_55/A0 sky130_fd_sc_hs__mux2_1_61/A0 VSS VDD sky130_fd_sc_hs__mux2_1
Xsky130_fd_sc_hs__mux2_1_66 VDD VSS sky130_fd_sc_hs__mux2_1_66/X sky130_fd_sc_hs__mux2_1_8/S
+ sky130_fd_sc_hs__mux2_1_66/A0 sky130_fd_sc_hs__mux2_1_96/A0 VSS VDD sky130_fd_sc_hs__mux2_1
Xsky130_fd_sc_hs__mux2_1_77 VDD VSS sky130_fd_sc_hs__mux2_1_77/X sky130_fd_sc_hs__mux2_1_5/S
+ sky130_fd_sc_hs__mux2_1_77/A0 sky130_fd_sc_hs__mux2_1_96/A0 VSS VDD sky130_fd_sc_hs__mux2_1
Xsky130_fd_sc_hs__mux2_1_88 VDD VSS sky130_fd_sc_hs__mux2_1_88/X sky130_fd_sc_hs__mux2_1_5/S
+ sky130_fd_sc_hs__mux2_1_88/A0 sky130_fd_sc_hs__mux2_1_94/A1 VSS VDD sky130_fd_sc_hs__mux2_1
Xsky130_fd_sc_hs__mux2_1_99 VDD VSS sky130_fd_sc_hs__mux2_1_99/X sky130_fd_sc_hs__mux2_1_99/S
+ sky130_fd_sc_hs__mux2_1_99/A0 sky130_fd_sc_hs__mux2_1_99/A1 VSS VDD sky130_fd_sc_hs__mux2_1
Xsky130_fd_sc_hs__nor2b_1_15 VDD VSS sky130_fd_sc_hs__maj3_1_20/X sky130_fd_sc_hs__nor2_1_73/A
+ sky130_fd_sc_hs__xnor2_1_11/Y VSS VDD sky130_fd_sc_hs__nor2b_1
Xsky130_fd_sc_hs__nor2b_1_26 VDD VSS sky130_fd_sc_hs__maj3_1_32/X sky130_fd_sc_hs__o31a_1_2/A2
+ sky130_fd_sc_hs__xnor2_1_87/Y VSS VDD sky130_fd_sc_hs__nor2b_1
Xsky130_fd_sc_hs__nor2b_1_37 VDD VSS sky130_fd_sc_hs__nor3_1_37/B sky130_fd_sc_hs__nor3_1_39/C
+ sky130_fd_sc_hs__nor3_1_37/A VSS VDD sky130_fd_sc_hs__nor2b_1
Xsky130_fd_sc_hs__nor2b_1_48 VDD VSS sky130_fd_sc_hs__or2_1_21/B sky130_fd_sc_hs__nor2b_1_48/Y
+ sky130_fd_sc_hs__or2_1_21/A VSS VDD sky130_fd_sc_hs__nor2b_1
Xsky130_fd_sc_hs__a31o_1_11 VDD VSS sky130_fd_sc_hs__a31o_1_11/X sky130_fd_sc_hs__xnor2_1_84/Y
+ sky130_fd_sc_hs__a21o_1_8/X sky130_fd_sc_hs__a31o_1_11/A1 sky130_fd_sc_hs__buf_8_12/X
+ VSS VDD sky130_fd_sc_hs__a31o_1
Xsky130_fd_sc_hs__o22ai_1_7 VDD VSS sky130_fd_sc_hs__nand4_1_5/C sky130_fd_sc_hs__o22ai_1_8/B2
+ sky130_fd_sc_hs__o22ai_1_7/Y sky130_fd_sc_hs__nand4_1_5/D sky130_fd_sc_hs__o22ai_1_8/A1
+ VSS VDD sky130_fd_sc_hs__o22ai_1
Xsky130_fd_sc_hs__o22ai_1_13 VDD VSS sky130_fd_sc_hs__nand4_1_5/C sky130_fd_sc_hs__o22ai_1_14/B1
+ sky130_fd_sc_hs__buf_1_182/A sky130_fd_sc_hs__o22ai_1_14/A2 sky130_fd_sc_hs__nand4_1_5/D
+ VSS VDD sky130_fd_sc_hs__o22ai_1
Xsky130_fd_sc_hs__dfrtp_1_404 sky130_fd_sc_hs__clkbuf_4_56/X VDD VSS sky130_fd_sc_hs__a22o_1_78/B2
+ sky130_fd_sc_hs__clkinv_1_76/A sky130_fd_sc_hs__a22o_1_78/X VSS VDD sky130_fd_sc_hs__dfrtp_1
Xsky130_fd_sc_hs__dfrtp_1_415 sky130_fd_sc_hs__clkbuf_4_19/X VDD VSS sky130_fd_sc_hs__a22o_1_89/B2
+ sky130_fd_sc_hs__clkbuf_2_118/A sky130_fd_sc_hs__a22o_1_89/X VSS VDD sky130_fd_sc_hs__dfrtp_1
Xsky130_fd_sc_hs__dfrtp_1_426 sky130_fd_sc_hs__clkbuf_4_19/X VDD VSS sky130_fd_sc_hs__nor2_1_88/A
+ sky130_fd_sc_hs__clkbuf_2_121/X sky130_fd_sc_hs__dfrtp_1_426/D VSS VDD sky130_fd_sc_hs__dfrtp_1
Xsky130_fd_sc_hs__dfrtp_1_437 sky130_fd_sc_hs__clkbuf_4_19/X VDD VSS sky130_fd_sc_hs__a22o_1_94/B2
+ sky130_fd_sc_hs__clkinv_1_85/A sky130_fd_sc_hs__a22o_1_94/X VSS VDD sky130_fd_sc_hs__dfrtp_1
Xsky130_fd_sc_hs__dfrtp_1_448 sky130_fd_sc_hs__buf_8_7/A VDD VSS sky130_fd_sc_hs__xor2_1_67/B
+ sky130_fd_sc_hs__clkinv_1_89/A sky130_fd_sc_hs__mux2_1_244/X VSS VDD sky130_fd_sc_hs__dfrtp_1
Xsky130_fd_sc_hs__dfrtp_1_459 sky130_fd_sc_hs__clkbuf_4_22/X VDD VSS sky130_fd_sc_hs__and4_1_5/B
+ sky130_fd_sc_hs__clkinv_1_95/A sky130_fd_sc_hs__nor2_1_106/Y VSS VDD sky130_fd_sc_hs__dfrtp_1
Xsky130_fd_sc_hs__mux2_1_408 VDD VSS sky130_fd_sc_hs__mux2_1_408/X sky130_fd_sc_hs__buf_16_10/A
+ sky130_fd_sc_hs__nand2_1_219/A sky130_fd_sc_hs__a22o_1_88/B2 VSS VDD sky130_fd_sc_hs__mux2_1
Xsky130_fd_sc_hs__mux2_1_419 VDD VSS sky130_fd_sc_hs__mux2_1_419/X sky130_fd_sc_hs__buf_16_4/A
+ sky130_fd_sc_hs__mux2_1_419/A0 sky130_fd_sc_hs__a22o_1_84/B2 VSS VDD sky130_fd_sc_hs__mux2_1
Xsky130_fd_sc_hs__a311oi_1_6 VDD VSS sky130_fd_sc_hs__nor2b_1_17/Y sky130_fd_sc_hs__nor2_1_73/A
+ sky130_fd_sc_hs__and2_1_19/B sky130_fd_sc_hs__xnor2_1_75/A sky130_fd_sc_hs__and2_1_19/A
+ sky130_fd_sc_hs__or2_1_6/B VSS VDD sky130_fd_sc_hs__a311oi_1
Xsky130_fd_sc_hs__or2_1_10 VDD VSS sky130_fd_sc_hs__or2_1_10/B sky130_fd_sc_hs__or2_1_10/A
+ sky130_fd_sc_hs__or2_1_10/X VSS VDD sky130_fd_sc_hs__or2_1
Xsky130_fd_sc_hs__or2_1_21 VDD VSS sky130_fd_sc_hs__or2_1_21/B sky130_fd_sc_hs__or2_1_21/A
+ sky130_fd_sc_hs__or2_1_21/X VSS VDD sky130_fd_sc_hs__or2_1
Xsky130_fd_sc_hs__dfrtp_1_201 sky130_fd_sc_hs__clkbuf_4_4/X VDD VSS sky130_fd_sc_hs__maj3_1_0/A
+ sky130_fd_sc_hs__dfrtp_1_8/CLK sky130_fd_sc_hs__a22o_1_17/X VSS VDD sky130_fd_sc_hs__dfrtp_1
Xsky130_fd_sc_hs__dfrtp_1_212 sky130_fd_sc_hs__clkbuf_4_4/X VDD VSS sky130_fd_sc_hs__a22oi_1_4/B2
+ sky130_fd_sc_hs__clkbuf_2_3/X sky130_fd_sc_hs__mux2_1_179/X VSS VDD sky130_fd_sc_hs__dfrtp_1
Xsky130_fd_sc_hs__dfrtp_1_223 sky130_fd_sc_hs__buf_8_4/X VDD VSS sky130_fd_sc_hs__nor2_1_41/B
+ sky130_fd_sc_hs__dfstp_1_0/CLK sky130_fd_sc_hs__o41ai_1_0/Y VSS VDD sky130_fd_sc_hs__dfrtp_1
Xsky130_fd_sc_hs__dfrtp_1_234 sky130_fd_sc_hs__buf_8_5/X VDD VSS sky130_fd_sc_hs__a21o_1_1/A1
+ sky130_fd_sc_hs__clkbuf_8_2/X sky130_fd_sc_hs__a21o_1_1/X VSS VDD sky130_fd_sc_hs__dfrtp_1
Xsky130_fd_sc_hs__dfrtp_1_245 sky130_fd_sc_hs__buf_8_5/X VDD VSS sky130_fd_sc_hs__dfrtp_1_245/Q
+ sky130_fd_sc_hs__clkbuf_8_2/X sky130_fd_sc_hs__dfrtp_1_245/D VSS VDD sky130_fd_sc_hs__dfrtp_1
Xsky130_fd_sc_hs__dfrtp_1_256 sky130_fd_sc_hs__buf_2_0/A VDD VSS sky130_fd_sc_hs__dfrtp_1_287/D
+ sky130_fd_sc_hs__clkbuf_2_73/X sky130_fd_sc_hs__dfrtp_1_258/Q VSS VDD sky130_fd_sc_hs__dfrtp_1
Xsky130_fd_sc_hs__dfrtp_1_267 sky130_fd_sc_hs__buf_2_0/A VDD VSS sky130_fd_sc_hs__and3_1_9/A
+ sky130_fd_sc_hs__clkinv_1_52/A sky130_fd_sc_hs__a21oi_1_67/Y VSS VDD sky130_fd_sc_hs__dfrtp_1
Xsky130_fd_sc_hs__dfrtp_1_278 sky130_fd_sc_hs__clkbuf_4_14/X VDD VSS sky130_fd_sc_hs__mux2_1_192/A0
+ sky130_fd_sc_hs__clkbuf_2_80/X sky130_fd_sc_hs__mux2_1_192/X VSS VDD sky130_fd_sc_hs__dfrtp_1
Xsky130_fd_sc_hs__dfrtp_1_289 sky130_fd_sc_hs__buf_2_0/A VDD VSS sky130_fd_sc_hs__xnor2_1_51/A
+ sky130_fd_sc_hs__clkbuf_2_74/X sky130_fd_sc_hs__dfrtp_1_289/D VSS VDD sky130_fd_sc_hs__dfrtp_1
Xsky130_fd_sc_hs__clkinv_1_11 VDD VSS sky130_fd_sc_hs__clkinv_1_11/A sky130_fd_sc_hs__clkinv_1_11/Y
+ VSS VDD sky130_fd_sc_hs__clkinv_1
Xsky130_fd_sc_hs__clkinv_1_22 VDD VSS sky130_fd_sc_hs__nor2b_1_4/A sky130_fd_sc_hs__o311ai_1_4/B1
+ VSS VDD sky130_fd_sc_hs__clkinv_1
Xsky130_fd_sc_hs__nor3b_1_0 VDD VSS sky130_fd_sc_hs__nor3b_1_0/Y sky130_fd_sc_hs__nor2b_1_39/Y
+ sky130_fd_sc_hs__xor2_1_75/A sky130_fd_sc_hs__nor3b_1_1/B VSS VDD sky130_fd_sc_hs__nor3b_1
Xsky130_fd_sc_hs__clkinv_1_33 VDD VSS sky130_fd_sc_hs__clkinv_1_33/A sky130_fd_sc_hs__clkinv_1_33/Y
+ VSS VDD sky130_fd_sc_hs__clkinv_1
Xsky130_fd_sc_hs__clkinv_1_44 VDD VSS sky130_fd_sc_hs__clkinv_1_44/A sky130_fd_sc_hs__clkinv_1_44/Y
+ VSS VDD sky130_fd_sc_hs__clkinv_1
Xsky130_fd_sc_hs__clkinv_1_55 VDD VSS sky130_fd_sc_hs__clkinv_1_55/A sky130_fd_sc_hs__clkinv_1_55/Y
+ VSS VDD sky130_fd_sc_hs__clkinv_1
Xsky130_fd_sc_hs__clkbuf_2_8 VDD VSS sky130_fd_sc_hs__clkbuf_2_8/X sky130_fd_sc_hs__clkinv_4_0/A
+ VSS VDD sky130_fd_sc_hs__clkbuf_2
Xsky130_fd_sc_hs__a22o_1_19 VDD VSS sky130_fd_sc_hs__a22o_1_19/X sky130_fd_sc_hs__a22o_1_25/A1
+ sky130_fd_sc_hs__a22o_1_6/B1 sky130_fd_sc_hs__nor2_2_0/Y sky130_fd_sc_hs__buf_1_10/A
+ VSS VDD sky130_fd_sc_hs__a22o_1
Xsky130_fd_sc_hs__clkinv_1_66 VDD VSS sky130_fd_sc_hs__nand2_1_75/A sky130_fd_sc_hs__clkinv_1_66/Y
+ VSS VDD sky130_fd_sc_hs__clkinv_1
Xsky130_fd_sc_hs__clkinv_1_77 VDD VSS sky130_fd_sc_hs__clkinv_1_77/A sky130_fd_sc_hs__clkinv_1_77/Y
+ VSS VDD sky130_fd_sc_hs__clkinv_1
Xsky130_fd_sc_hs__clkinv_1_88 VDD VSS sky130_fd_sc_hs__nor2_1_94/A sky130_fd_sc_hs__nor2_1_98/A
+ VSS VDD sky130_fd_sc_hs__clkinv_1
Xsky130_fd_sc_hs__clkinv_1_99 VDD VSS sky130_fd_sc_hs__xnor2_1_105/B sky130_fd_sc_hs__maj3_1_42/C
+ VSS VDD sky130_fd_sc_hs__clkinv_1
Xsky130_fd_sc_hs__o21ai_1_6 VDD VSS sky130_fd_sc_hs__o21ai_1_6/Y sky130_fd_sc_hs__buf_8_2/X
+ sky130_fd_sc_hs__buf_8_10/X sky130_fd_sc_hs__maj3_1_1/A VSS VDD sky130_fd_sc_hs__o21ai_1
Xsky130_fd_sc_hs__clkbuf_2_19 VDD VSS sky130_fd_sc_hs__clkbuf_2_19/X sky130_fd_sc_hs__clkbuf_2_3/A
+ VSS VDD sky130_fd_sc_hs__clkbuf_2
Xsky130_fd_sc_hs__dfrtp_1_790 sky130_fd_sc_hs__clkbuf_4_1/X VDD VSS sky130_fd_sc_hs__mux2_1_54/A1
+ sky130_fd_sc_hs__clkinv_1_8/A sky130_fd_sc_hs__mux2_1_54/X VSS VDD sky130_fd_sc_hs__dfrtp_1
Xsky130_fd_sc_hs__clkinv_2_8 VDD VSS sky130_fd_sc_hs__clkinv_2_8/Y sky130_fd_sc_hs__clkinv_2_8/A
+ VSS VDD sky130_fd_sc_hs__clkinv_2
Xsky130_fd_sc_hs__o21ai_1_104 VDD VSS sky130_fd_sc_hs__and2_1_46/A sky130_fd_sc_hs__nand2_1_212/Y
+ sky130_fd_sc_hs__nor2_1_178/B sky130_fd_sc_hs__nor2_1_178/A VSS VDD sky130_fd_sc_hs__o21ai_1
Xsky130_fd_sc_hs__o21ai_1_115 VDD VSS sky130_fd_sc_hs__o21ai_1_115/Y sky130_fd_sc_hs__o21a_1_4/B1
+ sky130_fd_sc_hs__a21oi_1_92/Y sky130_fd_sc_hs__a21oi_1_91/Y VSS VDD sky130_fd_sc_hs__o21ai_1
Xsky130_fd_sc_hs__mux2_1_205 VDD VSS sky130_fd_sc_hs__mux2_1_205/X sky130_fd_sc_hs__mux2_1_5/S
+ sky130_fd_sc_hs__a22o_1_70/B2 sky130_fd_sc_hs__mux2_1_98/A1 VSS VDD sky130_fd_sc_hs__mux2_1
Xsky130_fd_sc_hs__mux2_1_216 VDD VSS sky130_fd_sc_hs__mux2_1_216/X sky130_fd_sc_hs__nor2_1_82/B
+ sky130_fd_sc_hs__xor2_1_33/A sky130_fd_sc_hs__a21oi_1_20/Y VSS VDD sky130_fd_sc_hs__mux2_1
Xsky130_fd_sc_hs__mux2_1_227 VDD VSS sky130_fd_sc_hs__mux2_1_227/X sky130_fd_sc_hs__buf_16_0/A
+ sky130_fd_sc_hs__xor2_1_56/B sky130_fd_sc_hs__a22o_1_64/B2 VSS VDD sky130_fd_sc_hs__mux2_1
Xsky130_fd_sc_hs__nand2_1_19 VDD VSS sky130_fd_sc_hs__o21ai_1_3/Y sky130_fd_sc_hs__nand2_1_19/Y
+ sky130_fd_sc_hs__nand2_1_19/A VSS VDD sky130_fd_sc_hs__nand2_1
Xsky130_fd_sc_hs__mux2_1_238 VDD VSS sky130_fd_sc_hs__mux2_1_238/X sky130_fd_sc_hs__buf_8_21/A
+ sky130_fd_sc_hs__xor2_1_61/A sky130_fd_sc_hs__nor2_1_91/Y VSS VDD sky130_fd_sc_hs__mux2_1
Xsky130_fd_sc_hs__mux2_1_249 VDD VSS sky130_fd_sc_hs__mux2_1_249/X sky130_fd_sc_hs__buf_8_21/X
+ sky130_fd_sc_hs__xor2_1_71/A sky130_fd_sc_hs__mux2_1_250/A1 VSS VDD sky130_fd_sc_hs__mux2_1
Xsky130_fd_sc_hs__nand3_1_2 VDD VSS sky130_fd_sc_hs__and4_1_0/X sky130_fd_sc_hs__o21a_1_6/B1
+ sky130_fd_sc_hs__nand3_1_2/B sky130_fd_sc_hs__xnor2_1_2/A VSS VDD sky130_fd_sc_hs__nand3_1
Xsky130_fd_sc_hs__xnor2_1_50 VDD VSS sky130_fd_sc_hs__xnor2_1_50/A sky130_fd_sc_hs__xnor2_1_50/Y
+ sky130_fd_sc_hs__xnor2_1_50/B VSS VDD sky130_fd_sc_hs__xnor2_1
Xsky130_fd_sc_hs__xnor2_1_61 VDD VSS sky130_fd_sc_hs__maj3_1_25/X sky130_fd_sc_hs__xnor2_1_75/A
+ sky130_fd_sc_hs__xnor2_1_61/B VSS VDD sky130_fd_sc_hs__xnor2_1
Xsky130_fd_sc_hs__xnor2_1_72 VDD VSS sky130_fd_sc_hs__xnor2_1_72/A sky130_fd_sc_hs__xnor2_1_72/Y
+ sky130_fd_sc_hs__nor2_1_70/Y VSS VDD sky130_fd_sc_hs__xnor2_1
Xsky130_fd_sc_hs__xnor2_1_83 VDD VSS sky130_fd_sc_hs__xnor2_1_83/A sky130_fd_sc_hs__xnor2_1_83/Y
+ sky130_fd_sc_hs__xnor2_1_83/B VSS VDD sky130_fd_sc_hs__xnor2_1
Xsky130_fd_sc_hs__xnor2_1_94 VDD VSS sky130_fd_sc_hs__o21a_1_19/X sky130_fd_sc_hs__xnor2_1_94/Y
+ sky130_fd_sc_hs__xnor2_1_94/B VSS VDD sky130_fd_sc_hs__xnor2_1
Xsky130_fd_sc_hs__o32a_1_0 VDD VSS sky130_fd_sc_hs__o32a_1_0/B1 sky130_fd_sc_hs__o32a_1_0/A1
+ sky130_fd_sc_hs__o32a_1_0/A2 sky130_fd_sc_hs__o32a_1_0/A3 sky130_fd_sc_hs__or2_1_0/A
+ sky130_fd_sc_hs__o32a_1_0/X VSS VDD sky130_fd_sc_hs__o32a_1
Xsky130_fd_sc_hs__clkbuf_8_18 VDD VSS sky130_fd_sc_hs__mux2_1_397/S sky130_fd_sc_hs__nor3_4_2/Y
+ VSS VDD sky130_fd_sc_hs__clkbuf_8
Xsky130_fd_sc_hs__a32o_1_13 VDD VSS sky130_fd_sc_hs__a32o_1_13/X sky130_fd_sc_hs__xor2_1_80/A
+ sky130_fd_sc_hs__o31ai_4_0/Y sky130_fd_sc_hs__o21ai_1_88/Y sky130_fd_sc_hs__buf_8_26/X
+ sky130_fd_sc_hs__or3_1_8/X VSS VDD sky130_fd_sc_hs__a32o_1
Xsky130_fd_sc_hs__a21oi_1_108 VDD VSS sky130_fd_sc_hs__o21ai_1_50/Y sky130_fd_sc_hs__a21oi_1_108/Y
+ sky130_fd_sc_hs__xnor2_1_91/Y sky130_fd_sc_hs__buf_8_36/A VSS VDD sky130_fd_sc_hs__a21oi_1
Xsky130_fd_sc_hs__a21oi_1_119 VDD VSS sky130_fd_sc_hs__nor2_1_105/Y sky130_fd_sc_hs__dfrtp_1_462/D
+ sky130_fd_sc_hs__o21ai_1_66/Y sky130_fd_sc_hs__buf_8_21/X VSS VDD sky130_fd_sc_hs__a21oi_1
Xsky130_fd_sc_hs__o31ai_1_0 VDD VSS sky130_fd_sc_hs__nor3_1_3/C sky130_fd_sc_hs__nor2_1_0/Y
+ sky130_fd_sc_hs__nand2_1_7/A sky130_fd_sc_hs__nor3_1_2/A sky130_fd_sc_hs__o31ai_1_0/Y
+ VSS VDD sky130_fd_sc_hs__o31ai_1
Xsky130_fd_sc_hs__nand3b_1_4 VDD VSS sky130_fd_sc_hs__nor3_1_48/A sky130_fd_sc_hs__nor3_1_48/C
+ sky130_fd_sc_hs__nor3_4_0/B sky130_fd_sc_hs__nor3_1_46/B VSS VDD sky130_fd_sc_hs__nand3b_1
Xsky130_fd_sc_hs__clkbuf_2_102 VDD VSS sky130_fd_sc_hs__clkbuf_2_102/X sky130_fd_sc_hs__clkinv_4_4/A
+ VSS VDD sky130_fd_sc_hs__clkbuf_2
Xsky130_fd_sc_hs__clkbuf_2_113 VDD VSS sky130_fd_sc_hs__clkinv_1_76/A sky130_fd_sc_hs__clkinv_4_5/A
+ VSS VDD sky130_fd_sc_hs__clkbuf_2
Xsky130_fd_sc_hs__clkbuf_2_124 VDD VSS sky130_fd_sc_hs__clkinv_1_84/A sky130_fd_sc_hs__clkinv_4_6/A
+ VSS VDD sky130_fd_sc_hs__clkbuf_2
Xsky130_fd_sc_hs__clkbuf_2_135 VDD VSS sky130_fd_sc_hs__clkinv_1_94/A sky130_fd_sc_hs__clkinv_4_5/A
+ VSS VDD sky130_fd_sc_hs__clkbuf_2
Xsky130_fd_sc_hs__nand2_1_102 VDD VSS sky130_fd_sc_hs__and2_1_26/X sky130_fd_sc_hs__a22o_1_86/B1
+ sky130_fd_sc_hs__xnor2_1_89/Y VSS VDD sky130_fd_sc_hs__nand2_1
Xsky130_fd_sc_hs__clkbuf_2_146 VDD VSS sky130_fd_sc_hs__clkbuf_2_147/A sky130_fd_sc_hs__inv_8_1/A
+ VSS VDD sky130_fd_sc_hs__clkbuf_2
Xsky130_fd_sc_hs__nand2_1_113 VDD VSS sky130_fd_sc_hs__or2_1_18/B sky130_fd_sc_hs__a31o_1_13/A2
+ sky130_fd_sc_hs__or2_1_18/A VSS VDD sky130_fd_sc_hs__nand2_1
Xsky130_fd_sc_hs__clkbuf_2_157 VDD VSS sky130_fd_sc_hs__clkbuf_2_157/X sky130_fd_sc_hs__clkbuf_2_157/A
+ VSS VDD sky130_fd_sc_hs__clkbuf_2
Xsky130_fd_sc_hs__nand2_1_124 VDD VSS sky130_fd_sc_hs__nor2_1_119/Y sky130_fd_sc_hs__nand3_1_30/C
+ sky130_fd_sc_hs__nor2_1_157/Y VSS VDD sky130_fd_sc_hs__nand2_1
Xsky130_fd_sc_hs__nand2_1_135 VDD VSS sky130_fd_sc_hs__nand2_1_136/Y sky130_fd_sc_hs__nand2_1_135/Y
+ sky130_fd_sc_hs__nand3_1_30/C VSS VDD sky130_fd_sc_hs__nand2_1
Xsky130_fd_sc_hs__clkbuf_2_168 VDD VSS sky130_fd_sc_hs__dfstp_1_3/CLK sky130_fd_sc_hs__clkbuf_2_236/A
+ VSS VDD sky130_fd_sc_hs__clkbuf_2
Xsky130_fd_sc_hs__nand2_1_146 VDD VSS sky130_fd_sc_hs__nor2_1_136/Y sky130_fd_sc_hs__nor3_1_38/C
+ sky130_fd_sc_hs__nor3_1_37/C VSS VDD sky130_fd_sc_hs__nand2_1
Xsky130_fd_sc_hs__clkbuf_2_179 VDD VSS sky130_fd_sc_hs__clkbuf_2_179/X sky130_fd_sc_hs__clkbuf_2_236/A
+ VSS VDD sky130_fd_sc_hs__clkbuf_2
Xsky130_fd_sc_hs__nand2_1_157 VDD VSS sky130_fd_sc_hs__nor3_1_40/Y sky130_fd_sc_hs__nand2_1_157/Y
+ sky130_fd_sc_hs__nor2_1_149/A VSS VDD sky130_fd_sc_hs__nand2_1
Xsky130_fd_sc_hs__nand2_1_168 VDD VSS sky130_fd_sc_hs__nor2_1_177/Y sky130_fd_sc_hs__o22ai_1_8/B2
+ sky130_fd_sc_hs__nor2_1_127/Y VSS VDD sky130_fd_sc_hs__nand2_1
Xsky130_fd_sc_hs__nand2_1_179 VDD VSS sky130_fd_sc_hs__nor3_1_47/B sky130_fd_sc_hs__or3_1_5/B
+ sky130_fd_sc_hs__nand4_1_9/C VSS VDD sky130_fd_sc_hs__nand2_1
Xsky130_fd_sc_hs__maj3_1_6 VDD VSS sky130_fd_sc_hs__or2_1_3/A sky130_fd_sc_hs__or2_1_3/B
+ sky130_fd_sc_hs__xor2_1_6/A sky130_fd_sc_hs__xor2_1_4/B VSS VDD sky130_fd_sc_hs__maj3_1
Xsky130_fd_sc_hs__nor2_2_7 VDD VSS sky130_fd_sc_hs__nor2_2_7/B sky130_fd_sc_hs__nor2_2_7/Y
+ sky130_fd_sc_hs__or2_1_25/A VSS VDD sky130_fd_sc_hs__nor2_2
Xsky130_fd_sc_hs__buf_8_14 VDD VSS sky130_fd_sc_hs__buf_8_14/X sky130_fd_sc_hs__nor2_4_0/Y
+ VSS VDD sky130_fd_sc_hs__buf_8
Xsky130_fd_sc_hs__buf_8_25 VDD VSS sky130_fd_sc_hs__buf_8_25/X sky130_fd_sc_hs__buf_8_25/A
+ VSS VDD sky130_fd_sc_hs__buf_8
Xsky130_fd_sc_hs__buf_8_36 VDD VSS sky130_fd_sc_hs__buf_8_36/X sky130_fd_sc_hs__buf_8_36/A
+ VSS VDD sky130_fd_sc_hs__buf_8
Xsky130_fd_sc_hs__dfrtp_1_608 sky130_fd_sc_hs__clkbuf_4_2/X VDD VSS sky130_fd_sc_hs__xor2_1_52/B
+ sky130_fd_sc_hs__clkinv_1_132/A sky130_fd_sc_hs__mux2_1_319/X VSS VDD sky130_fd_sc_hs__dfrtp_1
Xsky130_fd_sc_hs__dfrtp_1_619 sky130_fd_sc_hs__clkbuf_4_31/X VDD VSS sky130_fd_sc_hs__nand2_1_200/A
+ sky130_fd_sc_hs__clkbuf_2_192/A sky130_fd_sc_hs__mux2_1_323/X VSS VDD sky130_fd_sc_hs__dfrtp_1
Xsky130_fd_sc_hs__nor2_1_16 VDD VSS sky130_fd_sc_hs__o21a_1_5/A1 sky130_fd_sc_hs__nor2_1_16/Y
+ sky130_fd_sc_hs__and2_1_3/X VSS VDD sky130_fd_sc_hs__nor2_1
Xsky130_fd_sc_hs__nor2_1_27 VDD VSS sky130_fd_sc_hs__nor2_1_27/B sky130_fd_sc_hs__or2_1_5/A
+ sky130_fd_sc_hs__or2_1_3/A VSS VDD sky130_fd_sc_hs__nor2_1
Xsky130_fd_sc_hs__nor2_1_38 VDD VSS sky130_fd_sc_hs__xnor3_1_0/C sky130_fd_sc_hs__nor2_1_38/Y
+ sky130_fd_sc_hs__maj3_1_8/A VSS VDD sky130_fd_sc_hs__nor2_1
Xsky130_fd_sc_hs__nor2_1_49 VDD VSS sky130_fd_sc_hs__o32a_1_0/A2 sky130_fd_sc_hs__nor2_1_50/A
+ sky130_fd_sc_hs__and3_1_5/A VSS VDD sky130_fd_sc_hs__nor2_1
Xsky130_fd_sc_hs__o311ai_1_2 VDD VSS sky130_fd_sc_hs__or2_1_4/A sky130_fd_sc_hs__or2_1_5/A
+ sky130_fd_sc_hs__nand2_1_45/A sky130_fd_sc_hs__o311ai_1_2/B1 sky130_fd_sc_hs__and3_1_3/C
+ sky130_fd_sc_hs__or2_1_5/B VSS VDD sky130_fd_sc_hs__o311ai_1
Xsky130_fd_sc_hs__xnor2_1_105 VDD VSS sky130_fd_sc_hs__maj3_1_46/X sky130_fd_sc_hs__xnor2_1_105/Y
+ sky130_fd_sc_hs__xnor2_1_105/B VSS VDD sky130_fd_sc_hs__xnor2_1
Xsky130_fd_sc_hs__xnor2_1_116 VDD VSS sky130_fd_sc_hs__and2_1_25/X sky130_fd_sc_hs__a221o_1_0/B1
+ sky130_fd_sc_hs__nor2_1_83/Y VSS VDD sky130_fd_sc_hs__xnor2_1
Xsky130_fd_sc_hs__xnor2_1_127 VDD VSS sky130_fd_sc_hs__nor2_1_184/Y sky130_fd_sc_hs__xnor2_1_127/Y
+ sky130_fd_sc_hs__nor2_1_170/Y VSS VDD sky130_fd_sc_hs__xnor2_1
Xsky130_fd_sc_hs__xnor2_1_138 VDD VSS sky130_fd_sc_hs__o31ai_1_21/Y sky130_fd_sc_hs__xnor2_1_138/Y
+ sky130_fd_sc_hs__or2_1_31/X VSS VDD sky130_fd_sc_hs__xnor2_1
Xsky130_fd_sc_hs__xnor2_1_149 VDD VSS sky130_fd_sc_hs__maj3_1_51/X sky130_fd_sc_hs__a31o_1_14/A3
+ sky130_fd_sc_hs__nor2_1_99/B VSS VDD sky130_fd_sc_hs__xnor2_1
Xsky130_fd_sc_hs__mux2_1_12 VDD VSS sky130_fd_sc_hs__mux2_1_12/X sky130_fd_sc_hs__buf_16_0/X
+ sky130_fd_sc_hs__maj3_1_7/C sky130_fd_sc_hs__mux2_1_9/A1 VSS VDD sky130_fd_sc_hs__mux2_1
Xsky130_fd_sc_hs__mux2_1_23 VDD VSS sky130_fd_sc_hs__mux2_1_23/X sky130_fd_sc_hs__buf_16_5/X
+ sky130_fd_sc_hs__mux2_1_23/A0 sky130_fd_sc_hs__mux2_1_95/A1 VSS VDD sky130_fd_sc_hs__mux2_1
Xsky130_fd_sc_hs__mux2_1_34 VDD VSS sky130_fd_sc_hs__mux2_1_34/X sky130_fd_sc_hs__buf_16_1/A
+ sky130_fd_sc_hs__mux2_1_34/A0 sky130_fd_sc_hs__mux2_1_40/A0 VSS VDD sky130_fd_sc_hs__mux2_1
Xsky130_fd_sc_hs__mux2_1_45 VDD VSS sky130_fd_sc_hs__mux2_1_45/X sky130_fd_sc_hs__mux2_1_98/S
+ sky130_fd_sc_hs__mux2_1_45/A0 sky130_fd_sc_hs__mux2_1_61/A0 VSS VDD sky130_fd_sc_hs__mux2_1
Xsky130_fd_sc_hs__mux2_1_56 VDD VSS sky130_fd_sc_hs__mux2_1_56/X sky130_fd_sc_hs__buf_16_5/X
+ sky130_fd_sc_hs__mux2_1_56/A0 sky130_fd_sc_hs__mux2_1_61/A0 VSS VDD sky130_fd_sc_hs__mux2_1
Xsky130_fd_sc_hs__mux2_1_67 VDD VSS sky130_fd_sc_hs__mux2_1_67/X sky130_fd_sc_hs__mux2_1_9/S
+ sky130_fd_sc_hs__mux2_1_67/A0 sky130_fd_sc_hs__mux2_1_99/A0 VSS VDD sky130_fd_sc_hs__mux2_1
Xsky130_fd_sc_hs__mux2_1_78 VDD VSS sky130_fd_sc_hs__mux2_1_78/X sky130_fd_sc_hs__buf_16_1/X
+ sky130_fd_sc_hs__mux2_1_78/A0 sky130_fd_sc_hs__mux2_1_96/A0 VSS VDD sky130_fd_sc_hs__mux2_1
Xsky130_fd_sc_hs__mux2_1_89 VDD VSS sky130_fd_sc_hs__mux2_1_89/X sky130_fd_sc_hs__mux2_1_99/S
+ sky130_fd_sc_hs__mux2_1_94/A1 sky130_fd_sc_hs__mux2_1_89/A1 VSS VDD sky130_fd_sc_hs__mux2_1
Xsky130_fd_sc_hs__nor2b_1_16 VDD VSS sky130_fd_sc_hs__xor2_1_36/B sky130_fd_sc_hs__a31o_1_4/B1
+ sky130_fd_sc_hs__xor2_1_36/A VSS VDD sky130_fd_sc_hs__nor2b_1
Xsky130_fd_sc_hs__nor2b_1_27 VDD VSS sky130_fd_sc_hs__xnor2_1_95/Y sky130_fd_sc_hs__or3_1_9/A
+ sky130_fd_sc_hs__maj3_1_37/X VSS VDD sky130_fd_sc_hs__nor2b_1
Xsky130_fd_sc_hs__nor2b_1_38 VDD VSS sky130_fd_sc_hs__nor3_1_37/A sky130_fd_sc_hs__nor3_1_39/B
+ sky130_fd_sc_hs__nor3_1_37/B VSS VDD sky130_fd_sc_hs__nor2b_1
Xsky130_fd_sc_hs__nor2b_1_49 VDD VSS sky130_fd_sc_hs__or2_1_29/A sky130_fd_sc_hs__nor2b_1_49/Y
+ sky130_fd_sc_hs__or3b_1_0/A VSS VDD sky130_fd_sc_hs__nor2b_1
Xsky130_fd_sc_hs__a31o_1_12 VDD VSS sky130_fd_sc_hs__a31o_1_12/X sky130_fd_sc_hs__and2_1_26/A
+ sky130_fd_sc_hs__a31o_1_12/A2 sky130_fd_sc_hs__a31o_1_12/A1 sky130_fd_sc_hs__buf_8_12/X
+ VSS VDD sky130_fd_sc_hs__a31o_1
Xsky130_fd_sc_hs__o22ai_1_8 VDD VSS sky130_fd_sc_hs__o22ai_1_8/B2 sky130_fd_sc_hs__nand4_1_5/D
+ sky130_fd_sc_hs__o22ai_1_8/Y sky130_fd_sc_hs__nand4_1_5/C sky130_fd_sc_hs__o22ai_1_8/A1
+ VSS VDD sky130_fd_sc_hs__o22ai_1
Xsky130_fd_sc_hs__o22ai_1_14 VDD VSS sky130_fd_sc_hs__nand4_1_5/D sky130_fd_sc_hs__o22ai_1_14/B1
+ sky130_fd_sc_hs__buf_1_191/A sky130_fd_sc_hs__o22ai_1_14/A2 sky130_fd_sc_hs__nand4_1_5/C
+ VSS VDD sky130_fd_sc_hs__o22ai_1
Xsky130_fd_sc_hs__dfrtp_1_405 sky130_fd_sc_hs__clkbuf_4_16/X VDD VSS sky130_fd_sc_hs__a22o_1_84/A1
+ sky130_fd_sc_hs__clkinv_1_76/A sky130_fd_sc_hs__a22o_1_79/X VSS VDD sky130_fd_sc_hs__dfrtp_1
Xsky130_fd_sc_hs__dfrtp_1_416 sky130_fd_sc_hs__clkbuf_4_16/X VDD VSS sky130_fd_sc_hs__a22o_1_94/A1
+ sky130_fd_sc_hs__clkbuf_2_118/A sky130_fd_sc_hs__a22o_1_85/X VSS VDD sky130_fd_sc_hs__dfrtp_1
Xsky130_fd_sc_hs__dfrtp_1_427 sky130_fd_sc_hs__clkbuf_4_16/X VDD VSS sky130_fd_sc_hs__maj3_1_32/C
+ sky130_fd_sc_hs__clkinv_1_81/A sky130_fd_sc_hs__a22o_1_86/X VSS VDD sky130_fd_sc_hs__dfrtp_1
Xsky130_fd_sc_hs__dfrtp_1_438 sky130_fd_sc_hs__clkbuf_4_16/X VDD VSS sky130_fd_sc_hs__a22o_1_75/B2
+ sky130_fd_sc_hs__dfrtp_2_3/CLK sky130_fd_sc_hs__a22o_1_75/X VSS VDD sky130_fd_sc_hs__dfrtp_1
Xsky130_fd_sc_hs__dfrtp_1_449 sky130_fd_sc_hs__clkbuf_4_13/X VDD VSS sky130_fd_sc_hs__buf_1_130/A
+ sky130_fd_sc_hs__clkbuf_2_132/X sky130_fd_sc_hs__buf_1_179/X VSS VDD sky130_fd_sc_hs__dfrtp_1
Xsky130_fd_sc_hs__mux2_1_409 VDD VSS sky130_fd_sc_hs__mux2_1_409/X sky130_fd_sc_hs__buf_16_2/A
+ sky130_fd_sc_hs__a22o_1_88/B2 sky130_fd_sc_hs__mux2_1_409/A1 VSS VDD sky130_fd_sc_hs__mux2_1
Xsky130_fd_sc_hs__a311oi_1_7 VDD VSS sky130_fd_sc_hs__nor2_1_71/A sky130_fd_sc_hs__nor2_1_70/A
+ sky130_fd_sc_hs__and2_1_20/B sky130_fd_sc_hs__nor2_1_71/Y sky130_fd_sc_hs__or2_1_15/X
+ sky130_fd_sc_hs__nor3_1_20/C VSS VDD sky130_fd_sc_hs__a311oi_1
Xsky130_fd_sc_hs__or2_1_11 VDD VSS sky130_fd_sc_hs__or2_1_11/B sky130_fd_sc_hs__or2_1_11/A
+ sky130_fd_sc_hs__or2_1_11/X VSS VDD sky130_fd_sc_hs__or2_1
Xsky130_fd_sc_hs__or2_1_22 VDD VSS sky130_fd_sc_hs__or2_1_22/B sky130_fd_sc_hs__or2_1_22/A
+ sky130_fd_sc_hs__or2_1_22/X VSS VDD sky130_fd_sc_hs__or2_1
Xsky130_fd_sc_hs__dfrtp_1_202 sky130_fd_sc_hs__buf_8_0/X VDD VSS sky130_fd_sc_hs__mux2_1_71/A0
+ sky130_fd_sc_hs__clkbuf_2_32/X sky130_fd_sc_hs__mux2_1_71/X VSS VDD sky130_fd_sc_hs__dfrtp_1
Xsky130_fd_sc_hs__dfrtp_1_213 sky130_fd_sc_hs__clkbuf_4_4/X VDD VSS sky130_fd_sc_hs__mux2_1_65/A1
+ sky130_fd_sc_hs__clkbuf_2_1/X sky130_fd_sc_hs__mux2_1_65/X VSS VDD sky130_fd_sc_hs__dfrtp_1
Xsky130_fd_sc_hs__dfrtp_1_224 sky130_fd_sc_hs__buf_2_0/A VDD VSS sky130_fd_sc_hs__buf_1_12/A
+ sky130_fd_sc_hs__clkinv_1_46/A sky130_fd_sc_hs__mux2_1_186/X VSS VDD sky130_fd_sc_hs__dfrtp_1
Xsky130_fd_sc_hs__dfrtp_1_235 sky130_fd_sc_hs__buf_8_5/X VDD VSS sky130_fd_sc_hs__a32o_1_3/B2
+ sky130_fd_sc_hs__clkbuf_8_2/X sky130_fd_sc_hs__a32o_1_3/X VSS VDD sky130_fd_sc_hs__dfrtp_1
Xsky130_fd_sc_hs__dfrtp_1_246 sky130_fd_sc_hs__clkbuf_4_12/A VDD VSS sky130_fd_sc_hs__dfrtp_1_289/D
+ sky130_fd_sc_hs__clkbuf_2_72/X sky130_fd_sc_hs__o21a_1_16/A1 VSS VDD sky130_fd_sc_hs__dfrtp_1
Xsky130_fd_sc_hs__dfrtp_1_257 sky130_fd_sc_hs__buf_8_5/X VDD VSS sky130_fd_sc_hs__and3_1_8/B
+ sky130_fd_sc_hs__clkbuf_8_4/X sky130_fd_sc_hs__dfrtp_1_257/D VSS VDD sky130_fd_sc_hs__dfrtp_1
Xsky130_fd_sc_hs__dfrtp_1_268 sky130_fd_sc_hs__clkbuf_4_14/X VDD VSS sky130_fd_sc_hs__mux2_1_190/A1
+ sky130_fd_sc_hs__clkbuf_2_80/X sky130_fd_sc_hs__mux2_1_190/X VSS VDD sky130_fd_sc_hs__dfrtp_1
Xsky130_fd_sc_hs__dfrtp_1_279 sky130_fd_sc_hs__buf_2_0/A VDD VSS sky130_fd_sc_hs__nor3_1_17/A
+ sky130_fd_sc_hs__clkbuf_2_78/X sky130_fd_sc_hs__nor2_1_53/Y VSS VDD sky130_fd_sc_hs__dfrtp_1
Xsky130_fd_sc_hs__clkinv_1_12 VDD VSS sky130_fd_sc_hs__and2_1_0/A sky130_fd_sc_hs__nand2_1_3/A
+ VSS VDD sky130_fd_sc_hs__clkinv_1
Xsky130_fd_sc_hs__clkinv_1_23 VDD VSS sky130_fd_sc_hs__nor2_1_13/Y sky130_fd_sc_hs__clkinv_1_23/Y
+ VSS VDD sky130_fd_sc_hs__clkinv_1
Xsky130_fd_sc_hs__clkinv_1_34 VDD VSS sky130_fd_sc_hs__clkinv_1_34/A sky130_fd_sc_hs__clkinv_1_34/Y
+ VSS VDD sky130_fd_sc_hs__clkinv_1
Xsky130_fd_sc_hs__nor3b_1_1 VDD VSS sky130_fd_sc_hs__nor3b_1_1/Y sky130_fd_sc_hs__nor2b_1_40/Y
+ sky130_fd_sc_hs__xor2_1_75/A sky130_fd_sc_hs__nor3b_1_1/B VSS VDD sky130_fd_sc_hs__nor3b_1
Xsky130_fd_sc_hs__clkinv_1_45 VDD VSS sky130_fd_sc_hs__xor2_1_20/X sky130_fd_sc_hs__clkinv_1_45/Y
+ VSS VDD sky130_fd_sc_hs__clkinv_1
Xsky130_fd_sc_hs__clkinv_1_56 VDD VSS sky130_fd_sc_hs__clkinv_1_56/A sky130_fd_sc_hs__clkinv_1_56/Y
+ VSS VDD sky130_fd_sc_hs__clkinv_1
Xsky130_fd_sc_hs__clkbuf_2_9 VDD VSS sky130_fd_sc_hs__clkbuf_2_9/X sky130_fd_sc_hs__clkinv_4_0/A
+ VSS VDD sky130_fd_sc_hs__clkbuf_2
Xsky130_fd_sc_hs__clkinv_1_67 VDD VSS sky130_fd_sc_hs__a21o_1_3/X sky130_fd_sc_hs__a311o_1_5/B1
+ VSS VDD sky130_fd_sc_hs__clkinv_1
Xsky130_fd_sc_hs__clkinv_1_78 VDD VSS sky130_fd_sc_hs__nor2_1_83/A sky130_fd_sc_hs__clkinv_1_78/Y
+ VSS VDD sky130_fd_sc_hs__clkinv_1
Xsky130_fd_sc_hs__clkinv_1_89 VDD VSS sky130_fd_sc_hs__clkinv_1_89/A sky130_fd_sc_hs__clkinv_1_89/Y
+ VSS VDD sky130_fd_sc_hs__clkinv_1
Xsky130_fd_sc_hs__o21ai_1_7 VDD VSS sky130_fd_sc_hs__o21ai_1_7/Y sky130_fd_sc_hs__o21ai_1_7/B1
+ sky130_fd_sc_hs__and2_1_5/X sky130_fd_sc_hs__nor2_1_15/Y VSS VDD sky130_fd_sc_hs__o21ai_1
Xsky130_fd_sc_hs__dfrtp_1_780 sky130_fd_sc_hs__buf_8_30/X VDD VSS sky130_fd_sc_hs__maj3_1_52/C
+ sky130_fd_sc_hs__clkinv_1_145/A sky130_fd_sc_hs__mux2_1_344/X VSS VDD sky130_fd_sc_hs__dfrtp_1
Xsky130_fd_sc_hs__dfrtp_1_791 sky130_fd_sc_hs__clkbuf_4_15/X VDD VSS sky130_fd_sc_hs__and2_1_7/A
+ sky130_fd_sc_hs__clkbuf_2_39/X sky130_fd_sc_hs__nand2_1_237/Y VSS VDD sky130_fd_sc_hs__dfrtp_1
Xsky130_fd_sc_hs__clkinv_2_9 VDD VSS sky130_fd_sc_hs__clkinv_2_9/Y sky130_fd_sc_hs__clkinv_2_9/A
+ VSS VDD sky130_fd_sc_hs__clkinv_2
Xsky130_fd_sc_hs__o21ai_1_105 VDD VSS sky130_fd_sc_hs__o21ai_1_105/Y sky130_fd_sc_hs__buf_8_26/X
+ sky130_fd_sc_hs__and2_1_46/B sky130_fd_sc_hs__and2_1_46/A VSS VDD sky130_fd_sc_hs__o21ai_1
Xsky130_fd_sc_hs__mux2_1_206 VDD VSS sky130_fd_sc_hs__mux2_1_206/X sky130_fd_sc_hs__buf_16_3/A
+ sky130_fd_sc_hs__mux2_1_99/A0 sky130_fd_sc_hs__mux2_1_206/A1 VSS VDD sky130_fd_sc_hs__mux2_1
Xsky130_fd_sc_hs__mux2_1_217 VDD VSS sky130_fd_sc_hs__mux2_1_217/X sky130_fd_sc_hs__nor2_1_82/B
+ sky130_fd_sc_hs__xor2_1_38/A sky130_fd_sc_hs__nor2_1_64/Y VSS VDD sky130_fd_sc_hs__mux2_1
Xsky130_fd_sc_hs__mux2_1_228 VDD VSS sky130_fd_sc_hs__mux2_1_228/X sky130_fd_sc_hs__buf_16_13/A
+ sky130_fd_sc_hs__xor2_1_56/A sky130_fd_sc_hs__a22o_1_64/B2 VSS VDD sky130_fd_sc_hs__mux2_1
Xsky130_fd_sc_hs__mux2_1_239 VDD VSS sky130_fd_sc_hs__mux2_1_239/X sky130_fd_sc_hs__mux2_1_370/S
+ sky130_fd_sc_hs__maj3_1_35/C sky130_fd_sc_hs__dfrtp_2_1/Q VSS VDD sky130_fd_sc_hs__mux2_1
Xsky130_fd_sc_hs__nand3_1_3 VDD VSS sky130_fd_sc_hs__nand3_1_3/C sky130_fd_sc_hs__nand3_1_3/Y
+ sky130_fd_sc_hs__nand3_1_3/B sky130_fd_sc_hs__nand3_1_3/A VSS VDD sky130_fd_sc_hs__nand3_1
Xsky130_fd_sc_hs__xnor2_1_40 VDD VSS sky130_fd_sc_hs__maj3_1_8/A sky130_fd_sc_hs__xnor2_1_40/Y
+ sky130_fd_sc_hs__maj3_1_8/B VSS VDD sky130_fd_sc_hs__xnor2_1
Xsky130_fd_sc_hs__xnor2_1_51 VDD VSS sky130_fd_sc_hs__xnor2_1_51/A sky130_fd_sc_hs__xnor2_1_51/Y
+ sky130_fd_sc_hs__xnor2_1_51/B VSS VDD sky130_fd_sc_hs__xnor2_1
Xsky130_fd_sc_hs__xnor2_1_62 VDD VSS sky130_fd_sc_hs__maj3_1_23/C sky130_fd_sc_hs__xor2_1_37/B
+ sky130_fd_sc_hs__xor2_1_42/X VSS VDD sky130_fd_sc_hs__xnor2_1
Xsky130_fd_sc_hs__xnor2_1_73 VDD VSS sky130_fd_sc_hs__xnor2_1_73/A sky130_fd_sc_hs__xnor2_1_73/Y
+ sky130_fd_sc_hs__xnor2_1_73/B VSS VDD sky130_fd_sc_hs__xnor2_1
Xsky130_fd_sc_hs__xnor2_1_84 VDD VSS sky130_fd_sc_hs__xnor2_1_84/A sky130_fd_sc_hs__xnor2_1_84/Y
+ sky130_fd_sc_hs__xnor2_1_84/B VSS VDD sky130_fd_sc_hs__xnor2_1
Xsky130_fd_sc_hs__xnor2_1_95 VDD VSS sky130_fd_sc_hs__maj3_1_36/C sky130_fd_sc_hs__xnor2_1_95/Y
+ sky130_fd_sc_hs__xor2_1_67/X VSS VDD sky130_fd_sc_hs__xnor2_1
Xsky130_fd_sc_hs__clkbuf_8_19 VDD VSS sky130_fd_sc_hs__clkbuf_8_19/X clk VSS VDD sky130_fd_sc_hs__clkbuf_8
Xsky130_fd_sc_hs__a32o_1_14 VDD VSS sky130_fd_sc_hs__a32o_1_14/X sky130_fd_sc_hs__or3b_1_0/A
+ sky130_fd_sc_hs__o21ai_1_58/Y sky130_fd_sc_hs__nor3_4_8/B sky130_fd_sc_hs__or3_1_3/C
+ sky130_fd_sc_hs__or2_1_29/X VSS VDD sky130_fd_sc_hs__a32o_1
Xsky130_fd_sc_hs__a21oi_1_109 VDD VSS sky130_fd_sc_hs__a21oi_1_108/Y sky130_fd_sc_hs__nor2_1_91/B
+ sky130_fd_sc_hs__o21a_1_20/X sky130_fd_sc_hs__nand2b_1_40/B VSS VDD sky130_fd_sc_hs__a21oi_1
Xsky130_fd_sc_hs__o31ai_1_1 VDD VSS sky130_fd_sc_hs__o21a_1_2/A2 sky130_fd_sc_hs__o21a_1_2/A1
+ sky130_fd_sc_hs__buf_8_26/X sky130_fd_sc_hs__o21a_1_2/B1 sky130_fd_sc_hs__o31ai_1_1/Y
+ VSS VDD sky130_fd_sc_hs__o31ai_1
Xsky130_fd_sc_hs__nand3b_1_5 VDD VSS sky130_fd_sc_hs__or2_1_30/B sky130_fd_sc_hs__nor3_1_44/B
+ sky130_fd_sc_hs__nor3b_1_3/B sky130_fd_sc_hs__or2_1_30/A VSS VDD sky130_fd_sc_hs__nand3b_1
Xsky130_fd_sc_hs__clkbuf_2_103 VDD VSS sky130_fd_sc_hs__clkbuf_2_103/X sky130_fd_sc_hs__clkinv_4_4/A
+ VSS VDD sky130_fd_sc_hs__clkbuf_2
Xsky130_fd_sc_hs__clkbuf_2_114 VDD VSS sky130_fd_sc_hs__clkinv_1_77/A sky130_fd_sc_hs__clkinv_4_5/A
+ VSS VDD sky130_fd_sc_hs__clkbuf_2
Xsky130_fd_sc_hs__clkbuf_2_125 VDD VSS sky130_fd_sc_hs__a22o_1_90/B1 sky130_fd_sc_hs__buf_8_16/A
+ VSS VDD sky130_fd_sc_hs__clkbuf_2
Xsky130_fd_sc_hs__nand2_1_103 VDD VSS sky130_fd_sc_hs__and4_1_5/X sky130_fd_sc_hs__nor2_1_86/B
+ sky130_fd_sc_hs__nor2_1_88/A VSS VDD sky130_fd_sc_hs__nand2_1
Xsky130_fd_sc_hs__clkbuf_2_136 VDD VSS sky130_fd_sc_hs__clkinv_1_95/A sky130_fd_sc_hs__clkinv_4_7/A
+ VSS VDD sky130_fd_sc_hs__clkbuf_2
Xsky130_fd_sc_hs__clkbuf_2_147 VDD VSS sky130_fd_sc_hs__clkbuf_2_147/X sky130_fd_sc_hs__clkbuf_2_147/A
+ VSS VDD sky130_fd_sc_hs__clkbuf_2
Xsky130_fd_sc_hs__nand2_1_114 VDD VSS sky130_fd_sc_hs__o21ai_1_49/Y sky130_fd_sc_hs__nand2_1_114/Y
+ sky130_fd_sc_hs__o21a_1_4/B1 VSS VDD sky130_fd_sc_hs__nand2_1
Xsky130_fd_sc_hs__nand2_1_125 VDD VSS sky130_fd_sc_hs__o211ai_1_9/B1 sky130_fd_sc_hs__nand2_1_125/Y
+ sky130_fd_sc_hs__nand2_2_2/B VSS VDD sky130_fd_sc_hs__nand2_1
Xsky130_fd_sc_hs__clkbuf_2_158 VDD VSS sky130_fd_sc_hs__clkinv_1_108/A sky130_fd_sc_hs__clkbuf_2_176/A
+ VSS VDD sky130_fd_sc_hs__clkbuf_2
Xsky130_fd_sc_hs__nand2_1_136 VDD VSS sky130_fd_sc_hs__nand4_1_5/Y sky130_fd_sc_hs__nand2_1_136/Y
+ sky130_fd_sc_hs__buf_1_175/A VSS VDD sky130_fd_sc_hs__nand2_1
Xsky130_fd_sc_hs__clkbuf_2_169 VDD VSS sky130_fd_sc_hs__clkinv_1_121/A sky130_fd_sc_hs__clkbuf_2_236/A
+ VSS VDD sky130_fd_sc_hs__clkbuf_2
Xsky130_fd_sc_hs__nand2_1_147 VDD VSS sky130_fd_sc_hs__nand4_1_7/D sky130_fd_sc_hs__mux2i_1_2/S
+ sky130_fd_sc_hs__xor2_1_75/B VSS VDD sky130_fd_sc_hs__nand2_1
Xsky130_fd_sc_hs__nand2_1_158 VDD VSS sky130_fd_sc_hs__and2_1_36/X sky130_fd_sc_hs__nand2_1_159/B
+ sky130_fd_sc_hs__nor3_1_44/B VSS VDD sky130_fd_sc_hs__nand2_1
Xsky130_fd_sc_hs__nand2_1_169 VDD VSS sky130_fd_sc_hs__and2_1_37/X sky130_fd_sc_hs__o22ai_1_9/B2
+ sky130_fd_sc_hs__nor2b_1_48/Y VSS VDD sky130_fd_sc_hs__nand2_1
Xsky130_fd_sc_hs__a222o_1_0 VDD VSS sky130_fd_sc_hs__buf_16_8/X sky130_fd_sc_hs__a222o_1_0/X
+ sky130_fd_sc_hs__mux2_1_0/A1 sky130_fd_sc_hs__dfrtp_1_1/Q sky130_fd_sc_hs__a222o_1_2/A2
+ sky130_fd_sc_hs__mux2_1_2/A0 sky130_fd_sc_hs__a22oi_1_6/A2 VSS VDD sky130_fd_sc_hs__a222o_1
Xsky130_fd_sc_hs__maj3_1_7 VDD VSS sky130_fd_sc_hs__maj3_1_7/A sky130_fd_sc_hs__maj3_1_7/B
+ sky130_fd_sc_hs__maj3_1_7/X sky130_fd_sc_hs__maj3_1_7/C VSS VDD sky130_fd_sc_hs__maj3_1
Xsky130_fd_sc_hs__o22a_1_0 VDD VSS sky130_fd_sc_hs__o22a_1_0/X sky130_fd_sc_hs__o22a_1_0/B1
+ sky130_fd_sc_hs__o22a_1_0/A2 sky130_fd_sc_hs__or2_1_23/X sky130_fd_sc_hs__o22a_1_0/A1
+ VSS VDD sky130_fd_sc_hs__o22a_1
Xsky130_fd_sc_hs__nor2_2_8 VDD VSS sky130_fd_sc_hs__nor2_2_8/B sky130_fd_sc_hs__nor2_2_8/Y
+ sky130_fd_sc_hs__or3_1_6/A VSS VDD sky130_fd_sc_hs__nor2_2
Xsky130_fd_sc_hs__buf_8_15 VDD VSS sky130_fd_sc_hs__buf_8_15/X sky130_fd_sc_hs__buf_8_15/A
+ VSS VDD sky130_fd_sc_hs__buf_8
Xsky130_fd_sc_hs__buf_8_26 VDD VSS sky130_fd_sc_hs__buf_8_26/X sky130_fd_sc_hs__nor2_4_3/Y
+ VSS VDD sky130_fd_sc_hs__buf_8
Xsky130_fd_sc_hs__buf_8_37 VDD VSS sky130_fd_sc_hs__buf_8_37/X sky130_fd_sc_hs__buf_8_37/A
+ VSS VDD sky130_fd_sc_hs__buf_8
Xsky130_fd_sc_hs__dfrtp_1_609 sky130_fd_sc_hs__clkbuf_4_31/X VDD VSS sky130_fd_sc_hs__mux2_1_318/A1
+ sky130_fd_sc_hs__clkinv_1_132/A sky130_fd_sc_hs__mux2_1_318/X VSS VDD sky130_fd_sc_hs__dfrtp_1
Xsky130_fd_sc_hs__nor2_1_17 VDD VSS sky130_fd_sc_hs__nor2_1_17/B sky130_fd_sc_hs__nor2_1_17/Y
+ sky130_fd_sc_hs__buf_8_19/X VSS VDD sky130_fd_sc_hs__nor2_1
Xsky130_fd_sc_hs__nor2_1_28 VDD VSS sky130_fd_sc_hs__nor2_1_29/Y sky130_fd_sc_hs__and3_1_2/B
+ sky130_fd_sc_hs__and2_1_8/X VSS VDD sky130_fd_sc_hs__nor2_1
Xsky130_fd_sc_hs__nor2_1_39 VDD VSS sky130_fd_sc_hs__maj3_1_8/B sky130_fd_sc_hs__nor2_1_39/Y
+ sky130_fd_sc_hs__maj3_1_8/A VSS VDD sky130_fd_sc_hs__nor2_1
Xsky130_fd_sc_hs__o311ai_1_3 VDD VSS sky130_fd_sc_hs__xor2_1_6/X sky130_fd_sc_hs__or2_1_2/A
+ sky130_fd_sc_hs__o21a_1_3/B1 sky130_fd_sc_hs__and2_1_10/A sky130_fd_sc_hs__o311ai_1_3/Y
+ sky130_fd_sc_hs__or2_1_2/B VSS VDD sky130_fd_sc_hs__o311ai_1
Xsky130_fd_sc_hs__xnor2_1_106 VDD VSS sky130_fd_sc_hs__maj3_1_44/C sky130_fd_sc_hs__maj3_1_43/C
+ sky130_fd_sc_hs__xor2_1_71/X VSS VDD sky130_fd_sc_hs__xnor2_1
Xsky130_fd_sc_hs__xnor2_1_117 VDD VSS sky130_fd_sc_hs__maj3_1_37/C sky130_fd_sc_hs__xnor2_1_97/B
+ sky130_fd_sc_hs__xor2_1_76/X VSS VDD sky130_fd_sc_hs__xnor2_1
Xsky130_fd_sc_hs__xnor2_1_128 VDD VSS sky130_fd_sc_hs__maj3_1_54/X sky130_fd_sc_hs__xnor2_1_128/Y
+ sky130_fd_sc_hs__xnor2_1_129/Y VSS VDD sky130_fd_sc_hs__xnor2_1
Xsky130_fd_sc_hs__xnor2_1_139 VDD VSS sky130_fd_sc_hs__xor2_1_88/A sky130_fd_sc_hs__xnor2_1_139/Y
+ sky130_fd_sc_hs__xor2_1_87/X VSS VDD sky130_fd_sc_hs__xnor2_1
Xsky130_fd_sc_hs__mux2_1_13 VDD VSS sky130_fd_sc_hs__mux2_1_13/X sky130_fd_sc_hs__buf_16_5/X
+ sky130_fd_sc_hs__dfrtp_1_9/Q sky130_fd_sc_hs__mux2_1_9/A1 VSS VDD sky130_fd_sc_hs__mux2_1
Xsky130_fd_sc_hs__mux2_1_24 VDD VSS sky130_fd_sc_hs__mux2_1_24/X sky130_fd_sc_hs__mux2_1_98/S
+ sky130_fd_sc_hs__mux2_1_24/A0 sky130_fd_sc_hs__mux2_1_7/A1 VSS VDD sky130_fd_sc_hs__mux2_1
Xsky130_fd_sc_hs__mux2_1_35 VDD VSS sky130_fd_sc_hs__mux2_1_35/X sky130_fd_sc_hs__mux2_1_7/S
+ sky130_fd_sc_hs__mux2_1_35/A0 sky130_fd_sc_hs__mux2_1_95/A1 VSS VDD sky130_fd_sc_hs__mux2_1
Xsky130_fd_sc_hs__mux2_1_46 VDD VSS sky130_fd_sc_hs__mux2_1_46/X sky130_fd_sc_hs__mux2_1_6/S
+ sky130_fd_sc_hs__mux2_1_96/A0 sky130_fd_sc_hs__mux2_1_46/A1 VSS VDD sky130_fd_sc_hs__mux2_1
Xsky130_fd_sc_hs__mux2_1_57 VDD VSS sky130_fd_sc_hs__mux2_1_57/X sky130_fd_sc_hs__mux2_1_94/S
+ sky130_fd_sc_hs__maj3_1_1/B sky130_fd_sc_hs__mux2_1_96/A0 VSS VDD sky130_fd_sc_hs__mux2_1
Xsky130_fd_sc_hs__mux2_1_68 VDD VSS sky130_fd_sc_hs__mux2_1_68/X sky130_fd_sc_hs__mux2_1_1/S
+ sky130_fd_sc_hs__mux2_1_99/A0 sky130_fd_sc_hs__mux2_1_68/A1 VSS VDD sky130_fd_sc_hs__mux2_1
Xsky130_fd_sc_hs__mux2_1_79 VDD VSS sky130_fd_sc_hs__mux2_1_79/X sky130_fd_sc_hs__buf_16_2/X
+ sky130_fd_sc_hs__mux2_1_95/A1 sky130_fd_sc_hs__mux2_1_79/A1 VSS VDD sky130_fd_sc_hs__mux2_1
Xsky130_fd_sc_hs__nor2b_1_17 VDD VSS sky130_fd_sc_hs__maj3_1_25/X sky130_fd_sc_hs__nor2b_1_17/Y
+ sky130_fd_sc_hs__xnor2_1_61/B VSS VDD sky130_fd_sc_hs__nor2b_1
Xsky130_fd_sc_hs__nor2b_1_28 VDD VSS sky130_fd_sc_hs__maj3_1_37/X sky130_fd_sc_hs__o31a_1_3/A2
+ sky130_fd_sc_hs__xnor2_1_95/Y VSS VDD sky130_fd_sc_hs__nor2b_1
Xsky130_fd_sc_hs__nor2b_1_39 VDD VSS sky130_fd_sc_hs__nor3_1_39/B sky130_fd_sc_hs__nor2b_1_39/Y
+ sky130_fd_sc_hs__nor3_1_37/C VSS VDD sky130_fd_sc_hs__nor2b_1
Xsky130_fd_sc_hs__a31o_1_13 VDD VSS sky130_fd_sc_hs__a31o_1_13/X sky130_fd_sc_hs__or2_1_18/X
+ sky130_fd_sc_hs__a31o_1_13/A2 sky130_fd_sc_hs__o31ai_1_10/Y sky130_fd_sc_hs__buf_8_37/A
+ VSS VDD sky130_fd_sc_hs__a31o_1
Xsky130_fd_sc_hs__o22ai_1_9 VDD VSS sky130_fd_sc_hs__o22ai_1_9/B2 sky130_fd_sc_hs__nand4_1_5/D
+ sky130_fd_sc_hs__o22ai_1_9/Y sky130_fd_sc_hs__nand4_1_5/C sky130_fd_sc_hs__o22ai_1_9/A1
+ VSS VDD sky130_fd_sc_hs__o22ai_1
Xsky130_fd_sc_hs__o22ai_1_15 VDD VSS sky130_fd_sc_hs__o22ai_1_15/B2 sky130_fd_sc_hs__a21oi_1_85/Y
+ sky130_fd_sc_hs__o22ai_1_15/Y sky130_fd_sc_hs__xor2_1_47/X sky130_fd_sc_hs__buf_8_2/X
+ VSS VDD sky130_fd_sc_hs__o22ai_1
Xsky130_fd_sc_hs__dfrtp_1_406 sky130_fd_sc_hs__clkbuf_4_16/X VDD VSS sky130_fd_sc_hs__a22o_1_97/A1
+ sky130_fd_sc_hs__clkinv_1_79/A sky130_fd_sc_hs__a22o_1_83/X VSS VDD sky130_fd_sc_hs__dfrtp_1
Xsky130_fd_sc_hs__dfrtp_1_417 sky130_fd_sc_hs__clkbuf_4_19/X VDD VSS sky130_fd_sc_hs__maj3_1_33/C
+ sky130_fd_sc_hs__clkinv_1_81/A sky130_fd_sc_hs__dfrtp_1_417/D VSS VDD sky130_fd_sc_hs__dfrtp_1
Xsky130_fd_sc_hs__dfrtp_1_428 sky130_fd_sc_hs__clkbuf_4_19/X VDD VSS sky130_fd_sc_hs__a222o_1_4/C2
+ sky130_fd_sc_hs__clkbuf_2_129/A sky130_fd_sc_hs__mux2_1_243/X VSS VDD sky130_fd_sc_hs__dfrtp_1
Xsky130_fd_sc_hs__dfrtp_1_439 sky130_fd_sc_hs__clkbuf_4_19/X VDD VSS sky130_fd_sc_hs__a22o_1_95/B2
+ sky130_fd_sc_hs__dfrtp_2_2/CLK sky130_fd_sc_hs__a22o_1_95/X VSS VDD sky130_fd_sc_hs__dfrtp_1
Xsky130_fd_sc_hs__a311oi_1_8 VDD VSS sky130_fd_sc_hs__nor2b_1_23/Y sky130_fd_sc_hs__nor2_1_74/A
+ sky130_fd_sc_hs__and2_1_24/B sky130_fd_sc_hs__xnor2_1_81/A sky130_fd_sc_hs__and2_1_24/A
+ sky130_fd_sc_hs__o31ai_1_8/A3 VSS VDD sky130_fd_sc_hs__a311oi_1
Xsky130_fd_sc_hs__or2_1_12 VDD VSS sky130_fd_sc_hs__or2_1_12/B sky130_fd_sc_hs__or2_1_12/A
+ sky130_fd_sc_hs__or2_1_12/X VSS VDD sky130_fd_sc_hs__or2_1
Xsky130_fd_sc_hs__or2_1_23 VDD VSS sky130_fd_sc_hs__or2_1_23/B sky130_fd_sc_hs__or2_1_23/A
+ sky130_fd_sc_hs__or2_1_23/X VSS VDD sky130_fd_sc_hs__or2_1
Xsky130_fd_sc_hs__dfrtp_1_203 sky130_fd_sc_hs__buf_8_0/X VDD VSS sky130_fd_sc_hs__mux2_1_74/A0
+ sky130_fd_sc_hs__clkbuf_2_3/X sky130_fd_sc_hs__mux2_1_74/X VSS VDD sky130_fd_sc_hs__dfrtp_1
Xsky130_fd_sc_hs__dfrtp_1_214 sky130_fd_sc_hs__clkbuf_4_4/X VDD VSS sky130_fd_sc_hs__a22oi_1_2/B2
+ sky130_fd_sc_hs__clkbuf_2_1/X sky130_fd_sc_hs__mux2_1_183/X VSS VDD sky130_fd_sc_hs__dfrtp_1
Xsky130_fd_sc_hs__dfrtp_1_225 sky130_fd_sc_hs__buf_8_4/X VDD VSS sky130_fd_sc_hs__nor2_2_0/A
+ sky130_fd_sc_hs__clkbuf_2_81/X sky130_fd_sc_hs__nor2_1_47/Y VSS VDD sky130_fd_sc_hs__dfrtp_1
Xsky130_fd_sc_hs__dfrtp_1_236 sky130_fd_sc_hs__buf_8_5/X VDD VSS sky130_fd_sc_hs__dfrtp_1_243/D
+ sky130_fd_sc_hs__clkbuf_8_4/X sky130_fd_sc_hs__and3_1_5/A VSS VDD sky130_fd_sc_hs__dfrtp_1
Xsky130_fd_sc_hs__dfrtp_1_247 sky130_fd_sc_hs__clkbuf_4_12/A VDD VSS sky130_fd_sc_hs__dfrtp_1_285/D
+ sky130_fd_sc_hs__clkbuf_2_74/X sky130_fd_sc_hs__a22o_1_29/A1 VSS VDD sky130_fd_sc_hs__dfrtp_1
Xsky130_fd_sc_hs__dfrtp_1_258 sky130_fd_sc_hs__buf_8_5/X VDD VSS sky130_fd_sc_hs__dfrtp_1_258/Q
+ sky130_fd_sc_hs__clkbuf_8_4/X sky130_fd_sc_hs__dfrtp_1_258/D VSS VDD sky130_fd_sc_hs__dfrtp_1
Xsky130_fd_sc_hs__dfrtp_1_269 sky130_fd_sc_hs__buf_8_8/X VDD VSS sky130_fd_sc_hs__mux2_1_193/A0
+ sky130_fd_sc_hs__clkbuf_2_80/X sky130_fd_sc_hs__mux2_1_193/X VSS VDD sky130_fd_sc_hs__dfrtp_1
Xsky130_fd_sc_hs__clkinv_1_13 VDD VSS sky130_fd_sc_hs__clkinv_1_13/A sky130_fd_sc_hs__clkinv_1_13/Y
+ VSS VDD sky130_fd_sc_hs__clkinv_1
Xsky130_fd_sc_hs__clkinv_1_24 VDD VSS sky130_fd_sc_hs__clkinv_1_24/A sky130_fd_sc_hs__clkinv_1_24/Y
+ VSS VDD sky130_fd_sc_hs__clkinv_1
Xsky130_fd_sc_hs__nor3b_1_2 VDD VSS sky130_fd_sc_hs__nor3b_1_2/Y sky130_fd_sc_hs__or3b_1_0/A
+ sky130_fd_sc_hs__or2_1_29/A sky130_fd_sc_hs__or3b_1_0/B VSS VDD sky130_fd_sc_hs__nor3b_1
Xsky130_fd_sc_hs__clkinv_1_35 VDD VSS sky130_fd_sc_hs__clkinv_1_35/A sky130_fd_sc_hs__clkinv_1_35/Y
+ VSS VDD sky130_fd_sc_hs__clkinv_1
Xsky130_fd_sc_hs__clkinv_1_46 VDD VSS sky130_fd_sc_hs__clkinv_1_46/A sky130_fd_sc_hs__clkinv_1_46/Y
+ VSS VDD sky130_fd_sc_hs__clkinv_1
Xsky130_fd_sc_hs__clkinv_1_57 VDD VSS sky130_fd_sc_hs__clkinv_1_57/A sky130_fd_sc_hs__clkinv_1_57/Y
+ VSS VDD sky130_fd_sc_hs__clkinv_1
Xsky130_fd_sc_hs__clkinv_1_68 VDD VSS sky130_fd_sc_hs__o211ai_1_5/Y sky130_fd_sc_hs__a31o_1_8/B1
+ VSS VDD sky130_fd_sc_hs__clkinv_1
Xsky130_fd_sc_hs__clkinv_1_79 VDD VSS sky130_fd_sc_hs__clkinv_1_79/A sky130_fd_sc_hs__clkinv_1_79/Y
+ VSS VDD sky130_fd_sc_hs__clkinv_1
Xsky130_fd_sc_hs__o21ai_1_8 VDD VSS sky130_fd_sc_hs__o21ai_1_8/Y sky130_fd_sc_hs__buf_8_2/X
+ sky130_fd_sc_hs__buf_8_10/X sky130_fd_sc_hs__maj3_1_4/A VSS VDD sky130_fd_sc_hs__o21ai_1
Xsky130_fd_sc_hs__dfrtp_1_770 sky130_fd_sc_hs__clkbuf_4_28/X VDD VSS sky130_fd_sc_hs__mux2_1_465/A1
+ sky130_fd_sc_hs__dfstp_1_3/CLK sky130_fd_sc_hs__mux2_1_465/X VSS VDD sky130_fd_sc_hs__dfrtp_1
Xsky130_fd_sc_hs__dfrtp_1_781 sky130_fd_sc_hs__buf_8_34/X VDD VSS sky130_fd_sc_hs__xnor3_1_1/C
+ sky130_fd_sc_hs__clkbuf_2_228/X sky130_fd_sc_hs__mux2_1_385/X VSS VDD sky130_fd_sc_hs__dfrtp_1
Xsky130_fd_sc_hs__dfrtp_2_0 sky130_fd_sc_hs__buf_8_6/X VDD VSS sky130_fd_sc_hs__dfrtp_2_0/D
+ sky130_fd_sc_hs__clkbuf_8_4/X sky130_fd_sc_hs__buf_8_5/A VSS VDD sky130_fd_sc_hs__dfrtp_2
Xsky130_fd_sc_hs__dfrtp_1_792 sky130_fd_sc_hs__clkbuf_4_31/X VDD VSS sky130_fd_sc_hs__or2_1_18/A
+ sky130_fd_sc_hs__clkbuf_2_193/X sky130_fd_sc_hs__a22o_1_122/X VSS VDD sky130_fd_sc_hs__dfrtp_1
Xsky130_fd_sc_hs__o21ai_1_106 VDD VSS sky130_fd_sc_hs__o21ai_1_106/Y sky130_fd_sc_hs__nor2_4_2/Y
+ sky130_fd_sc_hs__xor2_1_88/X sky130_fd_sc_hs__maj3_1_63/C VSS VDD sky130_fd_sc_hs__o21ai_1
Xsky130_fd_sc_hs__mux2_1_207 VDD VSS sky130_fd_sc_hs__mux2_1_207/X sky130_fd_sc_hs__mux2_1_5/S
+ sky130_fd_sc_hs__mux2_1_207/A0 sky130_fd_sc_hs__mux2_1_99/A0 VSS VDD sky130_fd_sc_hs__mux2_1
Xsky130_fd_sc_hs__mux2_1_218 VDD VSS sky130_fd_sc_hs__mux2_1_218/X sky130_fd_sc_hs__nor2_1_66/B
+ sky130_fd_sc_hs__xor2_1_42/B sky130_fd_sc_hs__a21oi_1_49/Y VSS VDD sky130_fd_sc_hs__mux2_1
Xsky130_fd_sc_hs__mux2_1_229 VDD VSS sky130_fd_sc_hs__mux2_1_229/X sky130_fd_sc_hs__mux2_1_397/S
+ sky130_fd_sc_hs__xor2_1_54/A sky130_fd_sc_hs__mux2_1_477/A1 VSS VDD sky130_fd_sc_hs__mux2_1
Xsky130_fd_sc_hs__nand3_1_4 VDD VSS sky130_fd_sc_hs__nand3_1_4/C sky130_fd_sc_hs__nor3_1_0/C
+ sky130_fd_sc_hs__nand3_1_4/B sky130_fd_sc_hs__nand3_1_4/A VSS VDD sky130_fd_sc_hs__nand3_1
Xsky130_fd_sc_hs__nor3_1_0 VDD VSS sky130_fd_sc_hs__nor3_1_0/Y sky130_fd_sc_hs__nor3_1_0/C
+ sky130_fd_sc_hs__nor3_1_0/B sky130_fd_sc_hs__nor3_1_0/A VSS VDD sky130_fd_sc_hs__nor3_1
Xsky130_fd_sc_hs__xnor2_1_30 VDD VSS sky130_fd_sc_hs__a21o_1_0/X sky130_fd_sc_hs__xnor2_1_30/Y
+ sky130_fd_sc_hs__xnor2_1_30/B VSS VDD sky130_fd_sc_hs__xnor2_1
Xsky130_fd_sc_hs__xnor2_1_41 VDD VSS sky130_fd_sc_hs__xor2_1_18/A sky130_fd_sc_hs__and3_1_3/B
+ sky130_fd_sc_hs__nor2b_1_8/A VSS VDD sky130_fd_sc_hs__xnor2_1
Xsky130_fd_sc_hs__xnor2_1_52 VDD VSS sky130_fd_sc_hs__maj3_1_14/C sky130_fd_sc_hs__xnor2_1_52/Y
+ sky130_fd_sc_hs__xor2_1_24/X VSS VDD sky130_fd_sc_hs__xnor2_1
Xsky130_fd_sc_hs__xnor2_1_63 VDD VSS sky130_fd_sc_hs__maj3_1_27/C sky130_fd_sc_hs__xnor2_1_64/B
+ sky130_fd_sc_hs__xor2_1_39/X VSS VDD sky130_fd_sc_hs__xnor2_1
Xsky130_fd_sc_hs__xnor2_1_74 VDD VSS sky130_fd_sc_hs__maj3_1_21/C sky130_fd_sc_hs__xor2_1_40/B
+ sky130_fd_sc_hs__xor2_1_33/X VSS VDD sky130_fd_sc_hs__xnor2_1
Xsky130_fd_sc_hs__xnor2_1_85 VDD VSS sky130_fd_sc_hs__xnor2_1_85/A sky130_fd_sc_hs__xor2_1_57/B
+ sky130_fd_sc_hs__or2_1_12/B VSS VDD sky130_fd_sc_hs__xnor2_1
Xsky130_fd_sc_hs__xnor2_1_96 VDD VSS sky130_fd_sc_hs__maj3_1_38/C sky130_fd_sc_hs__xnor2_1_96/Y
+ sky130_fd_sc_hs__xor2_1_66/X VSS VDD sky130_fd_sc_hs__xnor2_1
Xsky130_fd_sc_hs__a22oi_1_0 VDD VSS sky130_fd_sc_hs__dfrtp_1_4/Q sky130_fd_sc_hs__nand2_1_0/B
+ sky130_fd_sc_hs__buf_16_7/X sky130_fd_sc_hs__nand2_1_33/B sky130_fd_sc_hs__mux2_1_3/A0
+ VSS VDD sky130_fd_sc_hs__a22oi_1
Xsky130_fd_sc_hs__a32o_1_15 VDD VSS sky130_fd_sc_hs__a32o_1_15/X sky130_fd_sc_hs__maj3_1_18/C
+ sky130_fd_sc_hs__a32o_1_7/B1 sky130_fd_sc_hs__a32o_1_15/A2 sky130_fd_sc_hs__buf_8_14/X
+ sky130_fd_sc_hs__or3_1_9/X VSS VDD sky130_fd_sc_hs__a32o_1
Xsky130_fd_sc_hs__o31ai_1_2 VDD VSS sky130_fd_sc_hs__o31ai_1_2/A3 sky130_fd_sc_hs__and3_1_1/B
+ sky130_fd_sc_hs__buf_8_26/X sky130_fd_sc_hs__and2_1_7/X sky130_fd_sc_hs__o31ai_1_2/Y
+ VSS VDD sky130_fd_sc_hs__o31ai_1
Xsky130_fd_sc_hs__nand3b_1_6 VDD VSS sky130_fd_sc_hs__xor2_1_86/A sky130_fd_sc_hs__nor3_1_54/Y
+ sky130_fd_sc_hs__and3_1_14/A sky130_fd_sc_hs__nand3b_1_6/B VSS VDD sky130_fd_sc_hs__nand3b_1
Xsky130_fd_sc_hs__clkbuf_2_104 VDD VSS sky130_fd_sc_hs__clkbuf_2_104/X sky130_fd_sc_hs__clkinv_4_4/A
+ VSS VDD sky130_fd_sc_hs__clkbuf_2
Xsky130_fd_sc_hs__clkbuf_2_115 VDD VSS sky130_fd_sc_hs__clkinv_1_79/A sky130_fd_sc_hs__clkinv_4_5/A
+ VSS VDD sky130_fd_sc_hs__clkbuf_2
Xsky130_fd_sc_hs__clkbuf_2_126 VDD VSS sky130_fd_sc_hs__clkinv_1_85/A sky130_fd_sc_hs__clkinv_4_6/A
+ VSS VDD sky130_fd_sc_hs__clkbuf_2
Xsky130_fd_sc_hs__clkbuf_2_137 VDD VSS sky130_fd_sc_hs__clkinv_1_97/A sky130_fd_sc_hs__clkinv_4_7/A
+ VSS VDD sky130_fd_sc_hs__clkbuf_2
Xsky130_fd_sc_hs__nand2_1_104 VDD VSS sky130_fd_sc_hs__nor2_1_86/B sky130_fd_sc_hs__nand4b_1_0/C
+ sky130_fd_sc_hs__nor2_4_0/Y VSS VDD sky130_fd_sc_hs__nand2_1
Xsky130_fd_sc_hs__clkbuf_2_148 VDD VSS sky130_fd_sc_hs__clkbuf_2_148/X sky130_fd_sc_hs__clkbuf_2_149/X
+ VSS VDD sky130_fd_sc_hs__clkbuf_2
Xsky130_fd_sc_hs__nand2_1_115 VDD VSS sky130_fd_sc_hs__and2_1_24/A sky130_fd_sc_hs__xnor2_1_94/B
+ sky130_fd_sc_hs__o211ai_1_6/B1 VSS VDD sky130_fd_sc_hs__nand2_1
Xsky130_fd_sc_hs__nand2_1_126 VDD VSS sky130_fd_sc_hs__nor2_1_157/Y sky130_fd_sc_hs__o211ai_1_9/B1
+ sky130_fd_sc_hs__nor2_1_94/A VSS VDD sky130_fd_sc_hs__nand2_1
Xsky130_fd_sc_hs__clkbuf_2_159 VDD VSS sky130_fd_sc_hs__clkinv_1_110/A sky130_fd_sc_hs__clkbuf_2_176/A
+ VSS VDD sky130_fd_sc_hs__clkbuf_2
Xsky130_fd_sc_hs__nand2_1_137 VDD VSS sky130_fd_sc_hs__nor2_1_127/Y sky130_fd_sc_hs__nor2_1_128/B
+ sky130_fd_sc_hs__nor2_1_125/Y VSS VDD sky130_fd_sc_hs__nand2_1
Xsky130_fd_sc_hs__nand2_1_148 VDD VSS sky130_fd_sc_hs__nor3_1_38/C sky130_fd_sc_hs__nand2_1_148/Y
+ sky130_fd_sc_hs__o21a_1_27/B1 VSS VDD sky130_fd_sc_hs__nand2_1
Xsky130_fd_sc_hs__nand2_1_159 VDD VSS sky130_fd_sc_hs__nand2_1_159/B sky130_fd_sc_hs__nand2_1_160/B
+ sky130_fd_sc_hs__nor3_1_41/B VSS VDD sky130_fd_sc_hs__nand2_1
Xsky130_fd_sc_hs__a222o_1_1 VDD VSS sky130_fd_sc_hs__a222o_1_1/C2 sky130_fd_sc_hs__nor3_1_0/A
+ sky130_fd_sc_hs__buf_16_8/X sky130_fd_sc_hs__a222o_1_1/B2 sky130_fd_sc_hs__a222o_1_2/A2
+ sky130_fd_sc_hs__mux2_1_33/A0 sky130_fd_sc_hs__a22oi_1_5/A2 VSS VDD sky130_fd_sc_hs__a222o_1
Xsky130_fd_sc_hs__maj3_1_8 VDD VSS sky130_fd_sc_hs__maj3_1_8/A sky130_fd_sc_hs__maj3_1_8/B
+ sky130_fd_sc_hs__maj3_1_8/X sky130_fd_sc_hs__maj3_1_8/C VSS VDD sky130_fd_sc_hs__maj3_1
Xsky130_fd_sc_hs__mux2_1_390 VDD VSS sky130_fd_sc_hs__mux2_1_390/X sky130_fd_sc_hs__mux2_1_1/S
+ sky130_fd_sc_hs__a22o_1_92/B2 sky130_fd_sc_hs__mux2_1_390/A1 VSS VDD sky130_fd_sc_hs__mux2_1
Xsky130_fd_sc_hs__xor2_1_90 VDD VSS sky130_fd_sc_hs__xor2_1_90/A sky130_fd_sc_hs__xor2_1_90/B
+ sky130_fd_sc_hs__xor2_1_90/X VSS VDD sky130_fd_sc_hs__xor2_1
Xsky130_fd_sc_hs__nor2_2_9 VDD VSS sky130_fd_sc_hs__or3b_1_1/X sky130_fd_sc_hs__nor2_2_9/Y
+ sky130_fd_sc_hs__or2_1_29/X VSS VDD sky130_fd_sc_hs__nor2_2
Xsky130_fd_sc_hs__buf_8_16 VDD VSS sky130_fd_sc_hs__buf_8_16/X sky130_fd_sc_hs__buf_8_16/A
+ VSS VDD sky130_fd_sc_hs__buf_8
Xsky130_fd_sc_hs__buf_8_27 VDD VSS sky130_fd_sc_hs__buf_8_27/X sky130_fd_sc_hs__nor2_2_8/Y
+ VSS VDD sky130_fd_sc_hs__buf_8
Xsky130_fd_sc_hs__buf_8_38 VDD VSS sky130_fd_sc_hs__buf_8_38/X sky130_fd_sc_hs__buf_8_38/A
+ VSS VDD sky130_fd_sc_hs__buf_8
Xsky130_fd_sc_hs__nor2_1_18 VDD VSS sky130_fd_sc_hs__maj3_1_1/B sky130_fd_sc_hs__o21a_1_5/A1
+ sky130_fd_sc_hs__maj3_1_1/A VSS VDD sky130_fd_sc_hs__nor2_1
Xsky130_fd_sc_hs__nor2_1_29 VDD VSS sky130_fd_sc_hs__xor2_1_5/A sky130_fd_sc_hs__nor2_1_29/Y
+ sky130_fd_sc_hs__maj3_1_5/A VSS VDD sky130_fd_sc_hs__nor2_1
Xsky130_fd_sc_hs__o311ai_1_4 VDD VSS sky130_fd_sc_hs__xor2_1_2/X sky130_fd_sc_hs__or2_1_6/A
+ sky130_fd_sc_hs__nand2b_1_4/Y sky130_fd_sc_hs__o311ai_1_4/B1 sky130_fd_sc_hs__a31o_1_1/A3
+ sky130_fd_sc_hs__or2_1_6/B VSS VDD sky130_fd_sc_hs__o311ai_1
Xsky130_fd_sc_hs__xnor2_1_107 VDD VSS sky130_fd_sc_hs__maj3_1_45/X sky130_fd_sc_hs__o21a_1_21/A2
+ sky130_fd_sc_hs__maj3_1_43/C VSS VDD sky130_fd_sc_hs__xnor2_1
Xsky130_fd_sc_hs__xnor2_1_118 VDD VSS sky130_fd_sc_hs__nor2b_1_45/A sky130_fd_sc_hs__nor2_1_159/B
+ sky130_fd_sc_hs__nor2_1_162/B VSS VDD sky130_fd_sc_hs__xnor2_1
Xsky130_fd_sc_hs__xnor2_1_129 VDD VSS sky130_fd_sc_hs__maj3_1_55/X sky130_fd_sc_hs__xnor2_1_129/Y
+ sky130_fd_sc_hs__xnor2_1_139/Y VSS VDD sky130_fd_sc_hs__xnor2_1
Xsky130_fd_sc_hs__mux2_1_14 VDD VSS sky130_fd_sc_hs__mux2_1_14/X sky130_fd_sc_hs__mux2_1_94/S
+ sky130_fd_sc_hs__maj3_1_0/B sky130_fd_sc_hs__mux2_1_7/A1 VSS VDD sky130_fd_sc_hs__mux2_1
Xsky130_fd_sc_hs__mux2_1_25 VDD VSS sky130_fd_sc_hs__mux2_1_25/X sky130_fd_sc_hs__mux2_1_9/S
+ sky130_fd_sc_hs__mux2_1_25/A0 sky130_fd_sc_hs__mux2_1_95/A1 VSS VDD sky130_fd_sc_hs__mux2_1
Xsky130_fd_sc_hs__mux2_1_36 VDD VSS sky130_fd_sc_hs__mux2_1_36/X sky130_fd_sc_hs__buf_16_3/X
+ sky130_fd_sc_hs__mux2_1_95/A1 sky130_fd_sc_hs__mux2_1_36/A1 VSS VDD sky130_fd_sc_hs__mux2_1
Xsky130_fd_sc_hs__mux2_1_47 VDD VSS sky130_fd_sc_hs__mux2_1_47/X sky130_fd_sc_hs__mux2_1_7/S
+ sky130_fd_sc_hs__mux2_1_47/A0 sky130_fd_sc_hs__mux2_1_61/A0 VSS VDD sky130_fd_sc_hs__mux2_1
Xsky130_fd_sc_hs__mux2_1_58 VDD VSS sky130_fd_sc_hs__mux2_1_58/X sky130_fd_sc_hs__mux2_1_94/S
+ sky130_fd_sc_hs__xor2_1_1/A sky130_fd_sc_hs__mux2_1_95/A1 VSS VDD sky130_fd_sc_hs__mux2_1
Xsky130_fd_sc_hs__mux2_1_69 VDD VSS sky130_fd_sc_hs__mux2_1_69/X sky130_fd_sc_hs__buf_16_2/X
+ sky130_fd_sc_hs__mux2_1_96/A0 sky130_fd_sc_hs__mux2_1_69/A1 VSS VDD sky130_fd_sc_hs__mux2_1
Xsky130_fd_sc_hs__nor2b_1_18 VDD VSS sky130_fd_sc_hs__maj3_1_21/X sky130_fd_sc_hs__nor2b_1_18/Y
+ sky130_fd_sc_hs__xnor2_1_59/Y VSS VDD sky130_fd_sc_hs__nor2b_1
Xsky130_fd_sc_hs__nor2b_1_29 VDD VSS sky130_fd_sc_hs__maj3_1_40/X sky130_fd_sc_hs__nor2b_1_29/Y
+ sky130_fd_sc_hs__nor2b_1_29/A VSS VDD sky130_fd_sc_hs__nor2b_1
Xsky130_fd_sc_hs__a31o_1_14 VDD VSS sky130_fd_sc_hs__a31o_1_14/X sky130_fd_sc_hs__a31o_1_14/A3
+ sky130_fd_sc_hs__a31o_1_14/A2 sky130_fd_sc_hs__a31o_1_14/A1 sky130_fd_sc_hs__a31o_1_14/B1
+ VSS VDD sky130_fd_sc_hs__a31o_1
Xsky130_fd_sc_hs__dfrtp_1_407 sky130_fd_sc_hs__clkbuf_4_16/X VDD VSS sky130_fd_sc_hs__maj3_1_31/C
+ sky130_fd_sc_hs__clkinv_1_81/A sky130_fd_sc_hs__a22o_1_96/X VSS VDD sky130_fd_sc_hs__dfrtp_1
Xsky130_fd_sc_hs__dfrtp_1_418 sky130_fd_sc_hs__clkbuf_4_16/X VDD VSS sky130_fd_sc_hs__xor2_1_62/A
+ sky130_fd_sc_hs__clkbuf_2_121/X sky130_fd_sc_hs__dfrtp_1_418/D VSS VDD sky130_fd_sc_hs__dfrtp_1
Xsky130_fd_sc_hs__dfrtp_1_429 sky130_fd_sc_hs__clkbuf_4_19/X VDD VSS sky130_fd_sc_hs__a22o_1_92/B2
+ sky130_fd_sc_hs__clkinv_1_85/A sky130_fd_sc_hs__a22o_1_92/X VSS VDD sky130_fd_sc_hs__dfrtp_1
Xsky130_fd_sc_hs__buf_1_190 VDD VSS sky130_fd_sc_hs__buf_1_190/A w_wr_data[11] VSS
+ VDD sky130_fd_sc_hs__buf_1
Xsky130_fd_sc_hs__a311oi_1_9 VDD VSS sky130_fd_sc_hs__clkinv_1_80/Y sky130_fd_sc_hs__o31a_1_2/A2
+ sky130_fd_sc_hs__and2_1_26/B sky130_fd_sc_hs__xnor2_1_89/Y sky130_fd_sc_hs__and2_1_26/A
+ sky130_fd_sc_hs__or2_1_16/B VSS VDD sky130_fd_sc_hs__a311oi_1
Xsky130_fd_sc_hs__or2_1_13 VDD VSS sky130_fd_sc_hs__or2_1_13/B sky130_fd_sc_hs__or2_1_13/A
+ sky130_fd_sc_hs__or2_1_13/X VSS VDD sky130_fd_sc_hs__or2_1
Xsky130_fd_sc_hs__or2_1_24 VDD VSS sky130_fd_sc_hs__or2_1_24/B sky130_fd_sc_hs__or3_1_6/A
+ sky130_fd_sc_hs__or2_1_25/A VSS VDD sky130_fd_sc_hs__or2_1
Xsky130_fd_sc_hs__dfrtp_1_204 sky130_fd_sc_hs__buf_8_1/X VDD VSS sky130_fd_sc_hs__or2_1_3/B
+ sky130_fd_sc_hs__clkinv_1_17/A sky130_fd_sc_hs__mux2_1_115/X VSS VDD sky130_fd_sc_hs__dfrtp_1
Xsky130_fd_sc_hs__dfrtp_1_215 sky130_fd_sc_hs__clkbuf_4_4/X VDD VSS sky130_fd_sc_hs__maj3_1_8/A
+ sky130_fd_sc_hs__clkinv_1_18/A sky130_fd_sc_hs__a22o_1_10/X VSS VDD sky130_fd_sc_hs__dfrtp_1
Xsky130_fd_sc_hs__dfrtp_1_226 sky130_fd_sc_hs__buf_8_4/X VDD VSS sky130_fd_sc_hs__a22o_1_18/B2
+ sky130_fd_sc_hs__clkbuf_2_67/X sky130_fd_sc_hs__dfrtp_1_226/D VSS VDD sky130_fd_sc_hs__dfrtp_1
Xsky130_fd_sc_hs__dfrtp_1_237 sky130_fd_sc_hs__buf_8_5/X VDD VSS sky130_fd_sc_hs__nand4_1_2/B
+ sky130_fd_sc_hs__clkbuf_8_2/X sky130_fd_sc_hs__a311oi_1_3/Y VSS VDD sky130_fd_sc_hs__dfrtp_1
Xsky130_fd_sc_hs__dfrtp_1_248 sky130_fd_sc_hs__clkbuf_4_12/A VDD VSS sky130_fd_sc_hs__dfrtp_1_290/D
+ sky130_fd_sc_hs__clkbuf_2_74/X sky130_fd_sc_hs__a22o_1_28/A1 VSS VDD sky130_fd_sc_hs__dfrtp_1
Xsky130_fd_sc_hs__dfrtp_1_259 sky130_fd_sc_hs__clkbuf_4_14/X VDD VSS sky130_fd_sc_hs__dfrtp_1_259/Q
+ sky130_fd_sc_hs__clkbuf_2_76/X sky130_fd_sc_hs__dfrtp_1_259/D VSS VDD sky130_fd_sc_hs__dfrtp_1
Xsky130_fd_sc_hs__clkinv_1_14 VDD VSS sky130_fd_sc_hs__maj3_1_2/A sky130_fd_sc_hs__and3_1_0/A
+ VSS VDD sky130_fd_sc_hs__clkinv_1
Xsky130_fd_sc_hs__clkinv_1_25 VDD VSS sky130_fd_sc_hs__nor2_1_24/Y sky130_fd_sc_hs__and3_1_1/A
+ VSS VDD sky130_fd_sc_hs__clkinv_1
Xsky130_fd_sc_hs__nor3b_1_3 VDD VSS sky130_fd_sc_hs__nor3b_1_3/Y sky130_fd_sc_hs__or2_1_21/A
+ sky130_fd_sc_hs__or2_1_21/B sky130_fd_sc_hs__nor3b_1_3/B VSS VDD sky130_fd_sc_hs__nor3b_1
Xsky130_fd_sc_hs__clkinv_1_36 VDD VSS sky130_fd_sc_hs__clkinv_1_36/A sky130_fd_sc_hs__clkinv_1_36/Y
+ VSS VDD sky130_fd_sc_hs__clkinv_1
Xsky130_fd_sc_hs__clkinv_1_47 VDD VSS sky130_fd_sc_hs__xnor2_1_43/A sky130_fd_sc_hs__nor3_1_12/A
+ VSS VDD sky130_fd_sc_hs__clkinv_1
Xsky130_fd_sc_hs__clkinv_1_58 VDD VSS sky130_fd_sc_hs__xor2_1_31/X sky130_fd_sc_hs__o211ai_1_4/B1
+ VSS VDD sky130_fd_sc_hs__clkinv_1
Xsky130_fd_sc_hs__clkinv_1_69 VDD VSS sky130_fd_sc_hs__clkinv_1_69/A sky130_fd_sc_hs__clkinv_1_69/Y
+ VSS VDD sky130_fd_sc_hs__clkinv_1
Xsky130_fd_sc_hs__o21ai_1_9 VDD VSS sky130_fd_sc_hs__o21ai_1_9/Y sky130_fd_sc_hs__o21ai_1_9/B1
+ sky130_fd_sc_hs__nor2_1_22/Y sky130_fd_sc_hs__o21ai_1_9/A1 VSS VDD sky130_fd_sc_hs__o21ai_1
Xsky130_fd_sc_hs__dfrtp_1_760 sky130_fd_sc_hs__clkbuf_4_51/X VDD VSS sky130_fd_sc_hs__mux2_1_434/A1
+ sky130_fd_sc_hs__clkbuf_2_226/X sky130_fd_sc_hs__mux2_1_434/X VSS VDD sky130_fd_sc_hs__dfrtp_1
Xsky130_fd_sc_hs__dfrtp_1_771 sky130_fd_sc_hs__clkbuf_4_30/X VDD VSS sky130_fd_sc_hs__mux2_1_305/A1
+ sky130_fd_sc_hs__clkinv_1_128/A sky130_fd_sc_hs__mux2_1_305/X VSS VDD sky130_fd_sc_hs__dfrtp_1
Xsky130_fd_sc_hs__dfrtp_1_782 sky130_fd_sc_hs__clkbuf_4_50/X VDD VSS sky130_fd_sc_hs__mux2_1_362/A0
+ sky130_fd_sc_hs__clkbuf_2_223/X sky130_fd_sc_hs__mux2_1_362/X VSS VDD sky130_fd_sc_hs__dfrtp_1
Xsky130_fd_sc_hs__dfrtp_2_1 sky130_fd_sc_hs__clkbuf_4_15/X VDD VSS sky130_fd_sc_hs__dfrtp_2_1/D
+ sky130_fd_sc_hs__dfrtp_2_1/CLK sky130_fd_sc_hs__dfrtp_2_1/Q VSS VDD sky130_fd_sc_hs__dfrtp_2
Xsky130_fd_sc_hs__dfrtp_1_793 sky130_fd_sc_hs__clkbuf_4_12/A VDD VSS sky130_fd_sc_hs__buf_1_9/A
+ sky130_fd_sc_hs__clkinv_1_5/A sky130_fd_sc_hs__a22o_1_20/X VSS VDD sky130_fd_sc_hs__dfrtp_1
Xsky130_fd_sc_hs__o21ai_1_107 VDD VSS sky130_fd_sc_hs__o21ai_1_107/Y sky130_fd_sc_hs__nor2_4_2/Y
+ sky130_fd_sc_hs__xor2_1_85/X sky130_fd_sc_hs__maj3_1_63/X VSS VDD sky130_fd_sc_hs__o21ai_1
Xsky130_fd_sc_hs__mux2_1_208 VDD VSS sky130_fd_sc_hs__mux2_1_208/X sky130_fd_sc_hs__nor2_1_66/B
+ sky130_fd_sc_hs__xor2_1_33/B sky130_fd_sc_hs__a21oi_1_20/Y VSS VDD sky130_fd_sc_hs__mux2_1
Xsky130_fd_sc_hs__mux2_1_219 VDD VSS sky130_fd_sc_hs__mux2_1_219/X sky130_fd_sc_hs__nor2_1_82/B
+ sky130_fd_sc_hs__xor2_1_39/A sky130_fd_sc_hs__a21oi_1_43/Y VSS VDD sky130_fd_sc_hs__mux2_1
Xsky130_fd_sc_hs__nand3_1_5 VDD VSS sky130_fd_sc_hs__nand3_1_5/C sky130_fd_sc_hs__xor2_1_3/B
+ sky130_fd_sc_hs__nand3_1_5/B sky130_fd_sc_hs__and4_1_1/X VSS VDD sky130_fd_sc_hs__nand3_1
Xsky130_fd_sc_hs__nor3_1_1 VDD VSS sky130_fd_sc_hs__nor3_1_1/Y sky130_fd_sc_hs__nor3_1_5/A
+ sky130_fd_sc_hs__nor3_1_1/B sky130_fd_sc_hs__o21a_1_0/X VSS VDD sky130_fd_sc_hs__nor3_1
Xsky130_fd_sc_hs__xnor2_1_20 VDD VSS sky130_fd_sc_hs__o31ai_1_3/Y sky130_fd_sc_hs__xnor2_1_20/Y
+ sky130_fd_sc_hs__xnor2_1_20/B VSS VDD sky130_fd_sc_hs__xnor2_1
Xsky130_fd_sc_hs__xnor2_1_31 VDD VSS sky130_fd_sc_hs__maj3_1_0/A sky130_fd_sc_hs__xnor2_1_36/B
+ sky130_fd_sc_hs__maj3_1_0/B VSS VDD sky130_fd_sc_hs__xnor2_1
Xsky130_fd_sc_hs__xnor2_1_42 VDD VSS sky130_fd_sc_hs__xnor2_1_42/A sky130_fd_sc_hs__xor2_1_22/B
+ sky130_fd_sc_hs__xnor2_1_42/B VSS VDD sky130_fd_sc_hs__xnor2_1
Xsky130_fd_sc_hs__xnor2_1_53 VDD VSS sky130_fd_sc_hs__maj3_1_14/X sky130_fd_sc_hs__xnor2_1_53/Y
+ sky130_fd_sc_hs__xnor2_1_54/Y VSS VDD sky130_fd_sc_hs__xnor2_1
Xsky130_fd_sc_hs__xnor2_1_64 VDD VSS sky130_fd_sc_hs__maj3_1_19/X sky130_fd_sc_hs__xnor2_1_64/Y
+ sky130_fd_sc_hs__xnor2_1_64/B VSS VDD sky130_fd_sc_hs__xnor2_1
Xsky130_fd_sc_hs__xnor2_1_75 VDD VSS sky130_fd_sc_hs__xnor2_1_75/A sky130_fd_sc_hs__xnor2_1_75/Y
+ sky130_fd_sc_hs__and2_1_19/X VSS VDD sky130_fd_sc_hs__xnor2_1
Xsky130_fd_sc_hs__xnor2_1_86 VDD VSS sky130_fd_sc_hs__maj3_1_49/C sky130_fd_sc_hs__xor2_1_58/B
+ sky130_fd_sc_hs__xor2_1_59/X VSS VDD sky130_fd_sc_hs__xnor2_1
Xsky130_fd_sc_hs__xnor2_1_97 VDD VSS sky130_fd_sc_hs__maj3_1_38/X sky130_fd_sc_hs__xnor2_1_97/Y
+ sky130_fd_sc_hs__xnor2_1_97/B VSS VDD sky130_fd_sc_hs__xnor2_1
Xsky130_fd_sc_hs__a211oi_1_0 VDD VSS sky130_fd_sc_hs__nand3_1_0/Y sky130_fd_sc_hs__nand3_1_1/C
+ sky130_fd_sc_hs__a222o_1_0/X sky130_fd_sc_hs__a222o_1_3/C2 sky130_fd_sc_hs__mux2_1_1/A1
+ VSS VDD sky130_fd_sc_hs__a211oi_1
Xsky130_fd_sc_hs__a22oi_1_1 VDD VSS sky130_fd_sc_hs__mux2_1_11/A1 sky130_fd_sc_hs__nand3_1_0/C
+ sky130_fd_sc_hs__buf_16_9/X sky130_fd_sc_hs__a22oi_1_7/B1 sky130_fd_sc_hs__mux2_1_8/A0
+ VSS VDD sky130_fd_sc_hs__a22oi_1
Xsky130_fd_sc_hs__dfrtp_1_590 sky130_fd_sc_hs__buf_8_29/X VDD VSS sky130_fd_sc_hs__nand4_1_9/D
+ sky130_fd_sc_hs__clkinv_1_125/A sky130_fd_sc_hs__a22o_1_115/X VSS VDD sky130_fd_sc_hs__dfrtp_1
Xsky130_fd_sc_hs__and3_1_0 VDD VSS sky130_fd_sc_hs__and3_1_0/A sky130_fd_sc_hs__and3_1_0/B
+ sky130_fd_sc_hs__nor3_1_7/Y sky130_fd_sc_hs__and3_1_0/X VSS VDD sky130_fd_sc_hs__and3_1
Xsky130_fd_sc_hs__o31ai_1_3 VDD VSS sky130_fd_sc_hs__o21a_1_5/A2 sky130_fd_sc_hs__o21a_1_5/B1
+ sky130_fd_sc_hs__o31ai_1_3/B1 sky130_fd_sc_hs__o21a_1_5/A1 sky130_fd_sc_hs__o31ai_1_3/Y
+ VSS VDD sky130_fd_sc_hs__o31ai_1
Xsky130_fd_sc_hs__a21oi_1_0 VDD VSS sky130_fd_sc_hs__xnor2_1_2/A sky130_fd_sc_hs__o21a_1_6/A2
+ sky130_fd_sc_hs__and4_1_0/X sky130_fd_sc_hs__nand3_1_2/B VSS VDD sky130_fd_sc_hs__a21oi_1
Xsky130_fd_sc_hs__clkbuf_2_105 VDD VSS sky130_fd_sc_hs__clkinv_1_73/A sky130_fd_sc_hs__clkinv_4_4/A
+ VSS VDD sky130_fd_sc_hs__clkbuf_2
Xsky130_fd_sc_hs__clkbuf_2_116 VDD VSS sky130_fd_sc_hs__a22o_1_90/A2 sky130_fd_sc_hs__buf_8_18/A
+ VSS VDD sky130_fd_sc_hs__clkbuf_2
Xsky130_fd_sc_hs__clkbuf_2_127 VDD VSS sky130_fd_sc_hs__buf_8_15/A sky130_fd_sc_hs__nor2_1_92/Y
+ VSS VDD sky130_fd_sc_hs__clkbuf_2
Xsky130_fd_sc_hs__clkbuf_2_138 VDD VSS sky130_fd_sc_hs__clkinv_1_98/A sky130_fd_sc_hs__clkinv_4_7/A
+ VSS VDD sky130_fd_sc_hs__clkbuf_2
Xsky130_fd_sc_hs__nand2_1_105 VDD VSS sky130_fd_sc_hs__nor2_1_87/Y sky130_fd_sc_hs__nand2_1_105/Y
+ sky130_fd_sc_hs__nor2_1_93/Y VSS VDD sky130_fd_sc_hs__nand2_1
Xsky130_fd_sc_hs__clkbuf_2_149 VDD VSS sky130_fd_sc_hs__clkbuf_2_149/X sky130_fd_sc_hs__inv_8_1/A
+ VSS VDD sky130_fd_sc_hs__clkbuf_2
Xsky130_fd_sc_hs__nand2_1_116 VDD VSS sky130_fd_sc_hs__and2_1_30/B sky130_fd_sc_hs__nand2_1_116/Y
+ sky130_fd_sc_hs__buf_8_14/X VSS VDD sky130_fd_sc_hs__nand2_1
Xsky130_fd_sc_hs__nand2_1_127 VDD VSS sky130_fd_sc_hs__nor2_1_157/Y sky130_fd_sc_hs__nand4_1_4/C
+ sky130_fd_sc_hs__nor2_4_0/A VSS VDD sky130_fd_sc_hs__nand2_1
Xsky130_fd_sc_hs__nand2_1_138 VDD VSS sky130_fd_sc_hs__nor3_1_35/C sky130_fd_sc_hs__nor2_1_131/B
+ sky130_fd_sc_hs__nor3_1_36/Y VSS VDD sky130_fd_sc_hs__nand2_1
Xsky130_fd_sc_hs__nand2_1_149 VDD VSS sky130_fd_sc_hs__nor2b_1_36/Y sky130_fd_sc_hs__o21a_1_27/A2
+ sky130_fd_sc_hs__nor3_1_38/B VSS VDD sky130_fd_sc_hs__nand2_1
Xsky130_fd_sc_hs__a222o_1_2 VDD VSS sky130_fd_sc_hs__buf_16_8/X sky130_fd_sc_hs__a222o_1_2/X
+ sky130_fd_sc_hs__mux2_1_42/A1 sky130_fd_sc_hs__mux2_1_81/A1 sky130_fd_sc_hs__a222o_1_2/A2
+ sky130_fd_sc_hs__mux2_1_41/A0 sky130_fd_sc_hs__a22oi_1_6/A2 VSS VDD sky130_fd_sc_hs__a222o_1
Xsky130_fd_sc_hs__maj3_1_9 VDD VSS sky130_fd_sc_hs__maj3_1_9/A sky130_fd_sc_hs__maj3_1_9/B
+ sky130_fd_sc_hs__maj3_1_9/X sky130_fd_sc_hs__maj3_1_9/C VSS VDD sky130_fd_sc_hs__maj3_1
Xsky130_fd_sc_hs__mux2_1_380 VDD VSS sky130_fd_sc_hs__mux2_1_380/X sky130_fd_sc_hs__buf_16_5/A
+ sky130_fd_sc_hs__mux2_1_380/A0 sky130_fd_sc_hs__dfrtp_2_2/Q VSS VDD sky130_fd_sc_hs__mux2_1
Xsky130_fd_sc_hs__mux2_1_391 VDD VSS sky130_fd_sc_hs__mux2_1_391/X sky130_fd_sc_hs__buf_16_13/A
+ sky130_fd_sc_hs__xnor3_1_1/B sky130_fd_sc_hs__a22o_1_89/B2 VSS VDD sky130_fd_sc_hs__mux2_1
Xsky130_fd_sc_hs__xor2_1_80 VDD VSS sky130_fd_sc_hs__xor2_1_80/A sky130_fd_sc_hs__xor2_1_80/B
+ sky130_fd_sc_hs__xor2_1_80/X VSS VDD sky130_fd_sc_hs__xor2_1
Xsky130_fd_sc_hs__xor2_1_91 VDD VSS sky130_fd_sc_hs__xor2_1_91/A sky130_fd_sc_hs__xor2_1_91/B
+ sky130_fd_sc_hs__xor2_1_91/X VSS VDD sky130_fd_sc_hs__xor2_1
Xsky130_fd_sc_hs__nand2b_1_60 VDD VSS sky130_fd_sc_hs__xnor2_1_137/Y sky130_fd_sc_hs__maj3_1_52/X
+ sky130_fd_sc_hs__a31o_1_14/A1 VSS VDD sky130_fd_sc_hs__nand2b_1
Xsky130_fd_sc_hs__buf_8_17 VDD VSS sky130_fd_sc_hs__buf_8_17/X sky130_fd_sc_hs__buf_8_17/A
+ VSS VDD sky130_fd_sc_hs__buf_8
Xsky130_fd_sc_hs__buf_8_28 VDD VSS sky130_fd_sc_hs__buf_8_28/X sky130_fd_sc_hs__buf_8_28/A
+ VSS VDD sky130_fd_sc_hs__buf_8
Xsky130_fd_sc_hs__nor2_1_19 VDD VSS sky130_fd_sc_hs__xor2_1_1/A sky130_fd_sc_hs__nor2_1_19/Y
+ sky130_fd_sc_hs__maj3_1_4/A VSS VDD sky130_fd_sc_hs__nor2_1
Xsky130_fd_sc_hs__o311ai_1_5 VDD VSS sky130_fd_sc_hs__nor2_1_32/Y sky130_fd_sc_hs__o21a_1_11/X
+ sky130_fd_sc_hs__buf_1_22/X sky130_fd_sc_hs__o221ai_1_0/Y sky130_fd_sc_hs__o311ai_1_5/Y
+ sky130_fd_sc_hs__and2_1_13/X VSS VDD sky130_fd_sc_hs__o311ai_1
Xsky130_fd_sc_hs__xnor2_1_108 VDD VSS sky130_fd_sc_hs__maj3_1_47/C sky130_fd_sc_hs__xor2_1_73/B
+ sky130_fd_sc_hs__xor2_1_78/X VSS VDD sky130_fd_sc_hs__xnor2_1
Xsky130_fd_sc_hs__xnor2_1_119 VDD VSS sky130_fd_sc_hs__nor3_4_2/A sky130_fd_sc_hs__xnor2_1_119/Y
+ sky130_fd_sc_hs__xor2_1_79/B VSS VDD sky130_fd_sc_hs__xnor2_1
Xsky130_fd_sc_hs__mux2_1_15 VDD VSS sky130_fd_sc_hs__mux2_1_15/X sky130_fd_sc_hs__buf_16_0/X
+ sky130_fd_sc_hs__maj3_1_0/C sky130_fd_sc_hs__mux2_1_7/A1 VSS VDD sky130_fd_sc_hs__mux2_1
Xsky130_fd_sc_hs__mux2_1_26 VDD VSS sky130_fd_sc_hs__mux2_1_26/X sky130_fd_sc_hs__buf_16_5/X
+ sky130_fd_sc_hs__mux2_1_26/A0 sky130_fd_sc_hs__mux2_1_7/A1 VSS VDD sky130_fd_sc_hs__mux2_1
Xsky130_fd_sc_hs__mux2_1_37 VDD VSS sky130_fd_sc_hs__mux2_1_37/X sky130_fd_sc_hs__mux2_1_99/S
+ sky130_fd_sc_hs__mux2_1_7/A1 sky130_fd_sc_hs__mux2_1_37/A1 VSS VDD sky130_fd_sc_hs__mux2_1
Xsky130_fd_sc_hs__mux2_1_48 VDD VSS sky130_fd_sc_hs__mux2_1_48/X sky130_fd_sc_hs__mux2_1_1/S
+ sky130_fd_sc_hs__mux2_1_61/A0 sky130_fd_sc_hs__mux2_1_48/A1 VSS VDD sky130_fd_sc_hs__mux2_1
Xsky130_fd_sc_hs__mux2_1_59 VDD VSS sky130_fd_sc_hs__mux2_1_59/X sky130_fd_sc_hs__mux2_1_99/S
+ sky130_fd_sc_hs__mux2_1_96/A0 sky130_fd_sc_hs__a22o_1_9/B2 VSS VDD sky130_fd_sc_hs__mux2_1
Xsky130_fd_sc_hs__nor2b_1_19 VDD VSS sky130_fd_sc_hs__xnor2_1_65/Y sky130_fd_sc_hs__a31o_1_6/B1
+ sky130_fd_sc_hs__maj3_1_12/X VSS VDD sky130_fd_sc_hs__nor2b_1
Xsky130_fd_sc_hs__dfrtp_1_408 sky130_fd_sc_hs__clkbuf_4_16/X VDD VSS sky130_fd_sc_hs__xor2_1_60/A
+ sky130_fd_sc_hs__clkinv_1_79/A sky130_fd_sc_hs__mux2_1_235/X VSS VDD sky130_fd_sc_hs__dfrtp_1
Xsky130_fd_sc_hs__dfrtp_1_419 sky130_fd_sc_hs__clkbuf_4_16/X VDD VSS sky130_fd_sc_hs__a22o_1_91/A1
+ sky130_fd_sc_hs__clkbuf_2_121/X sky130_fd_sc_hs__a22o_1_87/X VSS VDD sky130_fd_sc_hs__dfrtp_1
Xsky130_fd_sc_hs__buf_1_180 VDD VSS sky130_fd_sc_hs__buf_1_180/A dac_n_force[8] VSS
+ VDD sky130_fd_sc_hs__buf_1
Xsky130_fd_sc_hs__buf_1_191 VDD VSS sky130_fd_sc_hs__buf_1_191/A dac_p_force[17] VSS
+ VDD sky130_fd_sc_hs__buf_1
Xsky130_fd_sc_hs__or2_1_14 VDD VSS sky130_fd_sc_hs__or2_1_14/B sky130_fd_sc_hs__or2_1_14/A
+ sky130_fd_sc_hs__or2_1_14/X VSS VDD sky130_fd_sc_hs__or2_1
Xsky130_fd_sc_hs__or2_1_25 VDD VSS sky130_fd_sc_hs__or3_1_6/B sky130_fd_sc_hs__or2_1_25/A
+ sky130_fd_sc_hs__or2_1_25/X VSS VDD sky130_fd_sc_hs__or2_1
Xsky130_fd_sc_hs__dfrtp_1_205 sky130_fd_sc_hs__clkbuf_4_3/A VDD VSS sky130_fd_sc_hs__a222o_1_1/B2
+ sky130_fd_sc_hs__clkinv_1_32/A sky130_fd_sc_hs__mux2_1_181/X VSS VDD sky130_fd_sc_hs__dfrtp_1
Xsky130_fd_sc_hs__dfrtp_1_216 sky130_fd_sc_hs__clkbuf_4_0/X VDD VSS sky130_fd_sc_hs__mux2_1_63/A0
+ sky130_fd_sc_hs__clkbuf_2_29/X sky130_fd_sc_hs__mux2_1_63/X VSS VDD sky130_fd_sc_hs__dfrtp_1
Xsky130_fd_sc_hs__dfrtp_1_227 sky130_fd_sc_hs__buf_2_0/A VDD VSS sky130_fd_sc_hs__or2_1_0/A
+ sky130_fd_sc_hs__clkbuf_2_81/X sky130_fd_sc_hs__o32a_1_0/X VSS VDD sky130_fd_sc_hs__dfrtp_1
Xsky130_fd_sc_hs__dfrtp_1_238 sky130_fd_sc_hs__buf_8_4/A VDD VSS sky130_fd_sc_hs__dfrtp_1_283/D
+ sky130_fd_sc_hs__clkbuf_2_71/X sky130_fd_sc_hs__o211a_2_1/A1 VSS VDD sky130_fd_sc_hs__dfrtp_1
Xsky130_fd_sc_hs__dfrtp_1_249 sky130_fd_sc_hs__buf_2_0/A VDD VSS sky130_fd_sc_hs__nor2_1_52/A
+ sky130_fd_sc_hs__clkbuf_2_76/X sky130_fd_sc_hs__nor3_1_16/Y VSS VDD sky130_fd_sc_hs__dfrtp_1
Xsky130_fd_sc_hs__clkinv_1_15 VDD VSS sky130_fd_sc_hs__and3_1_4/X sky130_fd_sc_hs__and2_1_1/A
+ VSS VDD sky130_fd_sc_hs__clkinv_1
Xsky130_fd_sc_hs__clkinv_1_26 VDD VSS sky130_fd_sc_hs__xor2_1_3/X sky130_fd_sc_hs__or3_1_0/B
+ VSS VDD sky130_fd_sc_hs__clkinv_1
Xsky130_fd_sc_hs__nor3b_1_4 VDD VSS sky130_fd_sc_hs__or2_1_31/B sky130_fd_sc_hs__nor3_1_51/Y
+ sky130_fd_sc_hs__nor3b_1_4/A sky130_fd_sc_hs__xnor3_1_1/A VSS VDD sky130_fd_sc_hs__nor3b_1
Xsky130_fd_sc_hs__clkinv_1_37 VDD VSS sky130_fd_sc_hs__clkinv_1_37/A sky130_fd_sc_hs__clkinv_1_37/Y
+ VSS VDD sky130_fd_sc_hs__clkinv_1
Xsky130_fd_sc_hs__clkinv_1_48 VDD VSS sky130_fd_sc_hs__o32a_1_0/A1 sky130_fd_sc_hs__nor2_1_47/A
+ VSS VDD sky130_fd_sc_hs__clkinv_1
Xsky130_fd_sc_hs__clkinv_1_59 VDD VSS sky130_fd_sc_hs__clkinv_1_59/A sky130_fd_sc_hs__clkinv_1_59/Y
+ VSS VDD sky130_fd_sc_hs__clkinv_1
Xsky130_fd_sc_hs__dfrtp_1_750 sky130_fd_sc_hs__buf_8_35/X VDD VSS sky130_fd_sc_hs__mux2_1_451/A0
+ sky130_fd_sc_hs__clkbuf_2_232/X sky130_fd_sc_hs__mux2_1_451/X VSS VDD sky130_fd_sc_hs__dfrtp_1
Xsky130_fd_sc_hs__dfrtp_1_761 sky130_fd_sc_hs__buf_8_35/A VDD VSS sky130_fd_sc_hs__mux2_1_449/A1
+ sky130_fd_sc_hs__clkbuf_2_226/X sky130_fd_sc_hs__mux2_1_449/X VSS VDD sky130_fd_sc_hs__dfrtp_1
Xsky130_fd_sc_hs__dfrtp_1_772 sky130_fd_sc_hs__clkbuf_4_28/X VDD VSS sky130_fd_sc_hs__mux2_1_302/A1
+ sky130_fd_sc_hs__clkinv_2_12/A sky130_fd_sc_hs__mux2_1_302/X VSS VDD sky130_fd_sc_hs__dfrtp_1
Xsky130_fd_sc_hs__dfrtp_2_2 sky130_fd_sc_hs__clkbuf_4_19/X VDD VSS sky130_fd_sc_hs__dfrtp_2_2/D
+ sky130_fd_sc_hs__dfrtp_2_2/CLK sky130_fd_sc_hs__dfrtp_2_2/Q VSS VDD sky130_fd_sc_hs__dfrtp_2
Xsky130_fd_sc_hs__dfrtp_1_783 sky130_fd_sc_hs__buf_8_25/A VDD VSS sky130_fd_sc_hs__mux2_1_468/A0
+ sky130_fd_sc_hs__clkinv_2_10/A sky130_fd_sc_hs__mux2_1_468/X VSS VDD sky130_fd_sc_hs__dfrtp_1
Xsky130_fd_sc_hs__dfrtp_1_794 sky130_fd_sc_hs__dfrtp_1_259/Q VDD VSS sky130_fd_sc_hs__buf_1_188/A
+ sky130_fd_sc_hs__clkinv_1_49/A sky130_fd_sc_hs__a22o_1_22/X VSS VDD sky130_fd_sc_hs__dfrtp_1
Xsky130_fd_sc_hs__o21ai_1_108 VDD VSS sky130_fd_sc_hs__o21ai_1_108/Y sky130_fd_sc_hs__nor2_4_2/Y
+ sky130_fd_sc_hs__xor2_1_86/X sky130_fd_sc_hs__maj3_1_62/X VSS VDD sky130_fd_sc_hs__o21ai_1
Xsky130_fd_sc_hs__mux2_1_209 VDD VSS sky130_fd_sc_hs__mux2_1_209/X sky130_fd_sc_hs__nor2_1_66/B
+ sky130_fd_sc_hs__xor2_1_34/B sky130_fd_sc_hs__nor2_1_62/Y VSS VDD sky130_fd_sc_hs__mux2_1
Xsky130_fd_sc_hs__nand3_1_6 VDD VSS sky130_fd_sc_hs__nand3_1_6/C sky130_fd_sc_hs__nand3_1_6/Y
+ sky130_fd_sc_hs__nand3_1_6/B sky130_fd_sc_hs__nand3_1_6/A VSS VDD sky130_fd_sc_hs__nand3_1
Xsky130_fd_sc_hs__nor3_1_2 VDD VSS sky130_fd_sc_hs__nor3_1_5/B sky130_fd_sc_hs__nor3_1_2/C
+ sky130_fd_sc_hs__xor2_1_0/X sky130_fd_sc_hs__nor3_1_2/A VSS VDD sky130_fd_sc_hs__nor3_1
Xsky130_fd_sc_hs__xnor2_1_10 VDD VSS sky130_fd_sc_hs__xnor2_1_10/A sky130_fd_sc_hs__xnor2_1_10/Y
+ sky130_fd_sc_hs__xnor2_1_40/Y VSS VDD sky130_fd_sc_hs__xnor2_1
Xsky130_fd_sc_hs__xnor2_1_21 VDD VSS sky130_fd_sc_hs__maj3_1_5/A sky130_fd_sc_hs__or2_1_4/A
+ sky130_fd_sc_hs__xnor2_1_21/B VSS VDD sky130_fd_sc_hs__xnor2_1
Xsky130_fd_sc_hs__xnor2_1_32 VDD VSS sky130_fd_sc_hs__a31oi_1_3/Y sky130_fd_sc_hs__xnor2_1_32/Y
+ sky130_fd_sc_hs__xor2_1_13/X VSS VDD sky130_fd_sc_hs__xnor2_1
Xsky130_fd_sc_hs__xnor2_1_43 VDD VSS sky130_fd_sc_hs__xnor2_1_43/A sky130_fd_sc_hs__xnor2_1_43/Y
+ sky130_fd_sc_hs__xor2_1_21/X VSS VDD sky130_fd_sc_hs__xnor2_1
Xsky130_fd_sc_hs__xnor2_1_54 VDD VSS sky130_fd_sc_hs__maj3_1_12/C sky130_fd_sc_hs__xnor2_1_54/Y
+ sky130_fd_sc_hs__xor2_1_25/X VSS VDD sky130_fd_sc_hs__xnor2_1
Xsky130_fd_sc_hs__xnor2_1_65 VDD VSS sky130_fd_sc_hs__maj3_1_22/C sky130_fd_sc_hs__xnor2_1_65/Y
+ sky130_fd_sc_hs__xor2_1_38/X VSS VDD sky130_fd_sc_hs__xnor2_1
Xsky130_fd_sc_hs__xnor2_1_76 VDD VSS sky130_fd_sc_hs__maj3_1_16/C sky130_fd_sc_hs__xor2_1_31/B
+ sky130_fd_sc_hs__xor2_1_51/X VSS VDD sky130_fd_sc_hs__xnor2_1
Xsky130_fd_sc_hs__xnor2_1_87 VDD VSS sky130_fd_sc_hs__maj3_1_31/C sky130_fd_sc_hs__xnor2_1_87/Y
+ sky130_fd_sc_hs__xor2_1_60/X VSS VDD sky130_fd_sc_hs__xnor2_1
Xsky130_fd_sc_hs__xnor2_1_98 VDD VSS sky130_fd_sc_hs__maj3_1_39/C sky130_fd_sc_hs__xnor2_1_99/B
+ sky130_fd_sc_hs__xor2_1_68/X VSS VDD sky130_fd_sc_hs__xnor2_1
Xsky130_fd_sc_hs__a211oi_1_1 VDD VSS sky130_fd_sc_hs__nor3_1_4/A sky130_fd_sc_hs__a211oi_1_1/Y
+ sky130_fd_sc_hs__nor3_1_4/B sky130_fd_sc_hs__nor3_1_3/C sky130_fd_sc_hs__nor2_1_2/B
+ VSS VDD sky130_fd_sc_hs__a211oi_1
Xsky130_fd_sc_hs__a22oi_1_2 VDD VSS sky130_fd_sc_hs__a22oi_1_2/B2 sky130_fd_sc_hs__nand3_1_0/A
+ sky130_fd_sc_hs__nand2_1_51/B sky130_fd_sc_hs__a22o_1_8/A2 sky130_fd_sc_hs__dfrtp_1_7/Q
+ VSS VDD sky130_fd_sc_hs__a22oi_1
Xsky130_fd_sc_hs__dfrtp_1_580 sky130_fd_sc_hs__buf_8_29/X VDD VSS sky130_fd_sc_hs__mux2_1_404/A0
+ sky130_fd_sc_hs__clkbuf_2_237/X sky130_fd_sc_hs__mux2_1_404/X VSS VDD sky130_fd_sc_hs__dfrtp_1
Xsky130_fd_sc_hs__dfrtp_1_591 sky130_fd_sc_hs__clkbuf_4_24/X VDD VSS sky130_fd_sc_hs__buf_1_135/A
+ sky130_fd_sc_hs__clkbuf_2_171/X sky130_fd_sc_hs__o21ai_1_77/Y VSS VDD sky130_fd_sc_hs__dfrtp_1
Xsky130_fd_sc_hs__mux2_1_0 VDD VSS sky130_fd_sc_hs__mux2_1_0/X sky130_fd_sc_hs__mux2_1_6/S
+ sky130_fd_sc_hs__mux2_1_9/A1 sky130_fd_sc_hs__mux2_1_0/A1 VSS VDD sky130_fd_sc_hs__mux2_1
Xsky130_fd_sc_hs__and3_1_1 VDD VSS sky130_fd_sc_hs__and3_1_1/A sky130_fd_sc_hs__and3_1_1/B
+ sky130_fd_sc_hs__and3_1_1/C sky130_fd_sc_hs__and3_1_1/X VSS VDD sky130_fd_sc_hs__and3_1
Xsky130_fd_sc_hs__o31ai_1_4 VDD VSS sky130_fd_sc_hs__and3_1_3/X sky130_fd_sc_hs__o31ai_1_4/A2
+ sky130_fd_sc_hs__o31ai_1_4/B1 sky130_fd_sc_hs__o31ai_1_4/A1 sky130_fd_sc_hs__o31ai_1_4/Y
+ VSS VDD sky130_fd_sc_hs__o31ai_1
Xsky130_fd_sc_hs__a21oi_1_1 VDD VSS sky130_fd_sc_hs__nand3_1_3/Y sky130_fd_sc_hs__nand3_1_8/B
+ sky130_fd_sc_hs__nand2_1_33/B sky130_fd_sc_hs__mux2_1_25/A0 VSS VDD sky130_fd_sc_hs__a21oi_1
Xsky130_fd_sc_hs__clkbuf_2_106 VDD VSS sky130_fd_sc_hs__clkinv_2_7/A sky130_fd_sc_hs__clkinv_4_4/A
+ VSS VDD sky130_fd_sc_hs__clkbuf_2
Xsky130_fd_sc_hs__clkbuf_2_117 VDD VSS sky130_fd_sc_hs__clkbuf_2_118/A sky130_fd_sc_hs__clkinv_4_6/A
+ VSS VDD sky130_fd_sc_hs__clkbuf_2
Xsky130_fd_sc_hs__clkbuf_2_128 VDD VSS sky130_fd_sc_hs__clkbuf_2_129/A sky130_fd_sc_hs__clkinv_4_6/A
+ VSS VDD sky130_fd_sc_hs__clkbuf_2
Xsky130_fd_sc_hs__clkbuf_2_139 VDD VSS sky130_fd_sc_hs__clkbuf_2_139/X sky130_fd_sc_hs__clkinv_4_7/A
+ VSS VDD sky130_fd_sc_hs__clkbuf_2
Xsky130_fd_sc_hs__nand2_1_106 VDD VSS sky130_fd_sc_hs__and2_1_27/X sky130_fd_sc_hs__nand2b_1_40/B
+ sky130_fd_sc_hs__o21a_1_20/A1 VSS VDD sky130_fd_sc_hs__nand2_1
Xsky130_fd_sc_hs__nand2_1_117 VDD VSS sky130_fd_sc_hs__buf_8_13/X sky130_fd_sc_hs__o21ai_1_53/B1
+ sky130_fd_sc_hs__and4_1_5/A VSS VDD sky130_fd_sc_hs__nand2_1
Xsky130_fd_sc_hs__nand2_1_128 VDD VSS sky130_fd_sc_hs__nor2b_1_41/Y sky130_fd_sc_hs__nand2_2_2/A
+ sky130_fd_sc_hs__nor3_1_24/C VSS VDD sky130_fd_sc_hs__nand2_1
Xsky130_fd_sc_hs__nand2_1_139 VDD VSS sky130_fd_sc_hs__nand3_1_24/Y sky130_fd_sc_hs__nand2_1_139/Y
+ sky130_fd_sc_hs__o21ai_1_63/Y VSS VDD sky130_fd_sc_hs__nand2_1
Xsky130_fd_sc_hs__a222o_1_3 VDD VSS sky130_fd_sc_hs__a222o_1_3/C2 sky130_fd_sc_hs__a222o_1_3/X
+ sky130_fd_sc_hs__mux2_1_85/A1 sky130_fd_sc_hs__mux2_1_43/A1 sky130_fd_sc_hs__a22oi_1_6/A2
+ sky130_fd_sc_hs__mux2_1_44/A1 sky130_fd_sc_hs__buf_16_8/X VSS VDD sky130_fd_sc_hs__a222o_1
Xsky130_fd_sc_hs__mux2_1_370 VDD VSS sky130_fd_sc_hs__mux2_1_370/X sky130_fd_sc_hs__mux2_1_370/S
+ sky130_fd_sc_hs__xor2_1_83/B sky130_fd_sc_hs__dfrtp_2_3/Q VSS VDD sky130_fd_sc_hs__mux2_1
Xsky130_fd_sc_hs__mux2_1_381 VDD VSS sky130_fd_sc_hs__mux2_1_381/X sky130_fd_sc_hs__buf_16_16/A
+ sky130_fd_sc_hs__dfrtp_2_2/Q sky130_fd_sc_hs__a222o_1_6/C1 VSS VDD sky130_fd_sc_hs__mux2_1
Xsky130_fd_sc_hs__mux2_1_392 VDD VSS sky130_fd_sc_hs__mux2_1_392/X sky130_fd_sc_hs__buf_16_10/A
+ sky130_fd_sc_hs__mux2_1_392/A0 sky130_fd_sc_hs__a22o_1_89/B2 VSS VDD sky130_fd_sc_hs__mux2_1
Xsky130_fd_sc_hs__xor2_1_70 VDD VSS sky130_fd_sc_hs__xor2_1_70/A sky130_fd_sc_hs__xor2_1_70/B
+ sky130_fd_sc_hs__xor2_1_70/X VSS VDD sky130_fd_sc_hs__xor2_1
Xsky130_fd_sc_hs__xor2_1_81 VDD VSS sky130_fd_sc_hs__xor2_1_88/A sky130_fd_sc_hs__xor2_1_81/B
+ sky130_fd_sc_hs__xor2_1_81/X VSS VDD sky130_fd_sc_hs__xor2_1
Xsky130_fd_sc_hs__xor2_1_92 VDD VSS sky130_fd_sc_hs__xor2_1_92/A sky130_fd_sc_hs__xor2_1_92/B
+ sky130_fd_sc_hs__xor2_1_92/X VSS VDD sky130_fd_sc_hs__xor2_1
Xsky130_fd_sc_hs__nand2b_1_50 VDD VSS sky130_fd_sc_hs__nor3_1_40/Y sky130_fd_sc_hs__o22ai_1_2/B2
+ sky130_fd_sc_hs__nand2b_1_50/Y VSS VDD sky130_fd_sc_hs__nand2b_1
Xsky130_fd_sc_hs__nand2b_1_61 VDD VSS sky130_fd_sc_hs__a211oi_1_7/Y sky130_fd_sc_hs__maj3_1_34/A
+ sky130_fd_sc_hs__and2_1_42/A VSS VDD sky130_fd_sc_hs__nand2b_1
Xsky130_fd_sc_hs__buf_8_18 VDD VSS sky130_fd_sc_hs__buf_8_18/X sky130_fd_sc_hs__buf_8_18/A
+ VSS VDD sky130_fd_sc_hs__buf_8
Xsky130_fd_sc_hs__buf_8_29 VDD VSS sky130_fd_sc_hs__buf_8_29/X sky130_fd_sc_hs__buf_8_29/A
+ VSS VDD sky130_fd_sc_hs__buf_8
Xsky130_fd_sc_hs__o311ai_1_6 VDD VSS sky130_fd_sc_hs__or2_1_24/B sky130_fd_sc_hs__or3_1_1/X
+ sky130_fd_sc_hs__buf_1_57/A sky130_fd_sc_hs__o31a_1_5/B1 sky130_fd_sc_hs__o311ai_1_6/Y
+ sky130_fd_sc_hs__or3_1_6/B VSS VDD sky130_fd_sc_hs__o311ai_1
Xsky130_fd_sc_hs__xnor2_1_109 VDD VSS sky130_fd_sc_hs__nor3_1_44/B sky130_fd_sc_hs__xnor2_1_109/Y
+ sky130_fd_sc_hs__nor2_1_127/Y VSS VDD sky130_fd_sc_hs__xnor2_1
Xsky130_fd_sc_hs__mux2_1_16 VDD VSS sky130_fd_sc_hs__mux2_1_16/X sky130_fd_sc_hs__buf_16_2/X
+ sky130_fd_sc_hs__mux2_1_7/A1 sky130_fd_sc_hs__mux2_1_16/A1 VSS VDD sky130_fd_sc_hs__mux2_1
Xsky130_fd_sc_hs__mux2_1_27 VDD VSS sky130_fd_sc_hs__mux2_1_27/X sky130_fd_sc_hs__mux2_1_9/S
+ sky130_fd_sc_hs__mux2_1_27/A0 sky130_fd_sc_hs__mux2_1_40/A0 VSS VDD sky130_fd_sc_hs__mux2_1
Xsky130_fd_sc_hs__mux2_1_38 VDD VSS sky130_fd_sc_hs__mux2_1_38/X sky130_fd_sc_hs__buf_16_2/X
+ sky130_fd_sc_hs__mux2_1_9/A1 sky130_fd_sc_hs__dfrtp_1_1/Q VSS VDD sky130_fd_sc_hs__mux2_1
Xsky130_fd_sc_hs__mux2_1_49 VDD VSS sky130_fd_sc_hs__mux2_1_49/X sky130_fd_sc_hs__buf_16_2/X
+ sky130_fd_sc_hs__mux2_1_61/A0 sky130_fd_sc_hs__mux2_1_49/A1 VSS VDD sky130_fd_sc_hs__mux2_1
Xsky130_fd_sc_hs__dfrtp_1_409 sky130_fd_sc_hs__clkbuf_4_16/X VDD VSS sky130_fd_sc_hs__a22o_1_76/B2
+ sky130_fd_sc_hs__clkinv_1_79/A sky130_fd_sc_hs__a22o_1_76/X VSS VDD sky130_fd_sc_hs__dfrtp_1
Xsky130_fd_sc_hs__buf_1_170 VDD VSS sky130_fd_sc_hs__buf_1_170/A dac_p_force[19] VSS
+ VDD sky130_fd_sc_hs__buf_1
Xsky130_fd_sc_hs__buf_1_181 VDD VSS sky130_fd_sc_hs__buf_1_181/A calib_overrange_bits[10]
+ VSS VDD sky130_fd_sc_hs__buf_1
Xsky130_fd_sc_hs__nand4_1_10 VDD VSS sky130_fd_sc_hs__nand4_1_10/C sky130_fd_sc_hs__nand4_1_10/Y
+ sky130_fd_sc_hs__nand4_1_10/D sky130_fd_sc_hs__nand4_1_10/B sky130_fd_sc_hs__nand4_1_10/A
+ VSS VDD sky130_fd_sc_hs__nand4_1
Xsky130_fd_sc_hs__or2_1_15 VDD VSS sky130_fd_sc_hs__or2_1_15/B sky130_fd_sc_hs__or2_1_15/A
+ sky130_fd_sc_hs__or2_1_15/X VSS VDD sky130_fd_sc_hs__or2_1
Xsky130_fd_sc_hs__or2_1_26 VDD VSS sky130_fd_sc_hs__or3_1_6/C sky130_fd_sc_hs__or2_1_26/A
+ sky130_fd_sc_hs__or2_1_26/X VSS VDD sky130_fd_sc_hs__or2_1
Xsky130_fd_sc_hs__dfrtp_1_206 sky130_fd_sc_hs__buf_8_0/X VDD VSS sky130_fd_sc_hs__mux2_1_88/A0
+ sky130_fd_sc_hs__clkinv_1_13/A sky130_fd_sc_hs__mux2_1_88/X VSS VDD sky130_fd_sc_hs__dfrtp_1
Xsky130_fd_sc_hs__dfrtp_1_217 sky130_fd_sc_hs__buf_8_4/X VDD VSS sky130_fd_sc_hs__a22o_1_6/B2
+ sky130_fd_sc_hs__clkinv_1_46/A sky130_fd_sc_hs__a22o_1_24/X VSS VDD sky130_fd_sc_hs__dfrtp_1
Xsky130_fd_sc_hs__dfrtp_1_228 sky130_fd_sc_hs__buf_8_4/X VDD VSS sky130_fd_sc_hs__a22o_1_21/B2
+ sky130_fd_sc_hs__clkbuf_2_67/X sky130_fd_sc_hs__o2bb2ai_1_9/Y VSS VDD sky130_fd_sc_hs__dfrtp_1
Xsky130_fd_sc_hs__dfrtp_1_239 sky130_fd_sc_hs__buf_8_4/A VDD VSS sky130_fd_sc_hs__dfrtp_1_292/D
+ sky130_fd_sc_hs__clkbuf_2_69/X sky130_fd_sc_hs__a32o_1_3/B2 VSS VDD sky130_fd_sc_hs__dfrtp_1
Xsky130_fd_sc_hs__o2bb2ai_1_70 VDD VSS sky130_fd_sc_hs__dfrtp_1_667/D sky130_fd_sc_hs__o31ai_1_20/Y
+ sky130_fd_sc_hs__xor2_1_85/A sky130_fd_sc_hs__nor2_1_178/Y sky130_fd_sc_hs__o31ai_4_0/Y
+ VSS VDD sky130_fd_sc_hs__o2bb2ai_1
Xsky130_fd_sc_hs__clkinv_1_16 VDD VSS sky130_fd_sc_hs__maj3_1_1/A sky130_fd_sc_hs__and3_1_4/A
+ VSS VDD sky130_fd_sc_hs__clkinv_1
Xsky130_fd_sc_hs__clkinv_1_27 VDD VSS sky130_fd_sc_hs__and2_1_7/X sky130_fd_sc_hs__o311ai_1_0/B1
+ VSS VDD sky130_fd_sc_hs__clkinv_1
Xsky130_fd_sc_hs__clkinv_1_38 VDD VSS sky130_fd_sc_hs__clkinv_1_38/A sky130_fd_sc_hs__clkinv_1_38/Y
+ VSS VDD sky130_fd_sc_hs__clkinv_1
Xsky130_fd_sc_hs__clkinv_1_49 VDD VSS sky130_fd_sc_hs__clkinv_1_49/A sky130_fd_sc_hs__clkinv_1_49/Y
+ VSS VDD sky130_fd_sc_hs__clkinv_1
Xsky130_fd_sc_hs__dfrtp_1_740 sky130_fd_sc_hs__buf_8_35/X VDD VSS sky130_fd_sc_hs__mux2_1_446/A1
+ sky130_fd_sc_hs__clkbuf_2_231/X sky130_fd_sc_hs__mux2_1_446/X VSS VDD sky130_fd_sc_hs__dfrtp_1
Xsky130_fd_sc_hs__dfrtp_1_751 sky130_fd_sc_hs__clkbuf_4_51/X VDD VSS sky130_fd_sc_hs__mux2_1_458/A0
+ sky130_fd_sc_hs__clkbuf_2_225/X sky130_fd_sc_hs__mux2_1_458/X VSS VDD sky130_fd_sc_hs__dfrtp_1
Xsky130_fd_sc_hs__dfrtp_1_762 sky130_fd_sc_hs__buf_8_34/X VDD VSS sky130_fd_sc_hs__nor2_1_180/A
+ sky130_fd_sc_hs__clkbuf_2_235/X sky130_fd_sc_hs__nor2_1_182/Y VSS VDD sky130_fd_sc_hs__dfrtp_1
Xsky130_fd_sc_hs__dfrtp_1_773 sky130_fd_sc_hs__buf_8_29/X VDD VSS sky130_fd_sc_hs__mux2_1_287/A1
+ sky130_fd_sc_hs__clkbuf_2_219/X sky130_fd_sc_hs__mux2_1_287/X VSS VDD sky130_fd_sc_hs__dfrtp_1
Xsky130_fd_sc_hs__dfrtp_2_3 sky130_fd_sc_hs__clkbuf_4_19/X VDD VSS sky130_fd_sc_hs__dfrtp_2_3/D
+ sky130_fd_sc_hs__dfrtp_2_3/CLK sky130_fd_sc_hs__dfrtp_2_3/Q VSS VDD sky130_fd_sc_hs__dfrtp_2
Xsky130_fd_sc_hs__dfrtp_1_784 sky130_fd_sc_hs__clkbuf_4_28/X VDD VSS sky130_fd_sc_hs__mux2_1_301/A0
+ sky130_fd_sc_hs__clkinv_2_12/A sky130_fd_sc_hs__mux2_1_301/X VSS VDD sky130_fd_sc_hs__dfrtp_1
Xsky130_fd_sc_hs__dfrtp_1_795 sky130_fd_sc_hs__dfrtp_1_259/Q VDD VSS sky130_fd_sc_hs__buf_1_64/A
+ sky130_fd_sc_hs__clkinv_1_46/A sky130_fd_sc_hs__a22o_1_26/X VSS VDD sky130_fd_sc_hs__dfrtp_1
Xsky130_fd_sc_hs__o21ai_1_109 VDD VSS sky130_fd_sc_hs__o21ai_1_109/Y sky130_fd_sc_hs__buf_8_36/X
+ sky130_fd_sc_hs__o21a_1_32/X sky130_fd_sc_hs__xnor3_1_2/A VSS VDD sky130_fd_sc_hs__o21ai_1
Xsky130_fd_sc_hs__nand3_1_7 VDD VSS sky130_fd_sc_hs__nand3_1_7/C sky130_fd_sc_hs__and2_1_6/B
+ sky130_fd_sc_hs__nand3_1_7/B sky130_fd_sc_hs__nand3_1_7/A VSS VDD sky130_fd_sc_hs__nand3_1
Xsky130_fd_sc_hs__nor3_1_3 VDD VSS sky130_fd_sc_hs__nor3_1_3/Y sky130_fd_sc_hs__nor3_1_3/C
+ sky130_fd_sc_hs__nor3_1_3/B sky130_fd_sc_hs__nor3_1_3/A VSS VDD sky130_fd_sc_hs__nor3_1
Xsky130_fd_sc_hs__xnor2_1_11 VDD VSS sky130_fd_sc_hs__xnor2_1_11/A sky130_fd_sc_hs__xnor2_1_11/Y
+ sky130_fd_sc_hs__xnor2_1_12/Y VSS VDD sky130_fd_sc_hs__xnor2_1
Xsky130_fd_sc_hs__xnor2_1_22 VDD VSS sky130_fd_sc_hs__maj3_1_5/A sky130_fd_sc_hs__xor2_1_6/B
+ sky130_fd_sc_hs__xor2_1_5/X VSS VDD sky130_fd_sc_hs__xnor2_1
Xsky130_fd_sc_hs__xnor2_1_33 VDD VSS sky130_fd_sc_hs__o21a_1_9/A1 sky130_fd_sc_hs__xnor2_1_33/Y
+ sky130_fd_sc_hs__xor2_1_14/X VSS VDD sky130_fd_sc_hs__xnor2_1
Xsky130_fd_sc_hs__xnor2_1_44 VDD VSS sky130_fd_sc_hs__nand4_1_2/B sky130_fd_sc_hs__xnor2_1_44/Y
+ sky130_fd_sc_hs__or2_1_9/X VSS VDD sky130_fd_sc_hs__xnor2_1
Xsky130_fd_sc_hs__xnor2_1_55 VDD VSS sky130_fd_sc_hs__maj3_1_15/C sky130_fd_sc_hs__xor2_1_27/B
+ sky130_fd_sc_hs__xor2_1_26/X VSS VDD sky130_fd_sc_hs__xnor2_1
Xsky130_fd_sc_hs__xnor2_1_66 VDD VSS sky130_fd_sc_hs__maj3_1_24/C sky130_fd_sc_hs__xor2_1_36/B
+ sky130_fd_sc_hs__xor2_1_41/X VSS VDD sky130_fd_sc_hs__xnor2_1
Xsky130_fd_sc_hs__xnor2_1_77 VDD VSS sky130_fd_sc_hs__or2_1_15/A sky130_fd_sc_hs__xnor2_1_77/Y
+ sky130_fd_sc_hs__xor2_1_52/X VSS VDD sky130_fd_sc_hs__xnor2_1
Xsky130_fd_sc_hs__xnor2_1_88 VDD VSS sky130_fd_sc_hs__maj3_1_32/C sky130_fd_sc_hs__xnor2_1_89/B
+ sky130_fd_sc_hs__xor2_1_61/X VSS VDD sky130_fd_sc_hs__xnor2_1
Xsky130_fd_sc_hs__xnor2_1_99 VDD VSS sky130_fd_sc_hs__maj3_1_50/X sky130_fd_sc_hs__xnor2_1_99/Y
+ sky130_fd_sc_hs__xnor2_1_99/B VSS VDD sky130_fd_sc_hs__xnor2_1
Xsky130_fd_sc_hs__a211oi_1_2 VDD VSS sky130_fd_sc_hs__clkinv_1_45/Y sky130_fd_sc_hs__a21o_1_0/B1
+ sky130_fd_sc_hs__nor2_1_38/Y sky130_fd_sc_hs__nand2_1_15/Y sky130_fd_sc_hs__xnor3_1_0/B
+ VSS VDD sky130_fd_sc_hs__a211oi_1
Xsky130_fd_sc_hs__a22oi_1_3 VDD VSS sky130_fd_sc_hs__mux2_1_65/A1 sky130_fd_sc_hs__nand3_1_1/B
+ sky130_fd_sc_hs__a22o_1_9/A2 sky130_fd_sc_hs__nand2_1_33/B sky130_fd_sc_hs__mux2_1_9/A0
+ VSS VDD sky130_fd_sc_hs__a22oi_1
Xsky130_fd_sc_hs__dfrtp_1_570 sky130_fd_sc_hs__clkbuf_4_24/X VDD VSS sky130_fd_sc_hs__buf_1_156/A
+ sky130_fd_sc_hs__clkbuf_2_171/X sky130_fd_sc_hs__nor2_2_5/Y VSS VDD sky130_fd_sc_hs__dfrtp_1
Xsky130_fd_sc_hs__dfrtp_1_581 sky130_fd_sc_hs__buf_8_29/X VDD VSS sky130_fd_sc_hs__mux2_1_281/A0
+ sky130_fd_sc_hs__clkinv_1_126/A sky130_fd_sc_hs__mux2_1_281/X VSS VDD sky130_fd_sc_hs__dfrtp_1
Xsky130_fd_sc_hs__dfrtp_1_592 sky130_fd_sc_hs__clkbuf_4_28/X VDD VSS sky130_fd_sc_hs__buf_1_144/A
+ sky130_fd_sc_hs__dfstp_1_1/CLK sky130_fd_sc_hs__mux2_1_268/X VSS VDD sky130_fd_sc_hs__dfrtp_1
Xsky130_fd_sc_hs__or3b_1_0 VDD VSS sky130_fd_sc_hs__or3b_1_0/A sky130_fd_sc_hs__or3b_1_0/B
+ sky130_fd_sc_hs__or2_1_29/A sky130_fd_sc_hs__or3b_1_0/X VSS VDD sky130_fd_sc_hs__or3b_1
Xsky130_fd_sc_hs__xor2_1_0 VDD VSS sky130_fd_sc_hs__xor2_1_0/A sky130_fd_sc_hs__xor2_1_0/B
+ sky130_fd_sc_hs__xor2_1_0/X VSS VDD sky130_fd_sc_hs__xor2_1
Xsky130_fd_sc_hs__mux2_1_1 VDD VSS sky130_fd_sc_hs__mux2_1_1/X sky130_fd_sc_hs__mux2_1_1/S
+ sky130_fd_sc_hs__mux2_1_9/A1 sky130_fd_sc_hs__mux2_1_1/A1 VSS VDD sky130_fd_sc_hs__mux2_1
Xsky130_fd_sc_hs__and3_1_2 VDD VSS sky130_fd_sc_hs__or2_1_3/X sky130_fd_sc_hs__and3_1_2/B
+ sky130_fd_sc_hs__and3_1_2/C sky130_fd_sc_hs__nor3_1_9/B VSS VDD sky130_fd_sc_hs__and3_1
Xsky130_fd_sc_hs__o31ai_1_5 VDD VSS sky130_fd_sc_hs__xnor2_1_1/Y sky130_fd_sc_hs__o21a_1_7/A2
+ sky130_fd_sc_hs__nor2_4_3/Y sky130_fd_sc_hs__o21a_1_7/A1 sky130_fd_sc_hs__o31ai_1_5/Y
+ VSS VDD sky130_fd_sc_hs__o31ai_1
Xsky130_fd_sc_hs__a21oi_1_2 VDD VSS sky130_fd_sc_hs__o21ai_1_1/Y sky130_fd_sc_hs__a21oi_1_2/Y
+ sky130_fd_sc_hs__o31ai_1_0/Y sky130_fd_sc_hs__o31a_1_0/B1 VSS VDD sky130_fd_sc_hs__a21oi_1
Xsky130_fd_sc_hs__clkbuf_2_107 VDD VSS sky130_fd_sc_hs__clkinv_1_53/A sky130_fd_sc_hs__clkbuf_2_92/A
+ VSS VDD sky130_fd_sc_hs__clkbuf_2
Xsky130_fd_sc_hs__clkbuf_2_118 VDD VSS sky130_fd_sc_hs__clkbuf_2_118/X sky130_fd_sc_hs__clkbuf_2_118/A
+ VSS VDD sky130_fd_sc_hs__clkbuf_2
Xsky130_fd_sc_hs__clkbuf_2_129 VDD VSS sky130_fd_sc_hs__clkbuf_2_129/X sky130_fd_sc_hs__clkbuf_2_129/A
+ VSS VDD sky130_fd_sc_hs__clkbuf_2
Xsky130_fd_sc_hs__nand2_1_107 VDD VSS sky130_fd_sc_hs__nor2_1_98/B sky130_fd_sc_hs__nor2_1_92/B
+ sky130_fd_sc_hs__nor2_1_94/A VSS VDD sky130_fd_sc_hs__nand2_1
Xsky130_fd_sc_hs__nand2_1_118 VDD VSS sky130_fd_sc_hs__buf_8_13/X sky130_fd_sc_hs__o31ai_1_12/B1
+ sky130_fd_sc_hs__and4_1_5/D VSS VDD sky130_fd_sc_hs__nand2_1
Xsky130_fd_sc_hs__nand2_1_129 VDD VSS sky130_fd_sc_hs__nor2b_1_41/Y sky130_fd_sc_hs__nand4_1_5/C
+ sky130_fd_sc_hs__nor2_4_0/A VSS VDD sky130_fd_sc_hs__nand2_1
Xsky130_fd_sc_hs__a222o_1_4 VDD VSS sky130_fd_sc_hs__a222o_1_4/C2 sky130_fd_sc_hs__a222o_1_4/X
+ sky130_fd_sc_hs__buf_8_32/X sky130_fd_sc_hs__maj3_1_35/C sky130_fd_sc_hs__a222o_1_7/B1
+ sky130_fd_sc_hs__or2_1_18/B sky130_fd_sc_hs__buf_4_4/A VSS VDD sky130_fd_sc_hs__a222o_1
Xsky130_fd_sc_hs__mux2_1_360 VDD VSS sky130_fd_sc_hs__mux2_1_360/X sky130_fd_sc_hs__buf_16_5/A
+ sky130_fd_sc_hs__mux2_1_360/A0 sky130_fd_sc_hs__dfrtp_2_3/Q VSS VDD sky130_fd_sc_hs__mux2_1
Xsky130_fd_sc_hs__mux2_1_371 VDD VSS sky130_fd_sc_hs__mux2_1_371/X sky130_fd_sc_hs__buf_16_0/A
+ sky130_fd_sc_hs__xor2_1_90/B sky130_fd_sc_hs__dfrtp_2_2/Q VSS VDD sky130_fd_sc_hs__mux2_1
Xsky130_fd_sc_hs__mux2_1_382 VDD VSS sky130_fd_sc_hs__mux2_1_382/X sky130_fd_sc_hs__buf_16_15/A
+ sky130_fd_sc_hs__a22o_1_89/B2 sky130_fd_sc_hs__mux2_1_382/A1 VSS VDD sky130_fd_sc_hs__mux2_1
Xsky130_fd_sc_hs__mux2_1_393 VDD VSS sky130_fd_sc_hs__mux2_1_393/X sky130_fd_sc_hs__buf_16_13/A
+ sky130_fd_sc_hs__xor2_1_86/B sky130_fd_sc_hs__a22o_1_94/B2 VSS VDD sky130_fd_sc_hs__mux2_1
Xsky130_fd_sc_hs__xor2_1_60 VDD VSS sky130_fd_sc_hs__xor2_1_60/A sky130_fd_sc_hs__xor2_1_60/B
+ sky130_fd_sc_hs__xor2_1_60/X VSS VDD sky130_fd_sc_hs__xor2_1
Xsky130_fd_sc_hs__xor2_1_71 VDD VSS sky130_fd_sc_hs__xor2_1_71/A sky130_fd_sc_hs__xor2_1_71/B
+ sky130_fd_sc_hs__xor2_1_71/X VSS VDD sky130_fd_sc_hs__xor2_1
Xsky130_fd_sc_hs__xor2_1_82 VDD VSS sky130_fd_sc_hs__xor2_1_86/B sky130_fd_sc_hs__xor2_1_82/B
+ sky130_fd_sc_hs__xor2_1_82/X VSS VDD sky130_fd_sc_hs__xor2_1
Xsky130_fd_sc_hs__xor2_1_93 VDD VSS sky130_fd_sc_hs__xor2_1_93/A sky130_fd_sc_hs__xor2_1_93/B
+ sky130_fd_sc_hs__or3_1_9/B VSS VDD sky130_fd_sc_hs__xor2_1
Xsky130_fd_sc_hs__nand2b_1_40 VDD VSS sky130_fd_sc_hs__and2_1_28/X sky130_fd_sc_hs__nand2b_1_40/B
+ sky130_fd_sc_hs__xnor2_1_78/A VSS VDD sky130_fd_sc_hs__nand2b_1
Xsky130_fd_sc_hs__nand2b_1_51 VDD VSS sky130_fd_sc_hs__or2_1_23/X sky130_fd_sc_hs__o21a_1_27/B1
+ sky130_fd_sc_hs__nand2b_1_51/Y VSS VDD sky130_fd_sc_hs__nand2b_1
Xsky130_fd_sc_hs__nand2b_1_62 VDD VSS sky130_fd_sc_hs__or3b_1_1/B sky130_fd_sc_hs__or3b_1_1/A
+ sky130_fd_sc_hs__nor3_4_8/C VSS VDD sky130_fd_sc_hs__nand2b_1
Xsky130_fd_sc_hs__buf_8_19 VDD VSS sky130_fd_sc_hs__buf_8_19/X sky130_fd_sc_hs__nor2_4_3/A
+ VSS VDD sky130_fd_sc_hs__buf_8
Xsky130_fd_sc_hs__o311ai_1_7 VDD VSS sky130_fd_sc_hs__or2_1_24/B sky130_fd_sc_hs__or3_1_1/X
+ sky130_fd_sc_hs__buf_1_55/A sky130_fd_sc_hs__o31a_1_5/B1 sky130_fd_sc_hs__o41ai_1_2/B1
+ sky130_fd_sc_hs__nor3_4_0/B VSS VDD sky130_fd_sc_hs__o311ai_1
Xsky130_fd_sc_hs__mux2_1_17 VDD VSS sky130_fd_sc_hs__mux2_1_17/X sky130_fd_sc_hs__mux2_1_8/S
+ sky130_fd_sc_hs__mux2_1_17/A0 sky130_fd_sc_hs__mux2_1_7/A1 VSS VDD sky130_fd_sc_hs__mux2_1
Xsky130_fd_sc_hs__mux2_1_28 VDD VSS sky130_fd_sc_hs__mux2_1_28/X sky130_fd_sc_hs__mux2_1_98/S
+ sky130_fd_sc_hs__mux2_1_28/A0 sky130_fd_sc_hs__mux2_1_40/A0 VSS VDD sky130_fd_sc_hs__mux2_1
Xsky130_fd_sc_hs__mux2_1_39 VDD VSS sky130_fd_sc_hs__mux2_1_39/X sky130_fd_sc_hs__mux2_1_5/S
+ sky130_fd_sc_hs__mux2_1_39/A0 sky130_fd_sc_hs__mux2_1_40/A0 VSS VDD sky130_fd_sc_hs__mux2_1
Xsky130_fd_sc_hs__mux2_1_190 VDD VSS sky130_fd_sc_hs__mux2_1_190/X sky130_fd_sc_hs__buf_16_3/A
+ sky130_fd_sc_hs__mux2_1_85/A0 sky130_fd_sc_hs__mux2_1_190/A1 VSS VDD sky130_fd_sc_hs__mux2_1
Xsky130_fd_sc_hs__buf_1_160 VDD VSS sky130_fd_sc_hs__buf_1_160/A raw_code_o[17] VSS
+ VDD sky130_fd_sc_hs__buf_1
Xsky130_fd_sc_hs__buf_1_171 VDD VSS sky130_fd_sc_hs__buf_1_171/A dac_p_force[13] VSS
+ VDD sky130_fd_sc_hs__buf_1
Xsky130_fd_sc_hs__buf_1_182 VDD VSS sky130_fd_sc_hs__buf_1_182/A dac_n_force[17] VSS
+ VDD sky130_fd_sc_hs__buf_1
Xsky130_fd_sc_hs__nand4_1_11 VDD VSS sky130_fd_sc_hs__and2_1_49/X sky130_fd_sc_hs__nand4_1_13/B
+ sky130_fd_sc_hs__nor2b_1_49/Y sky130_fd_sc_hs__nand4_1_11/B sky130_fd_sc_hs__nand4b_1_2/B
+ VSS VDD sky130_fd_sc_hs__nand4_1
Xsky130_fd_sc_hs__or2_1_16 VDD VSS sky130_fd_sc_hs__or2_1_16/B sky130_fd_sc_hs__or2_1_16/A
+ sky130_fd_sc_hs__or2_1_17/B VSS VDD sky130_fd_sc_hs__or2_1
Xsky130_fd_sc_hs__or2_1_27 VDD VSS sky130_fd_sc_hs__or3_1_0/A sky130_fd_sc_hs__or2_1_27/A
+ sky130_fd_sc_hs__or2_1_27/X VSS VDD sky130_fd_sc_hs__or2_1
Xsky130_fd_sc_hs__dfrtp_1_207 sky130_fd_sc_hs__clkbuf_4_0/X VDD VSS sky130_fd_sc_hs__mux2_1_121/A0
+ sky130_fd_sc_hs__clkbuf_2_31/X sky130_fd_sc_hs__mux2_1_121/X VSS VDD sky130_fd_sc_hs__dfrtp_1
Xsky130_fd_sc_hs__dfrtp_1_218 sky130_fd_sc_hs__clkbuf_4_12/A VDD VSS sky130_fd_sc_hs__buf_1_16/A
+ sky130_fd_sc_hs__clkinv_1_46/A sky130_fd_sc_hs__a22o_1_21/X VSS VDD sky130_fd_sc_hs__dfrtp_1
Xsky130_fd_sc_hs__dfrtp_1_229 sky130_fd_sc_hs__buf_8_4/X VDD VSS sky130_fd_sc_hs__a22o_1_20/B2
+ sky130_fd_sc_hs__clkbuf_2_67/X sky130_fd_sc_hs__dfrtp_1_229/D VSS VDD sky130_fd_sc_hs__dfrtp_1
Xsky130_fd_sc_hs__o2bb2ai_1_60 VDD VSS sky130_fd_sc_hs__buf_1_121/A sky130_fd_sc_hs__nand2_1_155/Y
+ sky130_fd_sc_hs__o22ai_1_3/B2 sky130_fd_sc_hs__nand4_1_5/D sky130_fd_sc_hs__buf_8_20/X
+ VSS VDD sky130_fd_sc_hs__o2bb2ai_1
Xsky130_fd_sc_hs__o2bb2ai_1_71 VDD VSS sky130_fd_sc_hs__dfrtp_1_764/D sky130_fd_sc_hs__xnor2_1_138/Y
+ sky130_fd_sc_hs__xnor3_1_1/A sky130_fd_sc_hs__o31ai_1_4/A1 sky130_fd_sc_hs__nor2_4_3/B
+ VSS VDD sky130_fd_sc_hs__o2bb2ai_1
Xsky130_fd_sc_hs__clkinv_1_17 VDD VSS sky130_fd_sc_hs__clkinv_1_17/A sky130_fd_sc_hs__clkinv_1_17/Y
+ VSS VDD sky130_fd_sc_hs__clkinv_1
Xsky130_fd_sc_hs__clkinv_1_28 VDD VSS sky130_fd_sc_hs__clkinv_1_28/A sky130_fd_sc_hs__clkinv_1_28/Y
+ VSS VDD sky130_fd_sc_hs__clkinv_1
Xsky130_fd_sc_hs__clkinv_1_39 VDD VSS sky130_fd_sc_hs__clkinv_1_39/A sky130_fd_sc_hs__clkinv_1_39/Y
+ VSS VDD sky130_fd_sc_hs__clkinv_1
Xsky130_fd_sc_hs__a31oi_1_10 VDD VSS sky130_fd_sc_hs__a31oi_1_10/Y sky130_fd_sc_hs__and4_1_5/C
+ sky130_fd_sc_hs__and4_1_5/D sky130_fd_sc_hs__and4_1_5/B sky130_fd_sc_hs__and4_1_5/A
+ VSS VDD sky130_fd_sc_hs__a31oi_1
Xsky130_fd_sc_hs__dfrtp_1_730 sky130_fd_sc_hs__buf_8_34/X VDD VSS sky130_fd_sc_hs__mux2_1_467/A0
+ sky130_fd_sc_hs__clkbuf_2_228/X sky130_fd_sc_hs__mux2_1_467/X VSS VDD sky130_fd_sc_hs__dfrtp_1
Xsky130_fd_sc_hs__dfrtp_1_741 sky130_fd_sc_hs__buf_8_35/X VDD VSS sky130_fd_sc_hs__mux2_1_454/A1
+ sky130_fd_sc_hs__clkbuf_2_234/X sky130_fd_sc_hs__mux2_1_454/X VSS VDD sky130_fd_sc_hs__dfrtp_1
Xsky130_fd_sc_hs__dfrtp_1_752 sky130_fd_sc_hs__clkbuf_4_50/X VDD VSS sky130_fd_sc_hs__mux2_1_427/A0
+ sky130_fd_sc_hs__clkbuf_2_226/X sky130_fd_sc_hs__mux2_1_427/X VSS VDD sky130_fd_sc_hs__dfrtp_1
Xsky130_fd_sc_hs__dfrtp_1_763 sky130_fd_sc_hs__clkbuf_4_51/X VDD VSS sky130_fd_sc_hs__mux2_1_417/A1
+ sky130_fd_sc_hs__clkbuf_2_218/X sky130_fd_sc_hs__mux2_1_417/X VSS VDD sky130_fd_sc_hs__dfrtp_1
Xsky130_fd_sc_hs__dfrtp_1_774 sky130_fd_sc_hs__clkbuf_4_33/X VDD VSS sky130_fd_sc_hs__mux2_1_357/A0
+ sky130_fd_sc_hs__clkbuf_2_200/X sky130_fd_sc_hs__mux2_1_357/X VSS VDD sky130_fd_sc_hs__dfrtp_1
Xsky130_fd_sc_hs__dfrtp_1_785 sky130_fd_sc_hs__clkbuf_4_50/X VDD VSS sky130_fd_sc_hs__xor2_1_89/A
+ sky130_fd_sc_hs__clkbuf_2_224/X sky130_fd_sc_hs__nand2_1_209/Y VSS VDD sky130_fd_sc_hs__dfrtp_1
Xsky130_fd_sc_hs__dfrtp_2_4 sky130_fd_sc_hs__clkbuf_4_35/X VDD VSS sky130_fd_sc_hs__dfrtp_2_4/D
+ sky130_fd_sc_hs__dfrtp_2_4/CLK sky130_fd_sc_hs__or3b_1_0/B VSS VDD sky130_fd_sc_hs__dfrtp_2
Xsky130_fd_sc_hs__dfrtp_1_796 sky130_fd_sc_hs__clkbuf_4_15/X VDD VSS sky130_fd_sc_hs__or2_1_1/B
+ sky130_fd_sc_hs__clkbuf_2_37/X sky130_fd_sc_hs__mux2_1_212/X VSS VDD sky130_fd_sc_hs__dfrtp_1
Xsky130_fd_sc_hs__nand3_1_8 VDD VSS sky130_fd_sc_hs__nand3_1_8/C sky130_fd_sc_hs__and2_1_2/B
+ sky130_fd_sc_hs__nand3_1_8/B sky130_fd_sc_hs__nand3_1_8/A VSS VDD sky130_fd_sc_hs__nand3_1
Xsky130_fd_sc_hs__nor3_1_4 VDD VSS sky130_fd_sc_hs__nor3_1_4/Y sky130_fd_sc_hs__nor3_1_4/C
+ sky130_fd_sc_hs__nor3_1_4/B sky130_fd_sc_hs__nor3_1_4/A VSS VDD sky130_fd_sc_hs__nor3_1
Xsky130_fd_sc_hs__xnor2_1_12 VDD VSS sky130_fd_sc_hs__or2_1_1/B sky130_fd_sc_hs__xnor2_1_12/Y
+ sky130_fd_sc_hs__maj3_1_3/C VSS VDD sky130_fd_sc_hs__xnor2_1
Xsky130_fd_sc_hs__xnor2_1_23 VDD VSS sky130_fd_sc_hs__or2_1_3/A sky130_fd_sc_hs__nor2b_1_7/A
+ sky130_fd_sc_hs__xor2_1_4/X VSS VDD sky130_fd_sc_hs__xnor2_1
Xsky130_fd_sc_hs__xnor2_1_34 VDD VSS sky130_fd_sc_hs__maj3_1_8/A sky130_fd_sc_hs__xor2_1_13/B
+ sky130_fd_sc_hs__xor2_1_12/X VSS VDD sky130_fd_sc_hs__xnor2_1
Xsky130_fd_sc_hs__xnor2_1_45 VDD VSS sky130_fd_sc_hs__or2_1_10/A sky130_fd_sc_hs__xnor2_1_45/Y
+ sky130_fd_sc_hs__xnor2_1_45/B VSS VDD sky130_fd_sc_hs__xnor2_1
Xsky130_fd_sc_hs__xnor2_1_56 VDD VSS sky130_fd_sc_hs__maj3_1_18/C sky130_fd_sc_hs__xor2_1_93/B
+ sky130_fd_sc_hs__xor2_1_30/X VSS VDD sky130_fd_sc_hs__xnor2_1
Xsky130_fd_sc_hs__xnor2_1_67 VDD VSS sky130_fd_sc_hs__xnor2_1_67/A sky130_fd_sc_hs__xnor2_1_67/Y
+ sky130_fd_sc_hs__xor2_1_43/X VSS VDD sky130_fd_sc_hs__xnor2_1
Xsky130_fd_sc_hs__xnor2_1_78 VDD VSS sky130_fd_sc_hs__xnor2_1_78/A sky130_fd_sc_hs__xnor2_1_78/Y
+ sky130_fd_sc_hs__or2_1_14/X VSS VDD sky130_fd_sc_hs__xnor2_1
Xsky130_fd_sc_hs__xnor2_1_89 VDD VSS sky130_fd_sc_hs__maj3_1_33/X sky130_fd_sc_hs__xnor2_1_89/Y
+ sky130_fd_sc_hs__xnor2_1_89/B VSS VDD sky130_fd_sc_hs__xnor2_1
Xsky130_fd_sc_hs__a211oi_1_3 VDD VSS sky130_fd_sc_hs__o21ai_1_7/B1 sky130_fd_sc_hs__a211oi_1_3/Y
+ sky130_fd_sc_hs__a21oi_1_32/Y sky130_fd_sc_hs__a31o_1_14/B1 sky130_fd_sc_hs__xnor2_1_16/A
+ VSS VDD sky130_fd_sc_hs__a211oi_1
Xsky130_fd_sc_hs__a22oi_1_4 VDD VSS sky130_fd_sc_hs__a22oi_1_4/B2 sky130_fd_sc_hs__nand3_1_0/B
+ sky130_fd_sc_hs__buf_16_7/X sky130_fd_sc_hs__a22o_1_8/B1 sky130_fd_sc_hs__maj3_1_7/B
+ VSS VDD sky130_fd_sc_hs__a22oi_1
Xsky130_fd_sc_hs__dfrtp_1_560 sky130_fd_sc_hs__buf_8_25/X VDD VSS sky130_fd_sc_hs__nor2b_1_45/A
+ sky130_fd_sc_hs__clkinv_1_123/A sky130_fd_sc_hs__a22o_1_117/X VSS VDD sky130_fd_sc_hs__dfrtp_1
Xsky130_fd_sc_hs__dfrtp_1_571 sky130_fd_sc_hs__clkbuf_4_24/X VDD VSS sky130_fd_sc_hs__buf_1_151/A
+ sky130_fd_sc_hs__dfstp_1_2/CLK sky130_fd_sc_hs__dfrtp_1_571/D VSS VDD sky130_fd_sc_hs__dfrtp_1
Xsky130_fd_sc_hs__dfrtp_1_582 sky130_fd_sc_hs__clkbuf_4_24/X VDD VSS sky130_fd_sc_hs__buf_1_159/A
+ sky130_fd_sc_hs__clkinv_1_127/A sky130_fd_sc_hs__a32o_1_11/X VSS VDD sky130_fd_sc_hs__dfrtp_1
Xsky130_fd_sc_hs__dfrtp_1_593 sky130_fd_sc_hs__buf_8_1/A VDD VSS sky130_fd_sc_hs__and2_1_9/A
+ sky130_fd_sc_hs__clkinv_1_131/A sky130_fd_sc_hs__mux2_1_292/X VSS VDD sky130_fd_sc_hs__dfrtp_1
Xsky130_fd_sc_hs__or3b_1_1 VDD VSS sky130_fd_sc_hs__or3b_1_1/A sky130_fd_sc_hs__or3b_1_1/B
+ sky130_fd_sc_hs__or3b_1_0/B sky130_fd_sc_hs__or3b_1_1/X VSS VDD sky130_fd_sc_hs__or3b_1
Xsky130_fd_sc_hs__xor2_1_1 VDD VSS sky130_fd_sc_hs__xor2_1_1/A sky130_fd_sc_hs__xor2_1_1/B
+ sky130_fd_sc_hs__xor2_1_1/X VSS VDD sky130_fd_sc_hs__xor2_1
Xsky130_fd_sc_hs__mux2_1_2 VDD VSS sky130_fd_sc_hs__mux2_1_2/X sky130_fd_sc_hs__mux2_1_7/S
+ sky130_fd_sc_hs__mux2_1_2/A0 sky130_fd_sc_hs__mux2_1_9/A1 VSS VDD sky130_fd_sc_hs__mux2_1
Xsky130_fd_sc_hs__dfrtp_1_390 sky130_fd_sc_hs__clkbuf_4_14/X VDD VSS sky130_fd_sc_hs__mux2_1_98/A1
+ sky130_fd_sc_hs__clkbuf_2_95/X sky130_fd_sc_hs__a22o_1_44/X VSS VDD sky130_fd_sc_hs__dfrtp_1
Xsky130_fd_sc_hs__and3_1_3 VDD VSS sky130_fd_sc_hs__and3_1_3/A sky130_fd_sc_hs__and3_1_3/B
+ sky130_fd_sc_hs__and3_1_3/C sky130_fd_sc_hs__and3_1_3/X VSS VDD sky130_fd_sc_hs__and3_1
Xsky130_fd_sc_hs__o31ai_1_6 VDD VSS sky130_fd_sc_hs__or2_1_10/B sky130_fd_sc_hs__xnor2_1_45/B
+ sky130_fd_sc_hs__o31ai_1_6/B1 sky130_fd_sc_hs__o31ai_1_6/A1 sky130_fd_sc_hs__o31ai_1_6/Y
+ VSS VDD sky130_fd_sc_hs__o31ai_1
Xsky130_fd_sc_hs__a21oi_1_3 VDD VSS sky130_fd_sc_hs__a21oi_1_6/Y sky130_fd_sc_hs__a21oi_1_3/Y
+ sky130_fd_sc_hs__o211ai_1_2/Y sky130_fd_sc_hs__nor3_1_4/A VSS VDD sky130_fd_sc_hs__a21oi_1
Xsky130_fd_sc_hs__clkbuf_2_108 VDD VSS sky130_fd_sc_hs__clkinv_2_8/A sky130_fd_sc_hs__clkinv_4_3/A
+ VSS VDD sky130_fd_sc_hs__clkbuf_2
Xsky130_fd_sc_hs__clkbuf_2_119 VDD VSS sky130_fd_sc_hs__clkinv_1_81/A sky130_fd_sc_hs__clkinv_4_5/A
+ VSS VDD sky130_fd_sc_hs__clkbuf_2
Xsky130_fd_sc_hs__nand2_1_108 VDD VSS sky130_fd_sc_hs__nor2_1_97/A sky130_fd_sc_hs__nand4_1_5/A
+ sky130_fd_sc_hs__nand2_2_1/B VSS VDD sky130_fd_sc_hs__nand2_1
Xsky130_fd_sc_hs__nand2_1_119 VDD VSS sky130_fd_sc_hs__o21a_1_21/A2 sky130_fd_sc_hs__nand2_1_119/Y
+ sky130_fd_sc_hs__and2_1_31/X VSS VDD sky130_fd_sc_hs__nand2_1
Xsky130_fd_sc_hs__a222o_1_5 VDD VSS sky130_fd_sc_hs__a222o_1_5/C2 sky130_fd_sc_hs__a222o_1_5/X
+ sky130_fd_sc_hs__buf_4_3/X sky130_fd_sc_hs__a222o_1_5/B2 sky130_fd_sc_hs__a222o_1_7/A2
+ sky130_fd_sc_hs__a222o_1_5/A1 sky130_fd_sc_hs__buf_8_31/X VSS VDD sky130_fd_sc_hs__a222o_1
Xsky130_fd_sc_hs__mux2_1_350 VDD VSS sky130_fd_sc_hs__mux2_1_350/X sky130_fd_sc_hs__buf_8_27/X
+ sky130_fd_sc_hs__nand2_1_197/A sky130_fd_sc_hs__mux2_1_355/A1 VSS VDD sky130_fd_sc_hs__mux2_1
Xsky130_fd_sc_hs__mux2_1_361 VDD VSS sky130_fd_sc_hs__mux2_1_361/X sky130_fd_sc_hs__mux2_1_99/S
+ sky130_fd_sc_hs__dfrtp_2_3/Q sky130_fd_sc_hs__mux2_1_361/A1 VSS VDD sky130_fd_sc_hs__mux2_1
Xsky130_fd_sc_hs__mux2_1_372 VDD VSS sky130_fd_sc_hs__mux2_1_372/X sky130_fd_sc_hs__buf_16_13/A
+ sky130_fd_sc_hs__xor2_1_90/A sky130_fd_sc_hs__dfrtp_2_2/Q VSS VDD sky130_fd_sc_hs__mux2_1
Xsky130_fd_sc_hs__mux2_1_383 VDD VSS sky130_fd_sc_hs__mux2_1_383/X sky130_fd_sc_hs__buf_16_6/A
+ sky130_fd_sc_hs__a222o_1_6/B2 sky130_fd_sc_hs__dfrtp_2_2/Q VSS VDD sky130_fd_sc_hs__mux2_1
Xsky130_fd_sc_hs__mux2_1_394 VDD VSS sky130_fd_sc_hs__mux2_1_394/X sky130_fd_sc_hs__mux2_1_1/S
+ sky130_fd_sc_hs__a22o_1_89/B2 sky130_fd_sc_hs__mux2_1_394/A1 VSS VDD sky130_fd_sc_hs__mux2_1
Xsky130_fd_sc_hs__xor2_1_50 VDD VSS sky130_fd_sc_hs__xor2_1_50/A sky130_fd_sc_hs__xor2_1_50/B
+ sky130_fd_sc_hs__xor2_1_50/X VSS VDD sky130_fd_sc_hs__xor2_1
Xsky130_fd_sc_hs__xor2_1_61 VDD VSS sky130_fd_sc_hs__xor2_1_61/A sky130_fd_sc_hs__xor2_1_61/B
+ sky130_fd_sc_hs__xor2_1_61/X VSS VDD sky130_fd_sc_hs__xor2_1
Xsky130_fd_sc_hs__xor2_1_72 VDD VSS sky130_fd_sc_hs__xor2_1_72/A sky130_fd_sc_hs__xor2_1_72/B
+ sky130_fd_sc_hs__or2_1_20/B VSS VDD sky130_fd_sc_hs__xor2_1
Xsky130_fd_sc_hs__xor2_1_83 VDD VSS sky130_fd_sc_hs__xor2_1_83/A sky130_fd_sc_hs__xor2_1_83/B
+ sky130_fd_sc_hs__xor2_1_83/X VSS VDD sky130_fd_sc_hs__xor2_1
Xsky130_fd_sc_hs__nand2b_1_30 VDD VSS sky130_fd_sc_hs__xnor2_1_64/B sky130_fd_sc_hs__maj3_1_19/X
+ sky130_fd_sc_hs__nand2_1_81/A VSS VDD sky130_fd_sc_hs__nand2b_1
Xsky130_fd_sc_hs__nand2b_1_41 VDD VSS sky130_fd_sc_hs__nor3_1_26/B sky130_fd_sc_hs__nor3_1_26/A
+ sky130_fd_sc_hs__nor2_2_2/B VSS VDD sky130_fd_sc_hs__nand2b_1
Xsky130_fd_sc_hs__nand2b_1_52 VDD VSS sky130_fd_sc_hs__xor2_1_75/A sky130_fd_sc_hs__xor2_1_75/B
+ sky130_fd_sc_hs__nor2_1_141/B VSS VDD sky130_fd_sc_hs__nand2b_1
Xsky130_fd_sc_hs__nand2b_1_63 VDD VSS sky130_fd_sc_hs__or2_1_29/A sky130_fd_sc_hs__or3b_1_0/A
+ sky130_fd_sc_hs__nor3_4_6/C VSS VDD sky130_fd_sc_hs__nand2b_1
Xsky130_fd_sc_hs__o311ai_1_8 VDD VSS sky130_fd_sc_hs__or3_1_5/B sky130_fd_sc_hs__or3_1_1/X
+ sky130_fd_sc_hs__buf_1_46/A sky130_fd_sc_hs__o31a_1_5/B1 sky130_fd_sc_hs__o311ai_1_8/Y
+ sky130_fd_sc_hs__or3_1_6/C VSS VDD sky130_fd_sc_hs__o311ai_1
Xsky130_fd_sc_hs__mux2_1_18 VDD VSS sky130_fd_sc_hs__mux2_1_18/X sky130_fd_sc_hs__buf_16_1/A
+ sky130_fd_sc_hs__dfrtp_1_4/Q sky130_fd_sc_hs__mux2_1_7/A1 VSS VDD sky130_fd_sc_hs__mux2_1
Xsky130_fd_sc_hs__mux2_1_29 VDD VSS sky130_fd_sc_hs__mux2_1_29/X sky130_fd_sc_hs__buf_16_2/X
+ sky130_fd_sc_hs__mux2_1_40/A0 sky130_fd_sc_hs__mux2_1_29/A1 VSS VDD sky130_fd_sc_hs__mux2_1
Xsky130_fd_sc_hs__mux2_1_180 VDD VSS sky130_fd_sc_hs__mux2_1_180/X sky130_fd_sc_hs__mux2_1_6/S
+ sky130_fd_sc_hs__mux2_1_40/A0 sky130_fd_sc_hs__a222o_1_1/C2 VSS VDD sky130_fd_sc_hs__mux2_1
Xsky130_fd_sc_hs__mux2_1_191 VDD VSS sky130_fd_sc_hs__mux2_1_191/X sky130_fd_sc_hs__buf_16_0/X
+ sky130_fd_sc_hs__xor2_1_35/B sky130_fd_sc_hs__mux2_1_85/A0 VSS VDD sky130_fd_sc_hs__mux2_1
Xsky130_fd_sc_hs__and3_1_10 VDD VSS sky130_fd_sc_hs__nor2_1_55/A sky130_fd_sc_hs__and3_1_10/B
+ sky130_fd_sc_hs__or2_1_8/A sky130_fd_sc_hs__and3_1_9/C VSS VDD sky130_fd_sc_hs__and3_1
Xsky130_fd_sc_hs__buf_1_150 VDD VSS sky130_fd_sc_hs__buf_1_150/A w_wr_data[4] VSS
+ VDD sky130_fd_sc_hs__buf_1
Xsky130_fd_sc_hs__buf_1_161 VDD VSS sky130_fd_sc_hs__buf_1_161/A calib_overrange_bits[16]
+ VSS VDD sky130_fd_sc_hs__buf_1
Xsky130_fd_sc_hs__buf_1_172 VDD VSS sky130_fd_sc_hs__buf_1_172/A dac_n_force[13] VSS
+ VDD sky130_fd_sc_hs__buf_1
Xsky130_fd_sc_hs__buf_1_183 VDD VSS sky130_fd_sc_hs__buf_1_183/A w_wr_data[27] VSS
+ VDD sky130_fd_sc_hs__buf_1
Xsky130_fd_sc_hs__nor2_2_10 VDD VSS sky130_fd_sc_hs__or3b_1_1/X sky130_fd_sc_hs__buf_4_4/A
+ sky130_fd_sc_hs__nor3_4_6/C VSS VDD sky130_fd_sc_hs__nor2_2
Xsky130_fd_sc_hs__o41ai_1_0 VDD VSS sky130_fd_sc_hs__and3_1_5/C sky130_fd_sc_hs__and3_1_5/B
+ sky130_fd_sc_hs__o41ai_1_0/B1 sky130_fd_sc_hs__o41ai_1_0/Y sky130_fd_sc_hs__o41ai_1_0/A4
+ sky130_fd_sc_hs__and3_1_5/A VSS VDD sky130_fd_sc_hs__o41ai_1
Xsky130_fd_sc_hs__nand4_1_12 VDD VSS sky130_fd_sc_hs__nor3_1_55/Y sky130_fd_sc_hs__xor2_1_81/B
+ sky130_fd_sc_hs__nand4_1_12/D sky130_fd_sc_hs__nand4_1_12/B sky130_fd_sc_hs__nand4_1_12/A
+ VSS VDD sky130_fd_sc_hs__nand4_1
Xsky130_fd_sc_hs__or2_1_17 VDD VSS sky130_fd_sc_hs__or2_1_17/B sky130_fd_sc_hs__or2_1_17/A
+ sky130_fd_sc_hs__or2_1_17/X VSS VDD sky130_fd_sc_hs__or2_1
Xsky130_fd_sc_hs__or2_1_28 VDD VSS sky130_fd_sc_hs__or2_1_28/B sky130_fd_sc_hs__or2_1_28/A
+ sky130_fd_sc_hs__or2_1_28/X VSS VDD sky130_fd_sc_hs__or2_1
Xsky130_fd_sc_hs__dfrtp_1_208 sky130_fd_sc_hs__clkbuf_4_0/X VDD VSS sky130_fd_sc_hs__mux2_1_64/A0
+ sky130_fd_sc_hs__clkbuf_2_28/X sky130_fd_sc_hs__mux2_1_64/X VSS VDD sky130_fd_sc_hs__dfrtp_1
Xsky130_fd_sc_hs__dfrtp_1_219 sky130_fd_sc_hs__buf_2_0/A VDD VSS sky130_fd_sc_hs__buf_1_61/A
+ sky130_fd_sc_hs__clkbuf_2_67/X sky130_fd_sc_hs__a22o_1_18/X VSS VDD sky130_fd_sc_hs__dfrtp_1
Xsky130_fd_sc_hs__o2bb2ai_1_50 VDD VSS sky130_fd_sc_hs__dfrtp_1_493/D sky130_fd_sc_hs__mux2i_1_12/Y
+ sky130_fd_sc_hs__nor2_1_147/A sky130_fd_sc_hs__nand2b_1_51/Y sky130_fd_sc_hs__or2_1_23/X
+ VSS VDD sky130_fd_sc_hs__o2bb2ai_1
Xsky130_fd_sc_hs__o2bb2ai_1_61 VDD VSS sky130_fd_sc_hs__buf_1_125/A sky130_fd_sc_hs__nand4_1_5/C
+ sky130_fd_sc_hs__o22ai_1_2/B2 sky130_fd_sc_hs__nand2_1_164/Y sky130_fd_sc_hs__nand2_1_125/Y
+ VSS VDD sky130_fd_sc_hs__o2bb2ai_1
Xsky130_fd_sc_hs__o2bb2ai_1_72 VDD VSS sky130_fd_sc_hs__dfrtp_1_692/D sky130_fd_sc_hs__o21ai_1_105/Y
+ sky130_fd_sc_hs__maj3_1_56/A sky130_fd_sc_hs__and2_1_46/X sky130_fd_sc_hs__o31ai_4_0/Y
+ VSS VDD sky130_fd_sc_hs__o2bb2ai_1
Xsky130_fd_sc_hs__clkinv_1_18 VDD VSS sky130_fd_sc_hs__clkinv_1_18/A sky130_fd_sc_hs__clkinv_1_18/Y
+ VSS VDD sky130_fd_sc_hs__clkinv_1
Xsky130_fd_sc_hs__clkinv_1_29 VDD VSS sky130_fd_sc_hs__clkinv_1_29/A sky130_fd_sc_hs__clkinv_1_29/Y
+ VSS VDD sky130_fd_sc_hs__clkinv_1
Xsky130_fd_sc_hs__a31oi_1_11 VDD VSS sky130_fd_sc_hs__nor2_1_132/B sky130_fd_sc_hs__nor3_1_35/C
+ sky130_fd_sc_hs__or2_1_23/A sky130_fd_sc_hs__nor3_1_36/Y sky130_fd_sc_hs__o21a_1_27/B1
+ VSS VDD sky130_fd_sc_hs__a31oi_1
Xsky130_fd_sc_hs__dfrtp_1_720 sky130_fd_sc_hs__clkbuf_4_50/X VDD VSS sky130_fd_sc_hs__maj3_1_66/C
+ sky130_fd_sc_hs__clkbuf_2_225/X sky130_fd_sc_hs__mux2_1_429/X VSS VDD sky130_fd_sc_hs__dfrtp_1
Xsky130_fd_sc_hs__dfrtp_1_731 sky130_fd_sc_hs__clkbuf_4_50/X VDD VSS sky130_fd_sc_hs__mux2_1_471/A1
+ sky130_fd_sc_hs__clkbuf_2_228/X sky130_fd_sc_hs__mux2_1_471/X VSS VDD sky130_fd_sc_hs__dfrtp_1
Xsky130_fd_sc_hs__dfrtp_1_742 sky130_fd_sc_hs__buf_8_35/X VDD VSS sky130_fd_sc_hs__mux2_1_445/A0
+ sky130_fd_sc_hs__clkbuf_2_231/X sky130_fd_sc_hs__mux2_1_445/X VSS VDD sky130_fd_sc_hs__dfrtp_1
Xsky130_fd_sc_hs__dfrtp_1_753 sky130_fd_sc_hs__buf_8_35/A VDD VSS sky130_fd_sc_hs__nor2_1_183/A
+ sky130_fd_sc_hs__clkbuf_2_226/X sky130_fd_sc_hs__mux2_1_433/X VSS VDD sky130_fd_sc_hs__dfrtp_1
Xsky130_fd_sc_hs__dfrtp_1_764 sky130_fd_sc_hs__clkbuf_4_33/X VDD VSS sky130_fd_sc_hs__xnor3_1_1/A
+ sky130_fd_sc_hs__clkinv_1_158/A sky130_fd_sc_hs__dfrtp_1_764/D VSS VDD sky130_fd_sc_hs__dfrtp_1
Xsky130_fd_sc_hs__dfrtp_1_775 sky130_fd_sc_hs__clkbuf_4_30/X VDD VSS sky130_fd_sc_hs__mux2_1_354/A0
+ sky130_fd_sc_hs__clkinv_2_10/A sky130_fd_sc_hs__mux2_1_354/X VSS VDD sky130_fd_sc_hs__dfrtp_1
Xsky130_fd_sc_hs__dfrtp_1_786 sky130_fd_sc_hs__clkbuf_4_12/A VDD VSS sky130_fd_sc_hs__xor2_1_0/A
+ sky130_fd_sc_hs__clkinv_1_49/A sky130_fd_sc_hs__a22o_1_23/X VSS VDD sky130_fd_sc_hs__dfrtp_1
Xsky130_fd_sc_hs__dfrtp_1_797 sky130_fd_sc_hs__clkbuf_4_19/X VDD VSS sky130_fd_sc_hs__xor2_1_65/A
+ sky130_fd_sc_hs__clkinv_1_84/A sky130_fd_sc_hs__mux2_1_241/X VSS VDD sky130_fd_sc_hs__dfrtp_1
Xsky130_fd_sc_hs__nand3_1_9 VDD VSS sky130_fd_sc_hs__nand3_1_9/C sky130_fd_sc_hs__and2_1_7/B
+ sky130_fd_sc_hs__nand3_1_9/B sky130_fd_sc_hs__nand3_1_9/A VSS VDD sky130_fd_sc_hs__nand3_1
Xsky130_fd_sc_hs__nor3_1_5 VDD VSS sky130_fd_sc_hs__nor3_1_5/Y sky130_fd_sc_hs__nor3_1_5/C
+ sky130_fd_sc_hs__nor3_1_5/B sky130_fd_sc_hs__nor3_1_5/A VSS VDD sky130_fd_sc_hs__nor3_1
Xsky130_fd_sc_hs__xnor2_1_13 VDD VSS sky130_fd_sc_hs__maj3_1_4/A sky130_fd_sc_hs__xor2_1_2/B
+ sky130_fd_sc_hs__xor2_1_1/X VSS VDD sky130_fd_sc_hs__xnor2_1
Xsky130_fd_sc_hs__xnor2_1_24 VDD VSS sky130_fd_sc_hs__maj3_1_1/B sky130_fd_sc_hs__xnor2_1_26/B
+ sky130_fd_sc_hs__maj3_1_1/C VSS VDD sky130_fd_sc_hs__xnor2_1
Xsky130_fd_sc_hs__xnor2_1_35 VDD VSS sky130_fd_sc_hs__maj3_1_9/A sky130_fd_sc_hs__xor2_1_8/B
+ sky130_fd_sc_hs__xor2_1_15/X VSS VDD sky130_fd_sc_hs__xnor2_1
Xsky130_fd_sc_hs__xnor2_1_46 VDD VSS sky130_fd_sc_hs__and3_1_8/C sky130_fd_sc_hs__xnor2_1_46/Y
+ sky130_fd_sc_hs__nor2_1_51/Y VSS VDD sky130_fd_sc_hs__xnor2_1
Xsky130_fd_sc_hs__xnor2_1_57 VDD VSS sky130_fd_sc_hs__maj3_1_17/C sky130_fd_sc_hs__xnor2_1_57/Y
+ sky130_fd_sc_hs__xor2_1_29/X VSS VDD sky130_fd_sc_hs__xnor2_1
Xsky130_fd_sc_hs__xnor2_1_68 VDD VSS sky130_fd_sc_hs__or2_1_13/X sky130_fd_sc_hs__xnor2_1_68/Y
+ sky130_fd_sc_hs__xor2_1_44/X VSS VDD sky130_fd_sc_hs__xnor2_1
Xsky130_fd_sc_hs__xnor2_1_79 VDD VSS sky130_fd_sc_hs__maj3_1_30/X sky130_fd_sc_hs__xnor2_1_81/A
+ sky130_fd_sc_hs__xnor2_1_82/Y VSS VDD sky130_fd_sc_hs__xnor2_1
Xsky130_fd_sc_hs__a211oi_1_4 VDD VSS sky130_fd_sc_hs__clkinv_1_96/Y sky130_fd_sc_hs__or3_1_2/C
+ sky130_fd_sc_hs__nor2b_1_29/Y sky130_fd_sc_hs__or2_1_19/B sky130_fd_sc_hs__or2_1_19/A
+ VSS VDD sky130_fd_sc_hs__a211oi_1
Xsky130_fd_sc_hs__a22oi_1_5 VDD VSS sky130_fd_sc_hs__maj3_1_7/C sky130_fd_sc_hs__nand3_1_1/A
+ sky130_fd_sc_hs__a22oi_1_6/B1 sky130_fd_sc_hs__a22oi_1_5/A2 sky130_fd_sc_hs__dfrtp_1_9/Q
+ VSS VDD sky130_fd_sc_hs__a22oi_1
Xsky130_fd_sc_hs__dfrtp_1_550 sky130_fd_sc_hs__clkbuf_4_28/X VDD VSS sky130_fd_sc_hs__mux2_1_261/A1
+ sky130_fd_sc_hs__clkinv_1_114/A sky130_fd_sc_hs__mux2_1_261/X VSS VDD sky130_fd_sc_hs__dfrtp_1
Xsky130_fd_sc_hs__dfrtp_1_561 sky130_fd_sc_hs__clkbuf_4_28/X VDD VSS sky130_fd_sc_hs__buf_1_152/A
+ sky130_fd_sc_hs__dfstp_1_1/CLK sky130_fd_sc_hs__mux2_1_279/X VSS VDD sky130_fd_sc_hs__dfrtp_1
Xsky130_fd_sc_hs__dfrtp_1_572 sky130_fd_sc_hs__clkbuf_4_24/X VDD VSS sky130_fd_sc_hs__mux2_1_283/A0
+ sky130_fd_sc_hs__clkinv_1_125/A sky130_fd_sc_hs__mux2_1_283/X VSS VDD sky130_fd_sc_hs__dfrtp_1
Xsky130_fd_sc_hs__dfrtp_1_583 sky130_fd_sc_hs__buf_8_29/X VDD VSS sky130_fd_sc_hs__mux2_1_277/A0
+ sky130_fd_sc_hs__clkbuf_2_237/X sky130_fd_sc_hs__mux2_1_277/X VSS VDD sky130_fd_sc_hs__dfrtp_1
Xsky130_fd_sc_hs__dfrtp_1_594 sky130_fd_sc_hs__buf_8_1/A VDD VSS sky130_fd_sc_hs__mux2_1_293/A0
+ sky130_fd_sc_hs__clkinv_1_129/A sky130_fd_sc_hs__mux2_1_293/X VSS VDD sky130_fd_sc_hs__dfrtp_1
Xsky130_fd_sc_hs__a21oi_1_90 VDD VSS sky130_fd_sc_hs__a21oi_1_89/Y sky130_fd_sc_hs__nor2_1_185/B
+ sky130_fd_sc_hs__xnor2_1_72/Y sky130_fd_sc_hs__o21ai_1_7/B1 VSS VDD sky130_fd_sc_hs__a21oi_1
Xsky130_fd_sc_hs__xor2_1_2 VDD VSS sky130_fd_sc_hs__xor2_1_2/A sky130_fd_sc_hs__xor2_1_2/B
+ sky130_fd_sc_hs__xor2_1_2/X VSS VDD sky130_fd_sc_hs__xor2_1
Xsky130_fd_sc_hs__mux2_1_3 VDD VSS sky130_fd_sc_hs__mux2_1_3/X sky130_fd_sc_hs__mux2_1_9/S
+ sky130_fd_sc_hs__mux2_1_3/A0 sky130_fd_sc_hs__mux2_1_7/A1 VSS VDD sky130_fd_sc_hs__mux2_1
Xsky130_fd_sc_hs__dfrtp_1_380 sky130_fd_sc_hs__buf_8_5/A VDD VSS sky130_fd_sc_hs__and3_1_8/A
+ sky130_fd_sc_hs__clkbuf_8_4/X sky130_fd_sc_hs__o21ai_1_34/Y VSS VDD sky130_fd_sc_hs__dfrtp_1
Xsky130_fd_sc_hs__dfrtp_1_391 sky130_fd_sc_hs__clkbuf_4_14/X VDD VSS sky130_fd_sc_hs__mux2_1_85/A0
+ sky130_fd_sc_hs__clkinv_1_61/A sky130_fd_sc_hs__a22o_1_37/X VSS VDD sky130_fd_sc_hs__dfrtp_1
Xsky130_fd_sc_hs__and3_1_4 VDD VSS sky130_fd_sc_hs__and3_1_4/A sky130_fd_sc_hs__and3_1_4/B
+ sky130_fd_sc_hs__nor3_1_6/Y sky130_fd_sc_hs__and3_1_4/X VSS VDD sky130_fd_sc_hs__and3_1
Xsky130_fd_sc_hs__o31ai_1_7 VDD VSS sky130_fd_sc_hs__o31ai_1_7/A3 sky130_fd_sc_hs__o31a_1_1/A2
+ sky130_fd_sc_hs__o31ai_1_7/B1 sky130_fd_sc_hs__o31a_1_1/A1 sky130_fd_sc_hs__o31ai_1_7/Y
+ VSS VDD sky130_fd_sc_hs__o31ai_1
Xsky130_fd_sc_hs__a21oi_1_4 VDD VSS sky130_fd_sc_hs__and2_1_0/A sky130_fd_sc_hs__nor3_1_4/A
+ sky130_fd_sc_hs__nor2_1_7/A sky130_fd_sc_hs__xor2_1_0/A VSS VDD sky130_fd_sc_hs__a21oi_1
Xsky130_fd_sc_hs__clkbuf_2_109 VDD VSS sky130_fd_sc_hs__clkbuf_2_109/X sky130_fd_sc_hs__dfrtp_2_1/CLK
+ VSS VDD sky130_fd_sc_hs__clkbuf_2
Xsky130_fd_sc_hs__nand2_1_109 VDD VSS sky130_fd_sc_hs__nor2_1_98/B sky130_fd_sc_hs__nor2_4_0/A
+ sky130_fd_sc_hs__nor2_1_98/A VSS VDD sky130_fd_sc_hs__nand2_1
Xsky130_fd_sc_hs__a222o_1_6 VDD VSS sky130_fd_sc_hs__buf_16_9/A sky130_fd_sc_hs__a222o_1_6/X
+ sky130_fd_sc_hs__a222o_1_6/C1 sky130_fd_sc_hs__a222o_1_6/B2 sky130_fd_sc_hs__a22o_1_8/B1
+ sky130_fd_sc_hs__xor2_1_90/A sky130_fd_sc_hs__nand2_1_51/B VSS VDD sky130_fd_sc_hs__a222o_1
Xsky130_fd_sc_hs__mux2_1_340 VDD VSS sky130_fd_sc_hs__mux2_1_340/X sky130_fd_sc_hs__mux2_1_1/S
+ sky130_fd_sc_hs__a22o_1_95/B2 sky130_fd_sc_hs__mux2_1_340/A1 VSS VDD sky130_fd_sc_hs__mux2_1
Xsky130_fd_sc_hs__mux2_1_351 VDD VSS sky130_fd_sc_hs__mux2_1_351/X sky130_fd_sc_hs__nor2_1_93/B
+ sky130_fd_sc_hs__mux2_1_351/A0 sky130_fd_sc_hs__a22o_1_67/B2 VSS VDD sky130_fd_sc_hs__mux2_1
Xsky130_fd_sc_hs__mux2_1_362 VDD VSS sky130_fd_sc_hs__mux2_1_362/X sky130_fd_sc_hs__buf_16_10/A
+ sky130_fd_sc_hs__mux2_1_362/A0 sky130_fd_sc_hs__dfrtp_2_3/Q VSS VDD sky130_fd_sc_hs__mux2_1
Xsky130_fd_sc_hs__mux2_1_373 VDD VSS sky130_fd_sc_hs__mux2_1_373/X sky130_fd_sc_hs__buf_16_1/X
+ sky130_fd_sc_hs__mux2_1_373/A0 sky130_fd_sc_hs__dfrtp_2_2/Q VSS VDD sky130_fd_sc_hs__mux2_1
Xsky130_fd_sc_hs__mux2_1_384 VDD VSS sky130_fd_sc_hs__mux2_1_384/X sky130_fd_sc_hs__buf_16_3/X
+ sky130_fd_sc_hs__dfrtp_2_2/Q sky130_fd_sc_hs__mux2_1_384/A1 VSS VDD sky130_fd_sc_hs__mux2_1
Xsky130_fd_sc_hs__mux2_1_395 VDD VSS sky130_fd_sc_hs__mux2_1_395/X sky130_fd_sc_hs__buf_16_6/A
+ sky130_fd_sc_hs__mux2_1_395/A0 sky130_fd_sc_hs__a22o_1_89/B2 VSS VDD sky130_fd_sc_hs__mux2_1
Xsky130_fd_sc_hs__xor2_1_40 VDD VSS sky130_fd_sc_hs__xor2_1_40/A sky130_fd_sc_hs__xor2_1_40/B
+ sky130_fd_sc_hs__or2_1_11/A VSS VDD sky130_fd_sc_hs__xor2_1
Xsky130_fd_sc_hs__xor2_1_51 VDD VSS sky130_fd_sc_hs__xor2_1_51/A sky130_fd_sc_hs__xor2_1_51/B
+ sky130_fd_sc_hs__xor2_1_51/X VSS VDD sky130_fd_sc_hs__xor2_1
Xsky130_fd_sc_hs__xor2_1_62 VDD VSS sky130_fd_sc_hs__xor2_1_62/A sky130_fd_sc_hs__xor2_1_62/B
+ sky130_fd_sc_hs__xor2_1_62/X VSS VDD sky130_fd_sc_hs__xor2_1
Xsky130_fd_sc_hs__xor2_1_73 VDD VSS sky130_fd_sc_hs__xor2_1_73/A sky130_fd_sc_hs__xor2_1_73/B
+ sky130_fd_sc_hs__xor2_1_73/X VSS VDD sky130_fd_sc_hs__xor2_1
Xsky130_fd_sc_hs__xor2_1_84 VDD VSS sky130_fd_sc_hs__xor2_1_85/A sky130_fd_sc_hs__xor2_1_84/B
+ sky130_fd_sc_hs__xor2_1_84/X VSS VDD sky130_fd_sc_hs__xor2_1
Xsky130_fd_sc_hs__nand2b_1_20 VDD VSS sky130_fd_sc_hs__maj3_1_18/X sky130_fd_sc_hs__xnor2_1_57/Y
+ sky130_fd_sc_hs__a31o_1_3/A3 VSS VDD sky130_fd_sc_hs__nand2b_1
Xsky130_fd_sc_hs__nand2b_1_31 VDD VSS sky130_fd_sc_hs__maj3_1_21/X sky130_fd_sc_hs__xnor2_1_59/Y
+ sky130_fd_sc_hs__o21ai_1_39/B1 VSS VDD sky130_fd_sc_hs__nand2b_1
Xsky130_fd_sc_hs__nand2b_1_42 VDD VSS sky130_fd_sc_hs__nor3_1_26/A sky130_fd_sc_hs__nor3_1_26/B
+ sky130_fd_sc_hs__nor2_4_0/B VSS VDD sky130_fd_sc_hs__nand2b_1
Xsky130_fd_sc_hs__nand2b_1_53 VDD VSS sky130_fd_sc_hs__xnor2_1_90/Y sky130_fd_sc_hs__maj3_1_39/X
+ sky130_fd_sc_hs__a31o_1_12/A2 VSS VDD sky130_fd_sc_hs__nand2b_1
Xsky130_fd_sc_hs__nand2b_1_64 VDD VSS sky130_fd_sc_hs__or3b_1_1/A sky130_fd_sc_hs__or3b_1_1/B
+ sky130_fd_sc_hs__nor3_4_9/C VSS VDD sky130_fd_sc_hs__nand2b_1
Xsky130_fd_sc_hs__nand2b_1_0 VDD VSS sky130_fd_sc_hs__o21a_1_6/A2 sky130_fd_sc_hs__o21a_1_6/B1
+ sky130_fd_sc_hs__xnor2_1_30/B VSS VDD sky130_fd_sc_hs__nand2b_1
Xsky130_fd_sc_hs__o311ai_1_9 VDD VSS sky130_fd_sc_hs__o31a_1_1/A2 sky130_fd_sc_hs__o31a_1_1/A1
+ sky130_fd_sc_hs__xnor2_1_53/Y sky130_fd_sc_hs__o31ai_1_7/B1 sky130_fd_sc_hs__a32o_1_5/A3
+ sky130_fd_sc_hs__o31ai_1_7/A3 VSS VDD sky130_fd_sc_hs__o311ai_1
Xsky130_fd_sc_hs__a32o_1_0 VDD VSS sky130_fd_sc_hs__a32o_1_0/X sky130_fd_sc_hs__buf_1_13/A
+ sky130_fd_sc_hs__nand2_1_9/B sky130_fd_sc_hs__nor2_1_6/Y sky130_fd_sc_hs__nor3_1_4/A
+ sky130_fd_sc_hs__a32o_1_0/A3 VSS VDD sky130_fd_sc_hs__a32o_1
Xsky130_fd_sc_hs__mux2_1_19 VDD VSS sky130_fd_sc_hs__mux2_1_19/X sky130_fd_sc_hs__buf_16_3/X
+ sky130_fd_sc_hs__mux2_1_7/A1 sky130_fd_sc_hs__mux2_1_19/A1 VSS VDD sky130_fd_sc_hs__mux2_1
Xsky130_fd_sc_hs__mux2_1_170 VDD VSS sky130_fd_sc_hs__mux2_1_170/X sky130_fd_sc_hs__mux2_1_8/S
+ sky130_fd_sc_hs__mux2_1_170/A0 sky130_fd_sc_hs__a22o_1_60/B2 VSS VDD sky130_fd_sc_hs__mux2_1
Xsky130_fd_sc_hs__mux2_1_181 VDD VSS sky130_fd_sc_hs__mux2_1_181/X sky130_fd_sc_hs__buf_16_5/X
+ sky130_fd_sc_hs__a222o_1_1/B2 sky130_fd_sc_hs__mux2_1_40/A0 VSS VDD sky130_fd_sc_hs__mux2_1
Xsky130_fd_sc_hs__mux2_1_192 VDD VSS sky130_fd_sc_hs__mux2_1_192/X sky130_fd_sc_hs__buf_16_1/X
+ sky130_fd_sc_hs__mux2_1_192/A0 sky130_fd_sc_hs__mux2_1_61/A0 VSS VDD sky130_fd_sc_hs__mux2_1
Xsky130_fd_sc_hs__and3_1_11 VDD VSS sky130_fd_sc_hs__and3_1_11/A sky130_fd_sc_hs__and3_1_11/B
+ sky130_fd_sc_hs__and3_1_11/C sky130_fd_sc_hs__nor2b_1_8/A VSS VDD sky130_fd_sc_hs__and3_1
Xsky130_fd_sc_hs__buf_1_140 VDD VSS sky130_fd_sc_hs__buf_1_140/A calib_overrange_bits[11]
+ VSS VDD sky130_fd_sc_hs__buf_1
Xsky130_fd_sc_hs__buf_1_151 VDD VSS sky130_fd_sc_hs__buf_1_151/A calib_overrange_bits[8]
+ VSS VDD sky130_fd_sc_hs__buf_1
Xsky130_fd_sc_hs__buf_1_162 VDD VSS sky130_fd_sc_hs__buf_1_162/A calib_overrange VSS
+ VDD sky130_fd_sc_hs__buf_1
Xsky130_fd_sc_hs__buf_1_173 VDD VSS sky130_fd_sc_hs__buf_1_173/A dac_p_force[11] VSS
+ VDD sky130_fd_sc_hs__buf_1
Xsky130_fd_sc_hs__buf_1_184 VDD VSS sky130_fd_sc_hs__buf_1_184/A raw_code_o[14] VSS
+ VDD sky130_fd_sc_hs__buf_1
Xsky130_fd_sc_hs__nor2_2_11 VDD VSS sky130_fd_sc_hs__or3b_1_0/X sky130_fd_sc_hs__nor2_2_11/Y
+ sky130_fd_sc_hs__nor3_4_9/C VSS VDD sky130_fd_sc_hs__nor2_2
Xsky130_fd_sc_hs__o41ai_1_1 VDD VSS sky130_fd_sc_hs__or2_1_22/A sky130_fd_sc_hs__or3_1_4/B
+ sky130_fd_sc_hs__o41ai_1_1/B1 sky130_fd_sc_hs__o41ai_1_1/Y sky130_fd_sc_hs__nor3_1_36/Y
+ sky130_fd_sc_hs__or3_1_4/A VSS VDD sky130_fd_sc_hs__o41ai_1
Xsky130_fd_sc_hs__nand4_1_13 VDD VSS sky130_fd_sc_hs__nand4_1_13/C sky130_fd_sc_hs__nor3_1_51/A
+ sky130_fd_sc_hs__nand4b_1_3/Y sky130_fd_sc_hs__nand4_1_13/B sky130_fd_sc_hs__nand4_1_13/A
+ VSS VDD sky130_fd_sc_hs__nand4_1
Xsky130_fd_sc_hs__o211ai_1_0 VDD VSS sky130_fd_sc_hs__nor3_1_2/A sky130_fd_sc_hs__a32o_1_0/A3
+ sky130_fd_sc_hs__xnor2_1_5/A sky130_fd_sc_hs__and2_1_0/A sky130_fd_sc_hs__nor2_1_7/A
+ VSS VDD sky130_fd_sc_hs__o211ai_1
Xsky130_fd_sc_hs__o2111ai_1_0 VDD VSS sky130_fd_sc_hs__nand2_1_5/B sky130_fd_sc_hs__xor2_1_0/A
+ sky130_fd_sc_hs__xnor2_1_5/A sky130_fd_sc_hs__nor3_1_2/A sky130_fd_sc_hs__nand2_1_3/A
+ sky130_fd_sc_hs__nor2_1_7/A VSS VDD sky130_fd_sc_hs__o2111ai_1
Xsky130_fd_sc_hs__or2_1_18 VDD VSS sky130_fd_sc_hs__or2_1_18/B sky130_fd_sc_hs__or2_1_18/A
+ sky130_fd_sc_hs__or2_1_18/X VSS VDD sky130_fd_sc_hs__or2_1
Xsky130_fd_sc_hs__or2_1_29 VDD VSS sky130_fd_sc_hs__or3b_1_0/A sky130_fd_sc_hs__or2_1_29/A
+ sky130_fd_sc_hs__or2_1_29/X VSS VDD sky130_fd_sc_hs__or2_1
Xsky130_fd_sc_hs__dfrtp_1_209 sky130_fd_sc_hs__clkbuf_4_0/X VDD VSS sky130_fd_sc_hs__mux2_1_44/A1
+ sky130_fd_sc_hs__clkbuf_2_14/X sky130_fd_sc_hs__mux2_1_44/X VSS VDD sky130_fd_sc_hs__dfrtp_1
Xsky130_fd_sc_hs__o2bb2ai_1_40 VDD VSS sky130_fd_sc_hs__dfrtp_1_514/D sky130_fd_sc_hs__mux2i_1_14/Y
+ sky130_fd_sc_hs__mux2i_1_14/A0 sky130_fd_sc_hs__nand2b_1_51/Y sky130_fd_sc_hs__or2_1_23/X
+ VSS VDD sky130_fd_sc_hs__o2bb2ai_1
Xsky130_fd_sc_hs__o2bb2ai_1_51 VDD VSS sky130_fd_sc_hs__buf_1_95/A sky130_fd_sc_hs__nand2_1_153/Y
+ sky130_fd_sc_hs__o22a_1_0/A1 sky130_fd_sc_hs__nand4_1_5/D sky130_fd_sc_hs__buf_8_20/X
+ VSS VDD sky130_fd_sc_hs__o2bb2ai_1
Xsky130_fd_sc_hs__o2bb2ai_1_62 VDD VSS sky130_fd_sc_hs__buf_1_100/A sky130_fd_sc_hs__nand2_1_167/Y
+ sky130_fd_sc_hs__mux2i_1_4/A1 sky130_fd_sc_hs__nand4_1_5/D sky130_fd_sc_hs__buf_8_20/X
+ VSS VDD sky130_fd_sc_hs__o2bb2ai_1
Xsky130_fd_sc_hs__o2bb2ai_1_73 VDD VSS sky130_fd_sc_hs__o2bb2ai_1_73/Y sky130_fd_sc_hs__xnor2_1_146/Y
+ sky130_fd_sc_hs__nor2_1_183/A sky130_fd_sc_hs__a31o_1_14/B1 sky130_fd_sc_hs__nor2_4_2/Y
+ VSS VDD sky130_fd_sc_hs__o2bb2ai_1
Xsky130_fd_sc_hs__clkinv_1_19 VDD VSS sky130_fd_sc_hs__clkinv_1_19/A sky130_fd_sc_hs__clkinv_1_19/Y
+ VSS VDD sky130_fd_sc_hs__clkinv_1
Xsky130_fd_sc_hs__a31oi_1_12 VDD VSS sky130_fd_sc_hs__a31oi_1_12/Y sky130_fd_sc_hs__nand4_1_7/D
+ sky130_fd_sc_hs__a31oi_1_12/B1 sky130_fd_sc_hs__nor2b_1_40/Y sky130_fd_sc_hs__or2_1_22/B
+ VSS VDD sky130_fd_sc_hs__a31oi_1
Xsky130_fd_sc_hs__dfrtp_1_710 sky130_fd_sc_hs__buf_8_29/X VDD VSS sky130_fd_sc_hs__mux2_1_403/A1
+ sky130_fd_sc_hs__clkbuf_2_219/X sky130_fd_sc_hs__mux2_1_403/X VSS VDD sky130_fd_sc_hs__dfrtp_1
Xsky130_fd_sc_hs__dfrtp_1_721 sky130_fd_sc_hs__clkbuf_4_50/X VDD VSS sky130_fd_sc_hs__xor2_1_89/B
+ sky130_fd_sc_hs__clkbuf_2_235/X sky130_fd_sc_hs__mux2_1_432/X VSS VDD sky130_fd_sc_hs__dfrtp_1
Xsky130_fd_sc_hs__dfrtp_1_732 sky130_fd_sc_hs__buf_8_34/X VDD VSS sky130_fd_sc_hs__mux2_1_441/A0
+ sky130_fd_sc_hs__clkbuf_2_229/X sky130_fd_sc_hs__mux2_1_441/X VSS VDD sky130_fd_sc_hs__dfrtp_1
Xsky130_fd_sc_hs__dfrtp_1_743 sky130_fd_sc_hs__buf_8_35/A VDD VSS sky130_fd_sc_hs__mux2_1_448/A0
+ sky130_fd_sc_hs__clkbuf_2_233/X sky130_fd_sc_hs__mux2_1_448/X VSS VDD sky130_fd_sc_hs__dfrtp_1
Xsky130_fd_sc_hs__dfrtp_1_754 sky130_fd_sc_hs__clkbuf_4_50/X VDD VSS sky130_fd_sc_hs__mux2_1_442/A1
+ sky130_fd_sc_hs__clkbuf_2_233/X sky130_fd_sc_hs__mux2_1_442/X VSS VDD sky130_fd_sc_hs__dfrtp_1
Xsky130_fd_sc_hs__dfrtp_1_765 sky130_fd_sc_hs__clkbuf_4_33/X VDD VSS sky130_fd_sc_hs__xor2_1_86/B
+ sky130_fd_sc_hs__clkinv_1_158/A sky130_fd_sc_hs__mux2_1_393/X VSS VDD sky130_fd_sc_hs__dfrtp_1
Xsky130_fd_sc_hs__dfrtp_1_776 sky130_fd_sc_hs__buf_8_25/A VDD VSS sky130_fd_sc_hs__xor2_1_91/A
+ sky130_fd_sc_hs__clkbuf_2_222/X sky130_fd_sc_hs__mux2_1_420/X VSS VDD sky130_fd_sc_hs__dfrtp_1
Xsky130_fd_sc_hs__dfrtp_1_787 sky130_fd_sc_hs__buf_8_9/X VDD VSS sky130_fd_sc_hs__mux2_1_481/A0
+ sky130_fd_sc_hs__dfrtp_2_1/CLK sky130_fd_sc_hs__mux2_1_481/X VSS VDD sky130_fd_sc_hs__dfrtp_1
Xsky130_fd_sc_hs__dfrtp_1_798 sky130_fd_sc_hs__buf_8_9/X VDD VSS sky130_fd_sc_hs__mux2_1_224/A0
+ sky130_fd_sc_hs__clkinv_2_7/A sky130_fd_sc_hs__mux2_1_224/X VSS VDD sky130_fd_sc_hs__dfrtp_1
Xsky130_fd_sc_hs__nor3_1_6 VDD VSS sky130_fd_sc_hs__nor3_1_6/Y sky130_fd_sc_hs__nor3_1_6/C
+ sky130_fd_sc_hs__nor3_1_6/B sky130_fd_sc_hs__nor3_1_6/A VSS VDD sky130_fd_sc_hs__nor3_1
Xsky130_fd_sc_hs__xnor2_1_14 VDD VSS sky130_fd_sc_hs__xnor2_1_14/A sky130_fd_sc_hs__xnor2_1_14/Y
+ sky130_fd_sc_hs__nor2_1_16/Y VSS VDD sky130_fd_sc_hs__xnor2_1
Xsky130_fd_sc_hs__xnor2_1_25 VDD VSS sky130_fd_sc_hs__xnor2_1_25/A sky130_fd_sc_hs__xnor2_1_25/Y
+ sky130_fd_sc_hs__nor2b_1_4/Y VSS VDD sky130_fd_sc_hs__xnor2_1
Xsky130_fd_sc_hs__xnor2_1_36 VDD VSS sky130_fd_sc_hs__xnor2_1_36/A sky130_fd_sc_hs__xnor2_1_36/Y
+ sky130_fd_sc_hs__xnor2_1_36/B VSS VDD sky130_fd_sc_hs__xnor2_1
Xsky130_fd_sc_hs__xnor2_1_47 VDD VSS sky130_fd_sc_hs__and3_1_8/A sky130_fd_sc_hs__xnor2_1_47/Y
+ sky130_fd_sc_hs__and3_1_8/B VSS VDD sky130_fd_sc_hs__xnor2_1
Xsky130_fd_sc_hs__xnor2_1_58 VDD VSS sky130_fd_sc_hs__maj3_1_13/C sky130_fd_sc_hs__xor2_1_28/B
+ sky130_fd_sc_hs__xor2_1_32/X VSS VDD sky130_fd_sc_hs__xnor2_1
Xsky130_fd_sc_hs__xnor2_1_69 VDD VSS sky130_fd_sc_hs__and2_1_6/A sky130_fd_sc_hs__nor3_1_20/B
+ sky130_fd_sc_hs__xor2_1_35/A VSS VDD sky130_fd_sc_hs__xnor2_1
Xsky130_fd_sc_hs__a211oi_1_5 VDD VSS sky130_fd_sc_hs__nor2b_1_33/Y sky130_fd_sc_hs__a211oi_1_5/Y
+ sky130_fd_sc_hs__nor2b_1_31/Y sky130_fd_sc_hs__nor2_1_129/A sky130_fd_sc_hs__o22a_1_0/A1
+ VSS VDD sky130_fd_sc_hs__a211oi_1
Xsky130_fd_sc_hs__a22oi_1_6 VDD VSS sky130_fd_sc_hs__maj3_1_0/C sky130_fd_sc_hs__and4_1_0/A
+ sky130_fd_sc_hs__a22oi_1_6/B1 sky130_fd_sc_hs__a22oi_1_6/A2 sky130_fd_sc_hs__mux2_1_16/A1
+ VSS VDD sky130_fd_sc_hs__a22oi_1
Xsky130_fd_sc_hs__dfrtp_1_540 sky130_fd_sc_hs__clkbuf_4_5/X VDD VSS sky130_fd_sc_hs__mux2_1_258/A1
+ sky130_fd_sc_hs__clkinv_1_112/A sky130_fd_sc_hs__mux2_1_258/X VSS VDD sky130_fd_sc_hs__dfrtp_1
Xsky130_fd_sc_hs__dfrtp_1_551 sky130_fd_sc_hs__clkbuf_4_28/X VDD VSS sky130_fd_sc_hs__mux2_1_262/A0
+ sky130_fd_sc_hs__clkinv_1_114/A sky130_fd_sc_hs__mux2_1_262/X VSS VDD sky130_fd_sc_hs__dfrtp_1
Xsky130_fd_sc_hs__dfrtp_1_562 sky130_fd_sc_hs__buf_8_25/A VDD VSS sky130_fd_sc_hs__mux2_1_463/A0
+ sky130_fd_sc_hs__clkinv_2_10/A sky130_fd_sc_hs__mux2_1_463/X VSS VDD sky130_fd_sc_hs__dfrtp_1
Xsky130_fd_sc_hs__dfrtp_1_573 sky130_fd_sc_hs__clkbuf_4_24/X VDD VSS sky130_fd_sc_hs__buf_1_164/A
+ sky130_fd_sc_hs__dfstp_1_2/CLK sky130_fd_sc_hs__mux2_1_291/X VSS VDD sky130_fd_sc_hs__dfrtp_1
Xsky130_fd_sc_hs__dfrtp_1_584 sky130_fd_sc_hs__buf_8_29/A VDD VSS sky130_fd_sc_hs__nor3_4_2/A
+ sky130_fd_sc_hs__dfstp_1_2/CLK sky130_fd_sc_hs__a22o_1_116/X VSS VDD sky130_fd_sc_hs__dfrtp_1
Xsky130_fd_sc_hs__dfrtp_1_595 sky130_fd_sc_hs__buf_8_1/A VDD VSS sky130_fd_sc_hs__mux2_1_295/A0
+ sky130_fd_sc_hs__clkinv_1_129/A sky130_fd_sc_hs__mux2_1_295/X VSS VDD sky130_fd_sc_hs__dfrtp_1
Xsky130_fd_sc_hs__a21oi_1_80 VDD VSS sky130_fd_sc_hs__buf_8_12/X sky130_fd_sc_hs__a22o_1_49/B2
+ sky130_fd_sc_hs__a31o_1_6/X sky130_fd_sc_hs__xor2_1_37/X VSS VDD sky130_fd_sc_hs__a21oi_1
Xsky130_fd_sc_hs__a21oi_1_91 VDD VSS sky130_fd_sc_hs__o21ai_1_44/Y sky130_fd_sc_hs__a21oi_1_91/Y
+ sky130_fd_sc_hs__xor2_1_92/X sky130_fd_sc_hs__buf_8_10/A VSS VDD sky130_fd_sc_hs__a21oi_1
Xsky130_fd_sc_hs__a222oi_1_0 VDD VSS sky130_fd_sc_hs__a22o_1_9/A2 sky130_fd_sc_hs__mux2_1_40/A1
+ sky130_fd_sc_hs__nand2_1_33/B sky130_fd_sc_hs__a22oi_1_6/A2 sky130_fd_sc_hs__mux2_1_29/A1
+ sky130_fd_sc_hs__nand3_1_4/A sky130_fd_sc_hs__mux2_1_27/A0 VSS VDD sky130_fd_sc_hs__a222oi_1
Xsky130_fd_sc_hs__xor2_1_3 VDD VSS sky130_fd_sc_hs__xor2_1_3/A sky130_fd_sc_hs__xor2_1_3/B
+ sky130_fd_sc_hs__xor2_1_3/X VSS VDD sky130_fd_sc_hs__xor2_1
Xsky130_fd_sc_hs__mux2_1_4 VDD VSS sky130_fd_sc_hs__mux2_1_4/X sky130_fd_sc_hs__mux2_1_4/S
+ sky130_fd_sc_hs__mux2_1_7/A1 sky130_fd_sc_hs__mux2_1_4/A1 VSS VDD sky130_fd_sc_hs__mux2_1
Xsky130_fd_sc_hs__dfrtp_1_370 sky130_fd_sc_hs__clkbuf_4_56/X VDD VSS sky130_fd_sc_hs__xor2_1_42/B
+ sky130_fd_sc_hs__clkinv_1_70/A sky130_fd_sc_hs__mux2_1_218/X VSS VDD sky130_fd_sc_hs__dfrtp_1
Xsky130_fd_sc_hs__dfrtp_1_381 sky130_fd_sc_hs__buf_8_5/A VDD VSS sky130_fd_sc_hs__and3_1_8/C
+ sky130_fd_sc_hs__clkbuf_8_4/X sky130_fd_sc_hs__o31ai_1_6/Y VSS VDD sky130_fd_sc_hs__dfrtp_1
Xsky130_fd_sc_hs__dfrtp_1_392 sky130_fd_sc_hs__buf_8_6/X VDD VSS sky130_fd_sc_hs__maj3_1_22/C
+ sky130_fd_sc_hs__clkinv_2_4/A sky130_fd_sc_hs__dfrtp_1_392/D VSS VDD sky130_fd_sc_hs__dfrtp_1
Xsky130_fd_sc_hs__dlygate4sd3_1_0 VSS VDD residue_consume_i sky130_fd_sc_hs__buf_1_63/A
+ VSS VDD sky130_fd_sc_hs__dlygate4sd3_1
Xsky130_fd_sc_hs__and3_1_5 VDD VSS sky130_fd_sc_hs__and3_1_5/A sky130_fd_sc_hs__and3_1_5/B
+ sky130_fd_sc_hs__and3_1_5/C sky130_fd_sc_hs__and3_1_5/X VSS VDD sky130_fd_sc_hs__and3_1
Xsky130_fd_sc_hs__o31ai_1_8 VDD VSS sky130_fd_sc_hs__o31ai_1_8/A3 sky130_fd_sc_hs__xor2_1_92/A
+ sky130_fd_sc_hs__o31ai_1_8/B1 sky130_fd_sc_hs__nor2_1_74/B sky130_fd_sc_hs__xor2_1_49/A
+ VSS VDD sky130_fd_sc_hs__o31ai_1
Xsky130_fd_sc_hs__a21oi_1_5 VDD VSS sky130_fd_sc_hs__a21oi_1_2/Y sky130_fd_sc_hs__a21oi_1_5/Y
+ sky130_fd_sc_hs__o31ai_1_0/Y sky130_fd_sc_hs__nor3_1_4/A VSS VDD sky130_fd_sc_hs__a21oi_1
Xsky130_fd_sc_hs__a222o_1_7 VDD VSS sky130_fd_sc_hs__a222o_1_7/C2 sky130_fd_sc_hs__a222o_1_7/X
+ sky130_fd_sc_hs__buf_16_8/X sky130_fd_sc_hs__xor2_1_91/A sky130_fd_sc_hs__a222o_1_7/A2
+ sky130_fd_sc_hs__a222o_1_7/A1 sky130_fd_sc_hs__a222o_1_7/B1 VSS VDD sky130_fd_sc_hs__a222o_1
Xsky130_fd_sc_hs__mux2_1_330 VDD VSS sky130_fd_sc_hs__mux2_1_330/X sky130_fd_sc_hs__mux2_1_7/S
+ sky130_fd_sc_hs__mux2_1_330/A0 sky130_fd_sc_hs__dfrtp_2_1/Q VSS VDD sky130_fd_sc_hs__mux2_1
Xsky130_fd_sc_hs__mux2_1_341 VDD VSS sky130_fd_sc_hs__mux2_1_341/X sky130_fd_sc_hs__mux2_1_341/S
+ sky130_fd_sc_hs__a22o_1_95/B2 sky130_fd_sc_hs__mux2_1_341/A1 VSS VDD sky130_fd_sc_hs__mux2_1
Xsky130_fd_sc_hs__mux2_1_352 VDD VSS sky130_fd_sc_hs__mux2_1_352/X sky130_fd_sc_hs__buf_16_15/A
+ sky130_fd_sc_hs__a22o_1_95/B2 sky130_fd_sc_hs__mux2_1_352/A1 VSS VDD sky130_fd_sc_hs__mux2_1
Xsky130_fd_sc_hs__mux2_1_363 VDD VSS sky130_fd_sc_hs__mux2_1_363/X sky130_fd_sc_hs__mux2_1_7/S
+ sky130_fd_sc_hs__mux2_1_363/A0 sky130_fd_sc_hs__dfrtp_2_3/Q VSS VDD sky130_fd_sc_hs__mux2_1
Xsky130_fd_sc_hs__mux2_1_374 VDD VSS sky130_fd_sc_hs__mux2_1_374/X sky130_fd_sc_hs__buf_16_16/A
+ sky130_fd_sc_hs__a22o_1_89/B2 sky130_fd_sc_hs__nand3_1_41/A VSS VDD sky130_fd_sc_hs__mux2_1
Xsky130_fd_sc_hs__mux2_1_385 VDD VSS sky130_fd_sc_hs__mux2_1_385/X sky130_fd_sc_hs__buf_16_0/A
+ sky130_fd_sc_hs__xnor3_1_1/C sky130_fd_sc_hs__a22o_1_89/B2 VSS VDD sky130_fd_sc_hs__mux2_1
Xsky130_fd_sc_hs__mux2_1_396 VDD VSS sky130_fd_sc_hs__mux2_1_396/X sky130_fd_sc_hs__buf_16_10/A
+ sky130_fd_sc_hs__nand2_1_218/A sky130_fd_sc_hs__a22o_1_92/B2 VSS VDD sky130_fd_sc_hs__mux2_1
Xsky130_fd_sc_hs__xor2_1_30 VDD VSS sky130_fd_sc_hs__xor2_1_30/A sky130_fd_sc_hs__xor2_1_30/B
+ sky130_fd_sc_hs__xor2_1_30/X VSS VDD sky130_fd_sc_hs__xor2_1
Xsky130_fd_sc_hs__xor2_1_41 VDD VSS sky130_fd_sc_hs__xor2_1_41/A sky130_fd_sc_hs__xor2_1_41/B
+ sky130_fd_sc_hs__xor2_1_41/X VSS VDD sky130_fd_sc_hs__xor2_1
Xsky130_fd_sc_hs__xor2_1_52 VDD VSS sky130_fd_sc_hs__or2_1_15/B sky130_fd_sc_hs__xor2_1_52/B
+ sky130_fd_sc_hs__xor2_1_52/X VSS VDD sky130_fd_sc_hs__xor2_1
Xsky130_fd_sc_hs__xor2_1_63 VDD VSS sky130_fd_sc_hs__xor2_1_63/A sky130_fd_sc_hs__xor2_1_63/B
+ sky130_fd_sc_hs__xor2_1_63/X VSS VDD sky130_fd_sc_hs__xor2_1
Xsky130_fd_sc_hs__xor2_1_74 VDD VSS sky130_fd_sc_hs__xor2_1_74/A sky130_fd_sc_hs__xor2_1_74/B
+ sky130_fd_sc_hs__xor2_1_74/X VSS VDD sky130_fd_sc_hs__xor2_1
Xsky130_fd_sc_hs__xor2_1_85 VDD VSS sky130_fd_sc_hs__xor2_1_85/A sky130_fd_sc_hs__xor2_1_90/A
+ sky130_fd_sc_hs__xor2_1_85/X VSS VDD sky130_fd_sc_hs__xor2_1
Xsky130_fd_sc_hs__nand2b_1_10 VDD VSS sky130_fd_sc_hs__xor2_1_10/B sky130_fd_sc_hs__maj3_1_7/X
+ sky130_fd_sc_hs__o21a_1_8/B1 VSS VDD sky130_fd_sc_hs__nand2b_1
Xsky130_fd_sc_hs__nand2b_1_21 VDD VSS sky130_fd_sc_hs__xnor2_1_57/Y sky130_fd_sc_hs__maj3_1_18/X
+ sky130_fd_sc_hs__a31o_1_3/A2 VSS VDD sky130_fd_sc_hs__nand2b_1
Xsky130_fd_sc_hs__nand2b_1_32 VDD VSS sky130_fd_sc_hs__xnor2_1_65/Y sky130_fd_sc_hs__maj3_1_12/X
+ sky130_fd_sc_hs__a31o_1_6/A3 VSS VDD sky130_fd_sc_hs__nand2b_1
Xsky130_fd_sc_hs__nand2b_1_43 VDD VSS sky130_fd_sc_hs__xnor2_1_97/B sky130_fd_sc_hs__maj3_1_38/X
+ sky130_fd_sc_hs__and2_1_30/A VSS VDD sky130_fd_sc_hs__nand2b_1
Xsky130_fd_sc_hs__nand2b_1_54 VDD VSS sky130_fd_sc_hs__o41ai_1_3/A2 sky130_fd_sc_hs__nor3_1_46/Y
+ sky130_fd_sc_hs__o21ai_1_79/A1 VSS VDD sky130_fd_sc_hs__nand2b_1
Xsky130_fd_sc_hs__nand2b_1_65 VDD VSS sky130_fd_sc_hs__xor2_1_48/B sky130_fd_sc_hs__xor2_1_48/A
+ sky130_fd_sc_hs__o31ai_1_8/B1 VSS VDD sky130_fd_sc_hs__nand2b_1
Xsky130_fd_sc_hs__nand2b_1_1 VDD VSS sky130_fd_sc_hs__nor3_1_3/B sky130_fd_sc_hs__nor3_1_3/C
+ sky130_fd_sc_hs__nand2_1_7/A VSS VDD sky130_fd_sc_hs__nand2b_1
Xsky130_fd_sc_hs__a32oi_1_0 VDD VSS sky130_fd_sc_hs__a32oi_1_0/A3 sky130_fd_sc_hs__nor2_1_177/A
+ sky130_fd_sc_hs__nand4_1_4/Y sky130_fd_sc_hs__or2_1_26/A sky130_fd_sc_hs__dfstp_1_4/D
+ sky130_fd_sc_hs__mux2_1_289/S VSS VDD sky130_fd_sc_hs__a32oi_1
Xsky130_fd_sc_hs__a32o_1_1 VDD VSS sky130_fd_sc_hs__a32o_1_1/X sky130_fd_sc_hs__buf_1_11/A
+ sky130_fd_sc_hs__nand2_1_9/B sky130_fd_sc_hs__o31a_1_0/X sky130_fd_sc_hs__nor2_1_6/Y
+ sky130_fd_sc_hs__a32o_1_1/A3 VSS VDD sky130_fd_sc_hs__a32o_1
Xsky130_fd_sc_hs__mux2_1_160 VDD VSS sky130_fd_sc_hs__mux2_1_160/X sky130_fd_sc_hs__buf_8_3/X
+ sky130_fd_sc_hs__buf_1_38/A sky130_fd_sc_hs__mux2_1_9/A1 VSS VDD sky130_fd_sc_hs__mux2_1
Xsky130_fd_sc_hs__mux2_1_171 VDD VSS sky130_fd_sc_hs__mux2_1_171/X sky130_fd_sc_hs__buf_16_2/X
+ sky130_fd_sc_hs__a22o_1_75/B2 sky130_fd_sc_hs__mux2_1_171/A1 VSS VDD sky130_fd_sc_hs__mux2_1
Xsky130_fd_sc_hs__mux2_1_182 VDD VSS sky130_fd_sc_hs__mux2_1_182/X sky130_fd_sc_hs__mux2_1_9/S
+ sky130_fd_sc_hs__dfrtp_1_63/Q sky130_fd_sc_hs__mux2_1_98/A1 VSS VDD sky130_fd_sc_hs__mux2_1
Xsky130_fd_sc_hs__mux2_1_193 VDD VSS sky130_fd_sc_hs__mux2_1_193/X sky130_fd_sc_hs__buf_16_1/X
+ sky130_fd_sc_hs__mux2_1_193/A0 sky130_fd_sc_hs__mux2_1_85/A0 VSS VDD sky130_fd_sc_hs__mux2_1
Xsky130_fd_sc_hs__and3_1_12 VDD VSS sky130_fd_sc_hs__and3_1_12/A sky130_fd_sc_hs__and3_1_12/B
+ sky130_fd_sc_hs__and3_1_12/C sky130_fd_sc_hs__or3_1_7/A VSS VDD sky130_fd_sc_hs__and3_1
Xsky130_fd_sc_hs__buf_1_130 VDD VSS sky130_fd_sc_hs__buf_1_130/A raw_code_o[18] VSS
+ VDD sky130_fd_sc_hs__buf_1
Xsky130_fd_sc_hs__buf_1_141 VDD VSS sky130_fd_sc_hs__buf_1_141/A raw_code_o[4] VSS
+ VDD sky130_fd_sc_hs__buf_1
Xsky130_fd_sc_hs__buf_1_152 VDD VSS sky130_fd_sc_hs__buf_1_152/A w_wr_data[1] VSS
+ VDD sky130_fd_sc_hs__buf_1
Xsky130_fd_sc_hs__buf_1_163 VDD VSS sky130_fd_sc_hs__buf_1_163/A w_wr_data[0] VSS
+ VDD sky130_fd_sc_hs__buf_1
Xsky130_fd_sc_hs__buf_1_174 VDD VSS sky130_fd_sc_hs__buf_1_174/A dac_p_force[6] VSS
+ VDD sky130_fd_sc_hs__buf_1
Xsky130_fd_sc_hs__buf_1_185 VDD VSS sky130_fd_sc_hs__buf_1_185/A sky130_fd_sc_hs__buf_1_185/X
+ VSS VDD sky130_fd_sc_hs__buf_1
Xsky130_fd_sc_hs__nor2_2_12 VDD VSS sky130_fd_sc_hs__or3b_1_0/X sky130_fd_sc_hs__buf_4_3/A
+ sky130_fd_sc_hs__nor3_4_7/C VSS VDD sky130_fd_sc_hs__nor2_2
Xsky130_fd_sc_hs__a21oi_1_200 VDD VSS sky130_fd_sc_hs__o21ai_1_106/Y sky130_fd_sc_hs__o21ai_1_93/A1
+ sky130_fd_sc_hs__xor2_1_88/X sky130_fd_sc_hs__maj3_1_63/C VSS VDD sky130_fd_sc_hs__a21oi_1
Xsky130_fd_sc_hs__o41ai_1_2 VDD VSS sky130_fd_sc_hs__or2_1_24/B sky130_fd_sc_hs__o41ai_1_3/A2
+ sky130_fd_sc_hs__o41ai_1_2/B1 sky130_fd_sc_hs__o41ai_1_2/Y sky130_fd_sc_hs__nor3_4_0/B
+ sky130_fd_sc_hs__or3_1_6/A VSS VDD sky130_fd_sc_hs__o41ai_1
Xsky130_fd_sc_hs__nand4_1_14 VDD VSS sky130_fd_sc_hs__nand4_1_14/C sky130_fd_sc_hs__nand4_1_14/Y
+ sky130_fd_sc_hs__nand4_1_14/D sky130_fd_sc_hs__nand4_1_14/B sky130_fd_sc_hs__nand4_1_14/A
+ VSS VDD sky130_fd_sc_hs__nand4_1
Xsky130_fd_sc_hs__o211ai_1_1 VDD VSS sky130_fd_sc_hs__nand2_1_7/Y sky130_fd_sc_hs__nand2_1_2/B
+ sky130_fd_sc_hs__nor2_1_6/Y sky130_fd_sc_hs__nand2_1_7/A sky130_fd_sc_hs__nor3_1_4/A
+ VSS VDD sky130_fd_sc_hs__o211ai_1
Xsky130_fd_sc_hs__o2111ai_1_1 VDD VSS sky130_fd_sc_hs__o2111ai_1_1/Y sky130_fd_sc_hs__nor2_1_93/Y
+ sky130_fd_sc_hs__nand2_2_2/B sky130_fd_sc_hs__nand4b_1_0/D sky130_fd_sc_hs__nor2_1_131/B
+ sky130_fd_sc_hs__and2_1_34/A VSS VDD sky130_fd_sc_hs__o2111ai_1
Xsky130_fd_sc_hs__a22o_1_0 VDD VSS sky130_fd_sc_hs__a22o_1_0/X sky130_fd_sc_hs__xnor2_1_4/Y
+ sky130_fd_sc_hs__nor2_1_6/Y sky130_fd_sc_hs__nand2_1_9/B sky130_fd_sc_hs__buf_1_1/A
+ VSS VDD sky130_fd_sc_hs__a22o_1
Xsky130_fd_sc_hs__or2_1_19 VDD VSS sky130_fd_sc_hs__or2_1_19/B sky130_fd_sc_hs__or2_1_19/A
+ sky130_fd_sc_hs__or2_1_19/X VSS VDD sky130_fd_sc_hs__or2_1
Xsky130_fd_sc_hs__o2bb2ai_1_30 VDD VSS sky130_fd_sc_hs__dfrtp_1_469/D sky130_fd_sc_hs__o21ai_1_57/Y
+ sky130_fd_sc_hs__xor3_1_0/C sky130_fd_sc_hs__and2_1_31/X sky130_fd_sc_hs__clkbuf_2_140/X
+ VSS VDD sky130_fd_sc_hs__o2bb2ai_1
Xsky130_fd_sc_hs__o2bb2ai_1_41 VDD VSS sky130_fd_sc_hs__dfrtp_1_511/D sky130_fd_sc_hs__mux2i_1_4/Y
+ sky130_fd_sc_hs__mux2i_1_4/A1 sky130_fd_sc_hs__nand2b_1_51/Y sky130_fd_sc_hs__or2_1_23/X
+ VSS VDD sky130_fd_sc_hs__o2bb2ai_1
Xsky130_fd_sc_hs__o2bb2ai_1_52 VDD VSS sky130_fd_sc_hs__buf_1_107/A sky130_fd_sc_hs__nand2_1_162/Y
+ sky130_fd_sc_hs__o32ai_1_0/A1 sky130_fd_sc_hs__nand4_1_5/D sky130_fd_sc_hs__nor2_2_2/Y
+ VSS VDD sky130_fd_sc_hs__o2bb2ai_1
Xsky130_fd_sc_hs__o2bb2ai_1_63 VDD VSS sky130_fd_sc_hs__buf_1_180/A sky130_fd_sc_hs__nand4_1_5/C
+ sky130_fd_sc_hs__o22ai_1_3/B2 sky130_fd_sc_hs__nand2_1_155/Y sky130_fd_sc_hs__nand2_1_125/Y
+ VSS VDD sky130_fd_sc_hs__o2bb2ai_1
Xsky130_fd_sc_hs__o2bb2ai_1_74 VDD VSS sky130_fd_sc_hs__buf_1_174/A sky130_fd_sc_hs__nand2_1_216/Y
+ sky130_fd_sc_hs__mux2i_1_9/A1 sky130_fd_sc_hs__nand4_1_5/D sky130_fd_sc_hs__buf_8_20/X
+ VSS VDD sky130_fd_sc_hs__o2bb2ai_1
Xsky130_fd_sc_hs__a31oi_1_13 VDD VSS sky130_fd_sc_hs__a31oi_1_13/Y sky130_fd_sc_hs__nand4_1_6/D
+ sky130_fd_sc_hs__a31oi_1_13/B1 sky130_fd_sc_hs__nor2b_1_39/Y sky130_fd_sc_hs__or2_1_22/B
+ VSS VDD sky130_fd_sc_hs__a31oi_1
Xsky130_fd_sc_hs__dfrtp_1_700 sky130_fd_sc_hs__clkbuf_4_51/X VDD VSS sky130_fd_sc_hs__mux2_1_457/A0
+ sky130_fd_sc_hs__clkbuf_2_218/X sky130_fd_sc_hs__mux2_1_457/X VSS VDD sky130_fd_sc_hs__dfrtp_1
Xsky130_fd_sc_hs__dfrtp_1_711 sky130_fd_sc_hs__clkbuf_4_51/X VDD VSS sky130_fd_sc_hs__mux2_1_414/A1
+ sky130_fd_sc_hs__clkbuf_2_215/X sky130_fd_sc_hs__mux2_1_414/X VSS VDD sky130_fd_sc_hs__dfrtp_1
Xsky130_fd_sc_hs__dfrtp_1_722 sky130_fd_sc_hs__clkbuf_4_50/X VDD VSS sky130_fd_sc_hs__mux2_1_428/A0
+ sky130_fd_sc_hs__clkbuf_2_225/X sky130_fd_sc_hs__mux2_1_428/X VSS VDD sky130_fd_sc_hs__dfrtp_1
Xsky130_fd_sc_hs__dfrtp_1_733 sky130_fd_sc_hs__clkbuf_4_50/X VDD VSS sky130_fd_sc_hs__mux2_1_440/A1
+ sky130_fd_sc_hs__clkbuf_2_229/X sky130_fd_sc_hs__mux2_1_440/X VSS VDD sky130_fd_sc_hs__dfrtp_1
Xsky130_fd_sc_hs__dfrtp_1_744 sky130_fd_sc_hs__clkbuf_4_51/X VDD VSS sky130_fd_sc_hs__nand2_1_228/A
+ sky130_fd_sc_hs__clkbuf_2_233/X sky130_fd_sc_hs__mux2_1_460/X VSS VDD sky130_fd_sc_hs__dfrtp_1
Xsky130_fd_sc_hs__dfrtp_1_755 sky130_fd_sc_hs__clkbuf_4_51/X VDD VSS sky130_fd_sc_hs__mux2_1_416/A1
+ sky130_fd_sc_hs__clkbuf_2_218/X sky130_fd_sc_hs__mux2_1_416/X VSS VDD sky130_fd_sc_hs__dfrtp_1
Xsky130_fd_sc_hs__dfrtp_1_766 sky130_fd_sc_hs__clkbuf_4_33/X VDD VSS sky130_fd_sc_hs__xnor3_1_1/B
+ sky130_fd_sc_hs__clkbuf_2_214/X sky130_fd_sc_hs__mux2_1_391/X VSS VDD sky130_fd_sc_hs__dfrtp_1
Xsky130_fd_sc_hs__dfrtp_1_777 sky130_fd_sc_hs__buf_8_25/A VDD VSS sky130_fd_sc_hs__xor2_1_91/B
+ sky130_fd_sc_hs__clkbuf_2_222/X sky130_fd_sc_hs__mux2_1_343/X VSS VDD sky130_fd_sc_hs__dfrtp_1
Xsky130_fd_sc_hs__dfrtp_1_788 sky130_fd_sc_hs__buf_2_0/A VDD VSS sky130_fd_sc_hs__buf_1_20/A
+ sky130_fd_sc_hs__clkinv_1_49/A sky130_fd_sc_hs__nand2_1_59/Y VSS VDD sky130_fd_sc_hs__dfrtp_1
Xsky130_fd_sc_hs__dfrtp_1_799 sky130_fd_sc_hs__clkbuf_4_23/A VDD VSS sky130_fd_sc_hs__a32oi_1_1/B2
+ sky130_fd_sc_hs__clkbuf_2_147/A sky130_fd_sc_hs__mux2_1_251/X VSS VDD sky130_fd_sc_hs__dfrtp_1
Xsky130_fd_sc_hs__nor3_1_7 VDD VSS sky130_fd_sc_hs__nor3_1_7/Y sky130_fd_sc_hs__nor3_1_7/C
+ sky130_fd_sc_hs__nor3_1_7/B sky130_fd_sc_hs__nor3_1_7/A VSS VDD sky130_fd_sc_hs__nor3_1
Xsky130_fd_sc_hs__xnor2_1_15 VDD VSS sky130_fd_sc_hs__xor2_1_2/X sky130_fd_sc_hs__xnor2_1_15/Y
+ sky130_fd_sc_hs__or2_1_6/X VSS VDD sky130_fd_sc_hs__xnor2_1
Xsky130_fd_sc_hs__xnor2_1_26 VDD VSS sky130_fd_sc_hs__and3_1_4/A sky130_fd_sc_hs__nor2b_1_3/A
+ sky130_fd_sc_hs__xnor2_1_26/B VSS VDD sky130_fd_sc_hs__xnor2_1
Xsky130_fd_sc_hs__xnor2_1_37 VDD VSS sky130_fd_sc_hs__o21a_1_8/X sky130_fd_sc_hs__xnor2_1_37/Y
+ sky130_fd_sc_hs__xor2_1_8/X VSS VDD sky130_fd_sc_hs__xnor2_1
Xsky130_fd_sc_hs__xnor2_1_48 VDD VSS sky130_fd_sc_hs__xnor2_1_48/A sky130_fd_sc_hs__xnor2_1_49/B
+ sky130_fd_sc_hs__xnor2_1_51/Y VSS VDD sky130_fd_sc_hs__xnor2_1
Xsky130_fd_sc_hs__xnor2_1_59 VDD VSS sky130_fd_sc_hs__maj3_1_19/C sky130_fd_sc_hs__xnor2_1_59/Y
+ sky130_fd_sc_hs__xor2_1_34/X VSS VDD sky130_fd_sc_hs__xnor2_1
Xsky130_fd_sc_hs__nand2_1_0 VDD VSS sky130_fd_sc_hs__nand2_1_0/B sky130_fd_sc_hs__nand2_1_0/Y
+ sky130_fd_sc_hs__nand2_1_0/A VSS VDD sky130_fd_sc_hs__nand2_1
Xsky130_fd_sc_hs__a211oi_1_6 VDD VSS sky130_fd_sc_hs__nand3_1_32/Y sky130_fd_sc_hs__and3_1_11/C
+ sky130_fd_sc_hs__a22o_1_140/X sky130_fd_sc_hs__a22oi_1_5/A2 sky130_fd_sc_hs__mux2_1_260/A0
+ VSS VDD sky130_fd_sc_hs__a211oi_1
Xsky130_fd_sc_hs__a22oi_1_7 VDD VSS sky130_fd_sc_hs__mux2_1_17/A0 sky130_fd_sc_hs__nand2_1_0/A
+ sky130_fd_sc_hs__a22oi_1_7/B1 sky130_fd_sc_hs__a22o_1_8/B1 sky130_fd_sc_hs__maj3_1_0/B
+ VSS VDD sky130_fd_sc_hs__a22oi_1
Xsky130_fd_sc_hs__clkbuf_16_20 VDD VSS sky130_fd_sc_hs__clkbuf_2_176/A sky130_fd_sc_hs__clkbuf_8_19/X
+ VSS VDD sky130_fd_sc_hs__clkbuf_16
Xsky130_fd_sc_hs__dfrtp_1_530 sky130_fd_sc_hs__clkbuf_16_5/X VDD VSS sky130_fd_sc_hs__buf_1_131/A
+ sky130_fd_sc_hs__clkinv_1_108/A sky130_fd_sc_hs__mux2_1_253/X VSS VDD sky130_fd_sc_hs__dfrtp_1
Xsky130_fd_sc_hs__dfrtp_1_541 sky130_fd_sc_hs__clkbuf_4_5/X VDD VSS sky130_fd_sc_hs__buf_1_146/A
+ sky130_fd_sc_hs__clkinv_1_116/A sky130_fd_sc_hs__mux2_1_255/X VSS VDD sky130_fd_sc_hs__dfrtp_1
Xsky130_fd_sc_hs__dfrtp_1_552 sky130_fd_sc_hs__buf_8_38/A VDD VSS sky130_fd_sc_hs__mux2_1_260/A0
+ sky130_fd_sc_hs__clkinv_1_112/A sky130_fd_sc_hs__mux2_1_260/X VSS VDD sky130_fd_sc_hs__dfrtp_1
Xsky130_fd_sc_hs__dfrtp_1_563 sky130_fd_sc_hs__buf_8_25/X VDD VSS sky130_fd_sc_hs__or2_1_30/B
+ sky130_fd_sc_hs__clkinv_1_121/A sky130_fd_sc_hs__dfrtp_1_563/D VSS VDD sky130_fd_sc_hs__dfrtp_1
Xsky130_fd_sc_hs__dfrtp_1_574 sky130_fd_sc_hs__clkbuf_4_24/X VDD VSS sky130_fd_sc_hs__buf_1_163/A
+ sky130_fd_sc_hs__clkinv_1_126/A sky130_fd_sc_hs__mux2_1_284/X VSS VDD sky130_fd_sc_hs__dfrtp_1
Xsky130_fd_sc_hs__dfrtp_1_585 sky130_fd_sc_hs__buf_8_25/X VDD VSS sky130_fd_sc_hs__nor3_1_48/A
+ sky130_fd_sc_hs__clkinv_1_125/A sky130_fd_sc_hs__a22o_1_114/X VSS VDD sky130_fd_sc_hs__dfrtp_1
Xsky130_fd_sc_hs__dfrtp_1_596 sky130_fd_sc_hs__clkbuf_4_30/X VDD VSS sky130_fd_sc_hs__mux2_1_299/A1
+ sky130_fd_sc_hs__clkbuf_2_179/X sky130_fd_sc_hs__mux2_1_299/X VSS VDD sky130_fd_sc_hs__dfrtp_1
Xsky130_fd_sc_hs__a21oi_1_70 VDD VSS sky130_fd_sc_hs__nor2_1_59/Y sky130_fd_sc_hs__a21oi_1_70/Y
+ sky130_fd_sc_hs__o21ai_1_15/Y sky130_fd_sc_hs__nor2_1_82/B VSS VDD sky130_fd_sc_hs__a21oi_1
Xsky130_fd_sc_hs__a21oi_1_81 VDD VSS sky130_fd_sc_hs__a31o_1_7/A1 sky130_fd_sc_hs__a21oi_1_81/Y
+ sky130_fd_sc_hs__a21o_1_3/X sky130_fd_sc_hs__a31o_1_7/A2 VSS VDD sky130_fd_sc_hs__a21oi_1
Xsky130_fd_sc_hs__a21oi_1_92 VDD VSS sky130_fd_sc_hs__o21ai_1_42/Y sky130_fd_sc_hs__a21oi_1_92/Y
+ sky130_fd_sc_hs__and2_1_20/X sky130_fd_sc_hs__nor2_1_71/Y VSS VDD sky130_fd_sc_hs__a21oi_1
Xsky130_fd_sc_hs__dfrtp_1_90 sky130_fd_sc_hs__clkbuf_4_0/X VDD VSS sky130_fd_sc_hs__mux2_1_83/A0
+ sky130_fd_sc_hs__clkbuf_2_24/X sky130_fd_sc_hs__mux2_1_83/X VSS VDD sky130_fd_sc_hs__dfrtp_1
Xsky130_fd_sc_hs__a222oi_1_1 VDD VSS sky130_fd_sc_hs__nand2_1_33/B sky130_fd_sc_hs__mux2_1_55/A0
+ sky130_fd_sc_hs__a22oi_1_6/B1 sky130_fd_sc_hs__a22oi_1_5/A2 sky130_fd_sc_hs__mux2_1_56/A0
+ sky130_fd_sc_hs__nand3_1_5/B sky130_fd_sc_hs__xor2_1_50/B VSS VDD sky130_fd_sc_hs__a222oi_1
Xsky130_fd_sc_hs__xor2_1_4 VDD VSS sky130_fd_sc_hs__or2_1_3/B sky130_fd_sc_hs__xor2_1_4/B
+ sky130_fd_sc_hs__xor2_1_4/X VSS VDD sky130_fd_sc_hs__xor2_1
Xsky130_fd_sc_hs__mux2_1_5 VDD VSS sky130_fd_sc_hs__mux2_1_5/X sky130_fd_sc_hs__mux2_1_5/S
+ sky130_fd_sc_hs__mux2_1_5/A0 sky130_fd_sc_hs__mux2_1_7/A1 VSS VDD sky130_fd_sc_hs__mux2_1
Xsky130_fd_sc_hs__dfrtp_1_360 sky130_fd_sc_hs__clkbuf_4_15/X VDD VSS sky130_fd_sc_hs__a22o_1_62/A1
+ sky130_fd_sc_hs__clkbuf_2_103/X sky130_fd_sc_hs__a22o_1_59/X VSS VDD sky130_fd_sc_hs__dfrtp_1
Xsky130_fd_sc_hs__dfrtp_1_371 sky130_fd_sc_hs__clkbuf_4_15/X VDD VSS sky130_fd_sc_hs__a22o_1_66/B2
+ sky130_fd_sc_hs__clkbuf_2_104/X sky130_fd_sc_hs__a22o_1_66/X VSS VDD sky130_fd_sc_hs__dfrtp_1
Xsky130_fd_sc_hs__dfrtp_1_382 sky130_fd_sc_hs__buf_8_5/A VDD VSS sky130_fd_sc_hs__and3_1_6/C
+ sky130_fd_sc_hs__clkbuf_8_2/X sky130_fd_sc_hs__a21o_1_5/X VSS VDD sky130_fd_sc_hs__dfrtp_1
Xsky130_fd_sc_hs__dfrtp_1_393 sky130_fd_sc_hs__buf_8_5/A VDD VSS sky130_fd_sc_hs__or2_1_9/A
+ sky130_fd_sc_hs__clkbuf_8_2/X sky130_fd_sc_hs__dfrtp_1_393/D VSS VDD sky130_fd_sc_hs__dfrtp_1
Xsky130_fd_sc_hs__dlygate4sd3_1_1 VSS VDD sky130_fd_sc_hs__o21ai_1_32/Y sky130_fd_sc_hs__nor2_1_46/B
+ VSS VDD sky130_fd_sc_hs__dlygate4sd3_1
Xsky130_fd_sc_hs__and3_1_6 VDD VSS sky130_fd_sc_hs__and3_1_6/A sky130_fd_sc_hs__and3_1_6/B
+ sky130_fd_sc_hs__and3_1_6/C sky130_fd_sc_hs__or2_1_9/B VSS VDD sky130_fd_sc_hs__and3_1
Xsky130_fd_sc_hs__o31ai_1_9 VDD VSS sky130_fd_sc_hs__or3_1_3/X sky130_fd_sc_hs__o31ai_1_9/A2
+ sky130_fd_sc_hs__o31ai_1_9/B1 sky130_fd_sc_hs__buf_8_19/X sky130_fd_sc_hs__o31ai_1_9/Y
+ VSS VDD sky130_fd_sc_hs__o31ai_1
Xsky130_fd_sc_hs__a21oi_1_6 VDD VSS sky130_fd_sc_hs__o21ai_1_1/Y sky130_fd_sc_hs__a21oi_1_6/Y
+ sky130_fd_sc_hs__o211ai_1_2/Y sky130_fd_sc_hs__o31a_1_0/B1 VSS VDD sky130_fd_sc_hs__a21oi_1
Xsky130_fd_sc_hs__mux2_1_320 VDD VSS sky130_fd_sc_hs__mux2_1_320/X sky130_fd_sc_hs__mux2_1_368/S
+ sky130_fd_sc_hs__mux2_1_320/A0 sky130_fd_sc_hs__a22o_1_67/B2 VSS VDD sky130_fd_sc_hs__mux2_1
Xsky130_fd_sc_hs__mux2_1_331 VDD VSS sky130_fd_sc_hs__mux2_1_331/X sky130_fd_sc_hs__mux2_1_397/S
+ sky130_fd_sc_hs__maj3_1_52/B sky130_fd_sc_hs__a22o_1_95/B2 VSS VDD sky130_fd_sc_hs__mux2_1
Xsky130_fd_sc_hs__mux2_1_342 VDD VSS sky130_fd_sc_hs__mux2_1_342/X sky130_fd_sc_hs__buf_16_15/A
+ sky130_fd_sc_hs__dfrtp_2_3/Q sky130_fd_sc_hs__mux2_1_342/A1 VSS VDD sky130_fd_sc_hs__mux2_1
Xsky130_fd_sc_hs__mux2_1_353 VDD VSS sky130_fd_sc_hs__mux2_1_353/X sky130_fd_sc_hs__buf_4_1/X
+ sky130_fd_sc_hs__a22o_1_61/B2 sky130_fd_sc_hs__mux2_1_353/A1 VSS VDD sky130_fd_sc_hs__mux2_1
Xsky130_fd_sc_hs__mux2_1_364 VDD VSS sky130_fd_sc_hs__mux2_1_364/X sky130_fd_sc_hs__buf_16_1/X
+ sky130_fd_sc_hs__mux2_1_364/A0 sky130_fd_sc_hs__dfrtp_2_3/Q VSS VDD sky130_fd_sc_hs__mux2_1
Xsky130_fd_sc_hs__mux2_1_375 VDD VSS sky130_fd_sc_hs__mux2_1_375/X sky130_fd_sc_hs__buf_16_4/A
+ sky130_fd_sc_hs__nand4_1_11/B sky130_fd_sc_hs__a22o_1_89/B2 VSS VDD sky130_fd_sc_hs__mux2_1
Xsky130_fd_sc_hs__mux2_1_386 VDD VSS sky130_fd_sc_hs__mux2_1_386/X sky130_fd_sc_hs__buf_16_14/A
+ sky130_fd_sc_hs__mux2_1_386/A0 sky130_fd_sc_hs__a22o_1_89/B2 VSS VDD sky130_fd_sc_hs__mux2_1
Xsky130_fd_sc_hs__mux2_1_397 VDD VSS sky130_fd_sc_hs__mux2_1_397/X sky130_fd_sc_hs__mux2_1_397/S
+ sky130_fd_sc_hs__xor2_1_83/A sky130_fd_sc_hs__dfrtp_2_3/Q VSS VDD sky130_fd_sc_hs__mux2_1
Xsky130_fd_sc_hs__xor2_1_20 VDD VSS sky130_fd_sc_hs__maj3_1_7/A sky130_fd_sc_hs__xor2_1_20/B
+ sky130_fd_sc_hs__xor2_1_20/X VSS VDD sky130_fd_sc_hs__xor2_1
Xsky130_fd_sc_hs__xor2_1_31 VDD VSS sky130_fd_sc_hs__xor2_1_31/A sky130_fd_sc_hs__xor2_1_31/B
+ sky130_fd_sc_hs__xor2_1_31/X VSS VDD sky130_fd_sc_hs__xor2_1
Xsky130_fd_sc_hs__xor2_1_42 VDD VSS sky130_fd_sc_hs__xor2_1_42/A sky130_fd_sc_hs__xor2_1_42/B
+ sky130_fd_sc_hs__xor2_1_42/X VSS VDD sky130_fd_sc_hs__xor2_1
Xsky130_fd_sc_hs__xor2_1_53 VDD VSS sky130_fd_sc_hs__xor2_1_53/A sky130_fd_sc_hs__xor2_1_56/A
+ sky130_fd_sc_hs__xor2_1_53/X VSS VDD sky130_fd_sc_hs__xor2_1
Xsky130_fd_sc_hs__xor2_1_64 VDD VSS sky130_fd_sc_hs__xor2_1_64/A sky130_fd_sc_hs__xor2_1_64/B
+ sky130_fd_sc_hs__xor2_1_64/X VSS VDD sky130_fd_sc_hs__xor2_1
Xsky130_fd_sc_hs__xor2_1_75 VDD VSS sky130_fd_sc_hs__xor2_1_75/A sky130_fd_sc_hs__xor2_1_75/B
+ sky130_fd_sc_hs__xor2_1_75/X VSS VDD sky130_fd_sc_hs__xor2_1
Xsky130_fd_sc_hs__xor2_1_86 VDD VSS sky130_fd_sc_hs__xor2_1_86/A sky130_fd_sc_hs__xor2_1_86/B
+ sky130_fd_sc_hs__xor2_1_86/X VSS VDD sky130_fd_sc_hs__xor2_1
Xsky130_fd_sc_hs__nand2b_1_11 VDD VSS sky130_fd_sc_hs__xor2_1_13/B sky130_fd_sc_hs__xor2_1_13/A
+ sky130_fd_sc_hs__o21a_1_13/B1 VSS VDD sky130_fd_sc_hs__nand2b_1
Xsky130_fd_sc_hs__nand2b_1_22 VDD VSS sky130_fd_sc_hs__xor2_1_31/B sky130_fd_sc_hs__xor2_1_31/A
+ sky130_fd_sc_hs__a31o_1_2/A1 VSS VDD sky130_fd_sc_hs__nand2b_1
Xsky130_fd_sc_hs__nand2b_1_33 VDD VSS sky130_fd_sc_hs__xnor2_1_80/Y sky130_fd_sc_hs__maj3_1_34/X
+ sky130_fd_sc_hs__o211ai_1_6/B1 VSS VDD sky130_fd_sc_hs__nand2b_1
Xsky130_fd_sc_hs__nand2b_1_44 VDD VSS sky130_fd_sc_hs__xnor2_1_99/B sky130_fd_sc_hs__maj3_1_50/X
+ sky130_fd_sc_hs__nand2b_1_44/Y VSS VDD sky130_fd_sc_hs__nand2b_1
Xsky130_fd_sc_hs__nand2b_1_55 VDD VSS sky130_fd_sc_hs__nor2b_1_45/A sky130_fd_sc_hs__nor3_4_2/A
+ sky130_fd_sc_hs__nor3_4_0/C VSS VDD sky130_fd_sc_hs__nand2b_1
Xsky130_fd_sc_hs__nand2b_1_66 VDD VSS sky130_fd_sc_hs__xor2_1_93/B sky130_fd_sc_hs__xor2_1_93/A
+ sky130_fd_sc_hs__nand2_1_73/A VSS VDD sky130_fd_sc_hs__nand2b_1
Xsky130_fd_sc_hs__nand2b_1_2 VDD VSS sky130_fd_sc_hs__nor3_1_2/A sky130_fd_sc_hs__nor3_1_2/C
+ sky130_fd_sc_hs__nand2b_1_2/Y VSS VDD sky130_fd_sc_hs__nand2b_1
Xsky130_fd_sc_hs__a221oi_1_0 VDD VSS sky130_fd_sc_hs__nand2_1_0/Y sky130_fd_sc_hs__nand3_1_2/B
+ sky130_fd_sc_hs__mux2_1_19/A1 sky130_fd_sc_hs__a22o_1_9/A2 sky130_fd_sc_hs__mux2_1_7/A0
+ sky130_fd_sc_hs__a222o_1_2/A2 VSS VDD sky130_fd_sc_hs__a221oi_1
Xsky130_fd_sc_hs__a21bo_1_0 VDD VSS sky130_fd_sc_hs__a21bo_1_0/X sky130_fd_sc_hs__xor2_1_86/A
+ sky130_fd_sc_hs__nand3b_1_6/B sky130_fd_sc_hs__nor3_1_54/Y VSS VDD sky130_fd_sc_hs__a21bo_1
Xsky130_fd_sc_hs__a32oi_1_1 VDD VSS sky130_fd_sc_hs__nand3_1_39/Y sky130_fd_sc_hs__a32oi_1_1/B2
+ sky130_fd_sc_hs__buf_8_31/X sky130_fd_sc_hs__nand4b_1_2/Y sky130_fd_sc_hs__a32oi_1_1/Y
+ sky130_fd_sc_hs__o31ai_1_22/Y VSS VDD sky130_fd_sc_hs__a32oi_1
Xsky130_fd_sc_hs__dfrtp_1_190 sky130_fd_sc_hs__clkbuf_4_3/A VDD VSS sky130_fd_sc_hs__xnor2_1_27/A
+ sky130_fd_sc_hs__clkinv_1_33/A sky130_fd_sc_hs__mux2_1_138/X VSS VDD sky130_fd_sc_hs__dfrtp_1
Xsky130_fd_sc_hs__a32o_1_2 VDD VSS sky130_fd_sc_hs__a32o_1_2/X sky130_fd_sc_hs__xor2_1_3/A
+ sky130_fd_sc_hs__a32o_1_2/B1 sky130_fd_sc_hs__a32o_1_2/A2 sky130_fd_sc_hs__buf_8_26/X
+ sky130_fd_sc_hs__or3_1_0/X VSS VDD sky130_fd_sc_hs__a32o_1
Xsky130_fd_sc_hs__mux2_1_150 VDD VSS sky130_fd_sc_hs__mux2_1_150/X sky130_fd_sc_hs__mux2_1_4/S
+ sky130_fd_sc_hs__a22o_1_40/B2 sky130_fd_sc_hs__mux2_1_150/A1 VSS VDD sky130_fd_sc_hs__mux2_1
Xsky130_fd_sc_hs__mux2_1_161 VDD VSS sky130_fd_sc_hs__mux2_1_161/X sky130_fd_sc_hs__buf_8_3/X
+ sky130_fd_sc_hs__buf_1_39/A sky130_fd_sc_hs__a22o_1_60/B2 VSS VDD sky130_fd_sc_hs__mux2_1
Xsky130_fd_sc_hs__mux2_1_172 VDD VSS sky130_fd_sc_hs__mux2_1_172/X sky130_fd_sc_hs__buf_8_3/X
+ sky130_fd_sc_hs__buf_1_30/A sky130_fd_sc_hs__a22o_1_62/B2 VSS VDD sky130_fd_sc_hs__mux2_1
Xsky130_fd_sc_hs__mux2_1_183 VDD VSS sky130_fd_sc_hs__mux2_1_183/X sky130_fd_sc_hs__mux2_1_5/S
+ sky130_fd_sc_hs__a22oi_1_2/B2 sky130_fd_sc_hs__mux2_1_9/A1 VSS VDD sky130_fd_sc_hs__mux2_1
Xsky130_fd_sc_hs__mux2_1_194 VDD VSS sky130_fd_sc_hs__mux2_1_194/X sky130_fd_sc_hs__mux2_1_94/S
+ sky130_fd_sc_hs__xor2_1_35/A sky130_fd_sc_hs__mux2_1_85/A0 VSS VDD sky130_fd_sc_hs__mux2_1
Xsky130_fd_sc_hs__buf_1_0 VDD VSS sky130_fd_sc_hs__buf_1_0/A srm_ones_count[0] VSS
+ VDD sky130_fd_sc_hs__buf_1
Xsky130_fd_sc_hs__and3_1_13 VDD VSS sky130_fd_sc_hs__and3_1_13/A sky130_fd_sc_hs__and3_1_13/B
+ sky130_fd_sc_hs__nor3_1_49/Y sky130_fd_sc_hs__or3_1_8/A VSS VDD sky130_fd_sc_hs__and3_1
Xsky130_fd_sc_hs__buf_1_120 VDD VSS sky130_fd_sc_hs__buf_1_120/A dac_n_force[6] VSS
+ VDD sky130_fd_sc_hs__buf_1
Xsky130_fd_sc_hs__buf_1_131 VDD VSS sky130_fd_sc_hs__buf_1_131/A w_wr_data[29] VSS
+ VDD sky130_fd_sc_hs__buf_1
Xsky130_fd_sc_hs__buf_1_142 VDD VSS sky130_fd_sc_hs__buf_1_142/A raw_code_o[11] VSS
+ VDD sky130_fd_sc_hs__buf_1
Xsky130_fd_sc_hs__buf_1_153 VDD VSS sky130_fd_sc_hs__buf_1_153/A w_wr_data[22] VSS
+ VDD sky130_fd_sc_hs__buf_1
Xsky130_fd_sc_hs__buf_1_164 VDD VSS sky130_fd_sc_hs__buf_1_164/A w_wr_data[3] VSS
+ VDD sky130_fd_sc_hs__buf_1
Xsky130_fd_sc_hs__buf_1_175 VDD VSS sky130_fd_sc_hs__buf_1_175/A calib_mode_en VSS
+ VDD sky130_fd_sc_hs__buf_1
Xsky130_fd_sc_hs__buf_1_186 VDD VSS sky130_fd_sc_hs__buf_1_186/A sky130_fd_sc_hs__buf_1_186/X
+ VSS VDD sky130_fd_sc_hs__buf_1
Xsky130_fd_sc_hs__mux2i_1_0 VDD VSS sky130_fd_sc_hs__mux2i_1_0/S sky130_fd_sc_hs__nor3_1_33/A
+ sky130_fd_sc_hs__or2_1_22/B sky130_fd_sc_hs__mux2i_1_0/Y VSS VDD sky130_fd_sc_hs__mux2i_1
Xsky130_fd_sc_hs__nor2_2_13 VDD VSS sky130_fd_sc_hs__or3b_1_1/X sky130_fd_sc_hs__buf_8_31/A
+ sky130_fd_sc_hs__nor3_4_8/B VSS VDD sky130_fd_sc_hs__nor2_2
Xsky130_fd_sc_hs__a21oi_1_201 VDD VSS sky130_fd_sc_hs__nor2_4_3/A sky130_fd_sc_hs__mux2_1_248/A1
+ sky130_fd_sc_hs__o211ai_1_16/Y sky130_fd_sc_hs__o21ai_1_110/Y VSS VDD sky130_fd_sc_hs__a21oi_1
Xsky130_fd_sc_hs__o41ai_1_3 VDD VSS sky130_fd_sc_hs__or2_1_24/B sky130_fd_sc_hs__o41ai_1_3/A2
+ sky130_fd_sc_hs__o41ai_1_3/B1 sky130_fd_sc_hs__o41ai_1_3/Y sky130_fd_sc_hs__nor2_2_3/A
+ sky130_fd_sc_hs__or3_1_6/A VSS VDD sky130_fd_sc_hs__o41ai_1
Xsky130_fd_sc_hs__nand4_1_15 VDD VSS sky130_fd_sc_hs__nand4_1_15/C sky130_fd_sc_hs__nor3_1_52/A
+ sky130_fd_sc_hs__nand4_1_15/D sky130_fd_sc_hs__nand4_1_15/B sky130_fd_sc_hs__nand4_1_15/A
+ VSS VDD sky130_fd_sc_hs__nand4_1
Xsky130_fd_sc_hs__o211ai_1_2 VDD VSS sky130_fd_sc_hs__nand2_1_11/Y sky130_fd_sc_hs__o211ai_1_2/Y
+ sky130_fd_sc_hs__nand2_1_5/B sky130_fd_sc_hs__o211ai_1_2/A2 sky130_fd_sc_hs__nor3_1_3/A
+ VSS VDD sky130_fd_sc_hs__o211ai_1
Xsky130_fd_sc_hs__a31oi_1_0 VDD VSS sky130_fd_sc_hs__a31oi_1_0/Y sky130_fd_sc_hs__nand2_1_21/Y
+ sky130_fd_sc_hs__nor2_1_39/Y sky130_fd_sc_hs__nand3b_1_0/C sky130_fd_sc_hs__nand2_1_54/Y
+ VSS VDD sky130_fd_sc_hs__a31oi_1
Xsky130_fd_sc_hs__o2111ai_1_2 VDD VSS sky130_fd_sc_hs__nor3_1_31/C sky130_fd_sc_hs__nor2_1_122/Y
+ sky130_fd_sc_hs__nor4_1_0/Y sky130_fd_sc_hs__a2111oi_1_0/Y sky130_fd_sc_hs__nor2b_1_33/A
+ sky130_fd_sc_hs__o21ai_1_63/B1 VSS VDD sky130_fd_sc_hs__o2111ai_1
Xsky130_fd_sc_hs__a22o_1_1 VDD VSS sky130_fd_sc_hs__a22o_1_1/X sky130_fd_sc_hs__xnor2_1_5/A
+ sky130_fd_sc_hs__a22o_1_6/B1 sky130_fd_sc_hs__nand2_1_9/B sky130_fd_sc_hs__buf_1_2/A
+ VSS VDD sky130_fd_sc_hs__a22o_1
Xsky130_fd_sc_hs__o2bb2ai_1_20 VDD VSS sky130_fd_sc_hs__dfrtp_1_397/D sky130_fd_sc_hs__nand2_1_71/Y
+ sky130_fd_sc_hs__maj3_1_13/C sky130_fd_sc_hs__o31a_1_1/A2 sky130_fd_sc_hs__a32o_1_7/B1
+ VSS VDD sky130_fd_sc_hs__o2bb2ai_1
Xsky130_fd_sc_hs__o2bb2ai_1_31 VDD VSS sky130_fd_sc_hs__o2bb2ai_1_31/Y sky130_fd_sc_hs__and2_1_35/B
+ sky130_fd_sc_hs__or2_1_22/X sky130_fd_sc_hs__nor3_1_36/B sky130_fd_sc_hs__nor2_1_132/B
+ VSS VDD sky130_fd_sc_hs__o2bb2ai_1
Xsky130_fd_sc_hs__o2bb2ai_1_42 VDD VSS sky130_fd_sc_hs__dfrtp_1_512/D sky130_fd_sc_hs__mux2i_1_7/Y
+ sky130_fd_sc_hs__nor3_1_32/A sky130_fd_sc_hs__nand2b_1_51/Y sky130_fd_sc_hs__or2_1_23/X
+ VSS VDD sky130_fd_sc_hs__o2bb2ai_1
Xsky130_fd_sc_hs__o2bb2ai_1_53 VDD VSS sky130_fd_sc_hs__buf_1_101/A sky130_fd_sc_hs__nand2_1_164/Y
+ sky130_fd_sc_hs__o22ai_1_2/B2 sky130_fd_sc_hs__nand4_1_5/D sky130_fd_sc_hs__buf_8_20/X
+ VSS VDD sky130_fd_sc_hs__o2bb2ai_1
Xsky130_fd_sc_hs__o2bb2ai_1_64 VDD VSS sky130_fd_sc_hs__buf_1_126/A sky130_fd_sc_hs__nand4_1_5/C
+ sky130_fd_sc_hs__mux2i_1_4/A1 sky130_fd_sc_hs__nand2_1_167/Y sky130_fd_sc_hs__nand2_1_125/Y
+ VSS VDD sky130_fd_sc_hs__o2bb2ai_1
Xsky130_fd_sc_hs__o2bb2ai_1_75 VDD VSS sky130_fd_sc_hs__buf_1_120/A sky130_fd_sc_hs__nand4_1_5/C
+ sky130_fd_sc_hs__mux2i_1_9/A1 sky130_fd_sc_hs__nand2_1_216/Y sky130_fd_sc_hs__nand2_1_125/Y
+ VSS VDD sky130_fd_sc_hs__o2bb2ai_1
Xsky130_fd_sc_hs__a31oi_1_14 VDD VSS sky130_fd_sc_hs__nor2_1_178/A sky130_fd_sc_hs__and3_1_14/C
+ sky130_fd_sc_hs__and2_1_47/X sky130_fd_sc_hs__xor2_1_81/X sky130_fd_sc_hs__and3_1_14/A
+ VSS VDD sky130_fd_sc_hs__a31oi_1
Xsky130_fd_sc_hs__o311a_1_0 VDD VSS sky130_fd_sc_hs__and2_1_43/A sky130_fd_sc_hs__o311a_1_0/B1
+ sky130_fd_sc_hs__or3_1_8/C sky130_fd_sc_hs__or3_1_8/B sky130_fd_sc_hs__or3_1_8/A
+ sky130_fd_sc_hs__or3_1_7/C VSS VDD sky130_fd_sc_hs__o311a_1
Xsky130_fd_sc_hs__dfrtp_1_701 sky130_fd_sc_hs__clkbuf_4_51/X VDD VSS sky130_fd_sc_hs__mux2_1_402/A0
+ sky130_fd_sc_hs__clkbuf_2_219/X sky130_fd_sc_hs__mux2_1_402/X VSS VDD sky130_fd_sc_hs__dfrtp_1
Xsky130_fd_sc_hs__dfrtp_1_712 sky130_fd_sc_hs__clkbuf_4_51/X VDD VSS sky130_fd_sc_hs__mux2_1_413/A1
+ sky130_fd_sc_hs__clkbuf_2_216/X sky130_fd_sc_hs__mux2_1_413/X VSS VDD sky130_fd_sc_hs__dfrtp_1
Xsky130_fd_sc_hs__dfrtp_1_723 sky130_fd_sc_hs__clkbuf_4_50/X VDD VSS sky130_fd_sc_hs__xor2_1_82/B
+ sky130_fd_sc_hs__clkbuf_2_223/X sky130_fd_sc_hs__mux2_1_466/X VSS VDD sky130_fd_sc_hs__dfrtp_1
Xsky130_fd_sc_hs__dfrtp_1_734 sky130_fd_sc_hs__clkbuf_4_50/X VDD VSS sky130_fd_sc_hs__mux2_1_443/A1
+ sky130_fd_sc_hs__clkinv_1_161/A sky130_fd_sc_hs__mux2_1_443/X VSS VDD sky130_fd_sc_hs__dfrtp_1
Xsky130_fd_sc_hs__dfrtp_1_745 sky130_fd_sc_hs__buf_8_35/A VDD VSS sky130_fd_sc_hs__mux2_1_452/A0
+ sky130_fd_sc_hs__clkbuf_2_233/X sky130_fd_sc_hs__mux2_1_452/X VSS VDD sky130_fd_sc_hs__dfrtp_1
Xsky130_fd_sc_hs__dfrtp_1_756 sky130_fd_sc_hs__clkbuf_4_50/X VDD VSS sky130_fd_sc_hs__mux2_1_435/A0
+ sky130_fd_sc_hs__clkinv_1_161/A sky130_fd_sc_hs__mux2_1_435/X VSS VDD sky130_fd_sc_hs__dfrtp_1
Xsky130_fd_sc_hs__dfrtp_1_767 sky130_fd_sc_hs__clkbuf_4_28/X VDD VSS sky130_fd_sc_hs__a222o_1_7/A1
+ sky130_fd_sc_hs__dfstp_1_4/CLK sky130_fd_sc_hs__mux2_1_273/X VSS VDD sky130_fd_sc_hs__dfrtp_1
Xsky130_fd_sc_hs__dfrtp_1_778 sky130_fd_sc_hs__buf_8_29/X VDD VSS sky130_fd_sc_hs__mux2_1_282/A0
+ sky130_fd_sc_hs__clkbuf_2_237/X sky130_fd_sc_hs__mux2_1_282/X VSS VDD sky130_fd_sc_hs__dfrtp_1
Xsky130_fd_sc_hs__dfrtp_1_789 sky130_fd_sc_hs__dfrtp_1_259/Q VDD VSS sky130_fd_sc_hs__buf_1_8/A
+ sky130_fd_sc_hs__clkinv_1_5/A sky130_fd_sc_hs__a22o_1_6/B1 VSS VDD sky130_fd_sc_hs__dfrtp_1
Xsky130_fd_sc_hs__nor3_1_8 VDD VSS sky130_fd_sc_hs__nor3_1_8/Y sky130_fd_sc_hs__nor3_1_8/C
+ sky130_fd_sc_hs__nor3_1_8/B sky130_fd_sc_hs__nor3_1_8/A VSS VDD sky130_fd_sc_hs__nor3_1
Xsky130_fd_sc_hs__xnor2_1_16 VDD VSS sky130_fd_sc_hs__xnor2_1_16/A sky130_fd_sc_hs__xnor2_1_17/B
+ sky130_fd_sc_hs__and2_1_9/A VSS VDD sky130_fd_sc_hs__xnor2_1
Xsky130_fd_sc_hs__xnor2_1_27 VDD VSS sky130_fd_sc_hs__xnor2_1_27/A sky130_fd_sc_hs__nor2_1_32/B
+ sky130_fd_sc_hs__or2_1_7/A VSS VDD sky130_fd_sc_hs__xnor2_1
Xsky130_fd_sc_hs__xnor2_1_38 VDD VSS sky130_fd_sc_hs__xor2_1_18/A sky130_fd_sc_hs__xnor2_1_38/Y
+ sky130_fd_sc_hs__xor2_1_17/X VSS VDD sky130_fd_sc_hs__xnor2_1
Xsky130_fd_sc_hs__xnor2_1_49 VDD VSS sky130_fd_sc_hs__xnor2_1_49/A sky130_fd_sc_hs__xnor2_1_50/B
+ sky130_fd_sc_hs__xnor2_1_49/B VSS VDD sky130_fd_sc_hs__xnor2_1
Xsky130_fd_sc_hs__nand2_1_1 VDD VSS sky130_fd_sc_hs__nand2_1_1/B sky130_fd_sc_hs__nor3_1_0/B
+ sky130_fd_sc_hs__nand2_1_1/A VSS VDD sky130_fd_sc_hs__nand2_1
Xsky130_fd_sc_hs__a211oi_1_7 VDD VSS sky130_fd_sc_hs__nand4_1_10/Y sky130_fd_sc_hs__a211oi_1_7/Y
+ sky130_fd_sc_hs__nand2_1_199/Y sky130_fd_sc_hs__buf_4_4/A sky130_fd_sc_hs__xor2_1_65/B
+ VSS VDD sky130_fd_sc_hs__a211oi_1
Xsky130_fd_sc_hs__a22oi_1_8 VDD VSS sky130_fd_sc_hs__mux2_1_22/A1 sky130_fd_sc_hs__nand3_1_3/A
+ sky130_fd_sc_hs__buf_16_9/X sky130_fd_sc_hs__buf_16_7/X sky130_fd_sc_hs__mux2_1_21/A0
+ VSS VDD sky130_fd_sc_hs__a22oi_1
Xsky130_fd_sc_hs__clkbuf_16_10 VDD VSS sky130_fd_sc_hs__clkinv_4_3/A sky130_fd_sc_hs__clkbuf_8_19/X
+ VSS VDD sky130_fd_sc_hs__clkbuf_16
Xsky130_fd_sc_hs__clkbuf_16_21 VDD VSS sky130_fd_sc_hs__clkbuf_16_21/X sky130_fd_sc_hs__clkbuf_2_176/A
+ VSS VDD sky130_fd_sc_hs__clkbuf_16
Xsky130_fd_sc_hs__dfrtp_1_520 sky130_fd_sc_hs__clkbuf_4_22/A VDD VSS sky130_fd_sc_hs__xor2_1_77/B
+ sky130_fd_sc_hs__clkbuf_2_142/X sky130_fd_sc_hs__dfrtp_1_520/D VSS VDD sky130_fd_sc_hs__dfrtp_1
Xsky130_fd_sc_hs__dfrtp_1_531 sky130_fd_sc_hs__clkbuf_2_61/X VDD VSS sky130_fd_sc_hs__buf_1_51/A
+ sky130_fd_sc_hs__clkinv_1_110/A sky130_fd_sc_hs__o31ai_1_17/Y VSS VDD sky130_fd_sc_hs__dfrtp_1
Xsky130_fd_sc_hs__dfrtp_1_542 sky130_fd_sc_hs__clkbuf_4_28/X VDD VSS sky130_fd_sc_hs__mux2_1_464/A1
+ sky130_fd_sc_hs__clkinv_1_113/A sky130_fd_sc_hs__mux2_1_464/X VSS VDD sky130_fd_sc_hs__dfrtp_1
Xsky130_fd_sc_hs__dfrtp_1_553 sky130_fd_sc_hs__clkbuf_4_5/X VDD VSS sky130_fd_sc_hs__mux2_1_259/A1
+ sky130_fd_sc_hs__clkinv_1_112/A sky130_fd_sc_hs__mux2_1_259/X VSS VDD sky130_fd_sc_hs__dfrtp_1
Xsky130_fd_sc_hs__dfrtp_1_564 sky130_fd_sc_hs__buf_8_25/X VDD VSS sky130_fd_sc_hs__mux2_1_275/A0
+ sky130_fd_sc_hs__clkinv_1_121/A sky130_fd_sc_hs__mux2_1_275/X VSS VDD sky130_fd_sc_hs__dfrtp_1
Xsky130_fd_sc_hs__dfrtp_1_575 sky130_fd_sc_hs__clkbuf_4_24/X VDD VSS sky130_fd_sc_hs__buf_1_165/A
+ sky130_fd_sc_hs__clkinv_1_127/A sky130_fd_sc_hs__mux2_1_285/X VSS VDD sky130_fd_sc_hs__dfrtp_1
Xsky130_fd_sc_hs__dfrtp_1_586 sky130_fd_sc_hs__clkbuf_2_61/X VDD VSS sky130_fd_sc_hs__buf_1_129/A
+ sky130_fd_sc_hs__clkinv_1_110/A sky130_fd_sc_hs__mux2_1_257/X VSS VDD sky130_fd_sc_hs__dfrtp_1
Xsky130_fd_sc_hs__dfrtp_1_597 sky130_fd_sc_hs__clkbuf_4_30/X VDD VSS sky130_fd_sc_hs__mux2_1_353/A1
+ sky130_fd_sc_hs__clkinv_1_130/A sky130_fd_sc_hs__mux2_1_353/X VSS VDD sky130_fd_sc_hs__dfrtp_1
Xsky130_fd_sc_hs__a21oi_1_60 VDD VSS sky130_fd_sc_hs__nand4_1_2/B sky130_fd_sc_hs__a21oi_1_60/Y
+ sky130_fd_sc_hs__and2_1_16/X sky130_fd_sc_hs__and2_1_15/X VSS VDD sky130_fd_sc_hs__a21oi_1
Xsky130_fd_sc_hs__a21oi_1_71 VDD VSS sky130_fd_sc_hs__nand2_1_74/Y sky130_fd_sc_hs__a21oi_1_71/Y
+ sky130_fd_sc_hs__a32o_1_5/A3 sky130_fd_sc_hs__a31o_1_6/A1 VSS VDD sky130_fd_sc_hs__a21oi_1
Xsky130_fd_sc_hs__a21oi_1_82 VDD VSS sky130_fd_sc_hs__nor2_1_65/Y sky130_fd_sc_hs__a21oi_1_82/Y
+ sky130_fd_sc_hs__o21ai_1_5/Y sky130_fd_sc_hs__nor2_1_82/B VSS VDD sky130_fd_sc_hs__a21oi_1
Xsky130_fd_sc_hs__a21oi_1_93 VDD VSS sky130_fd_sc_hs__o21ai_1_41/Y sky130_fd_sc_hs__o21a_1_15/A1
+ sky130_fd_sc_hs__xnor2_1_75/Y sky130_fd_sc_hs__buf_8_10/X VSS VDD sky130_fd_sc_hs__a21oi_1
Xsky130_fd_sc_hs__dfrtp_1_80 sky130_fd_sc_hs__clkbuf_4_0/X VDD VSS sky130_fd_sc_hs__a22o_1_9/A1
+ sky130_fd_sc_hs__clkbuf_2_19/X sky130_fd_sc_hs__mux2_1_84/X VSS VDD sky130_fd_sc_hs__dfrtp_1
Xsky130_fd_sc_hs__dfrtp_1_91 sky130_fd_sc_hs__clkbuf_4_1/X VDD VSS sky130_fd_sc_hs__mux2_1_46/A1
+ sky130_fd_sc_hs__clkbuf_2_19/X sky130_fd_sc_hs__mux2_1_46/X VSS VDD sky130_fd_sc_hs__dfrtp_1
Xsky130_fd_sc_hs__a222oi_1_2 VDD VSS sky130_fd_sc_hs__a22oi_1_5/A2 sky130_fd_sc_hs__mux2_1_224/A0
+ sky130_fd_sc_hs__buf_16_7/X sky130_fd_sc_hs__a22o_1_9/A2 sky130_fd_sc_hs__mux2_1_108/A1
+ sky130_fd_sc_hs__a222oi_1_2/Y sky130_fd_sc_hs__mux2_1_488/A0 VSS VDD sky130_fd_sc_hs__a222oi_1
Xsky130_fd_sc_hs__xor2_1_5 VDD VSS sky130_fd_sc_hs__xor2_1_5/A sky130_fd_sc_hs__xor2_1_5/B
+ sky130_fd_sc_hs__xor2_1_5/X VSS VDD sky130_fd_sc_hs__xor2_1
Xsky130_fd_sc_hs__mux2_1_6 VDD VSS sky130_fd_sc_hs__mux2_1_6/X sky130_fd_sc_hs__mux2_1_6/S
+ sky130_fd_sc_hs__mux2_1_7/A1 sky130_fd_sc_hs__mux2_1_6/A1 VSS VDD sky130_fd_sc_hs__mux2_1
Xsky130_fd_sc_hs__dfrtp_1_350 sky130_fd_sc_hs__clkbuf_4_56/X VDD VSS sky130_fd_sc_hs__xor2_1_51/B
+ sky130_fd_sc_hs__clkinv_1_70/A sky130_fd_sc_hs__a21oi_1_83/Y VSS VDD sky130_fd_sc_hs__dfrtp_1
Xsky130_fd_sc_hs__dfrtp_1_361 sky130_fd_sc_hs__clkbuf_4_15/X VDD VSS sky130_fd_sc_hs__a22o_1_67/B2
+ sky130_fd_sc_hs__clkbuf_2_103/X sky130_fd_sc_hs__a22o_1_67/X VSS VDD sky130_fd_sc_hs__dfrtp_1
Xsky130_fd_sc_hs__dfrtp_1_372 sky130_fd_sc_hs__clkbuf_4_14/X VDD VSS sky130_fd_sc_hs__a22o_1_72/A1
+ sky130_fd_sc_hs__clkinv_1_61/A sky130_fd_sc_hs__a22o_1_46/X VSS VDD sky130_fd_sc_hs__dfrtp_1
Xsky130_fd_sc_hs__dfrtp_1_383 sky130_fd_sc_hs__buf_8_5/A VDD VSS sky130_fd_sc_hs__or2_1_10/A
+ sky130_fd_sc_hs__clkbuf_8_4/X sky130_fd_sc_hs__a32o_1_4/X VSS VDD sky130_fd_sc_hs__dfrtp_1
Xsky130_fd_sc_hs__dfrtp_1_394 sky130_fd_sc_hs__buf_8_5/A VDD VSS sky130_fd_sc_hs__and3_1_6/A
+ sky130_fd_sc_hs__clkbuf_8_2/X sky130_fd_sc_hs__o21ai_1_36/Y VSS VDD sky130_fd_sc_hs__dfrtp_1
Xsky130_fd_sc_hs__dlygate4sd3_1_2 VSS VDD data_valid_i sky130_fd_sc_hs__buf_1_71/A
+ VSS VDD sky130_fd_sc_hs__dlygate4sd3_1
Xsky130_fd_sc_hs__and3_1_7 VDD VSS sky130_fd_sc_hs__and3_1_7/A sky130_fd_sc_hs__buf_1_67/A
+ sky130_fd_sc_hs__buf_1_65/X sky130_fd_sc_hs__and3_1_7/X VSS VDD sky130_fd_sc_hs__and3_1
Xsky130_fd_sc_hs__a21oi_1_7 VDD VSS sky130_fd_sc_hs__or2_1_0/X sky130_fd_sc_hs__a22o_1_7/B2
+ sky130_fd_sc_hs__nor3_1_3/Y sky130_fd_sc_hs__nor3_1_4/A VSS VDD sky130_fd_sc_hs__a21oi_1
Xsky130_fd_sc_hs__mux2_1_310 VDD VSS sky130_fd_sc_hs__mux2_1_310/X sky130_fd_sc_hs__mux2_1_5/S
+ sky130_fd_sc_hs__mux2_1_310/A0 sky130_fd_sc_hs__a22o_1_67/B2 VSS VDD sky130_fd_sc_hs__mux2_1
Xsky130_fd_sc_hs__mux2_1_321 VDD VSS sky130_fd_sc_hs__mux2_1_321/X sky130_fd_sc_hs__buf_8_23/X
+ sky130_fd_sc_hs__mux2_1_321/A0 sky130_fd_sc_hs__a22o_1_67/B2 VSS VDD sky130_fd_sc_hs__mux2_1
Xsky130_fd_sc_hs__mux2_1_332 VDD VSS sky130_fd_sc_hs__mux2_1_332/X sky130_fd_sc_hs__nor2_1_93/B
+ sky130_fd_sc_hs__mux2_1_332/A0 sky130_fd_sc_hs__dfrtp_2_1/Q VSS VDD sky130_fd_sc_hs__mux2_1
Xsky130_fd_sc_hs__mux2_1_343 VDD VSS sky130_fd_sc_hs__mux2_1_343/X sky130_fd_sc_hs__nor3_4_1/Y
+ sky130_fd_sc_hs__xor2_1_91/B sky130_fd_sc_hs__a22o_1_84/B2 VSS VDD sky130_fd_sc_hs__mux2_1
Xsky130_fd_sc_hs__mux2_1_354 VDD VSS sky130_fd_sc_hs__mux2_1_354/X sky130_fd_sc_hs__mux2_1_368/S
+ sky130_fd_sc_hs__mux2_1_354/A0 sky130_fd_sc_hs__mux2_1_477/A1 VSS VDD sky130_fd_sc_hs__mux2_1
Xsky130_fd_sc_hs__mux2_1_365 VDD VSS sky130_fd_sc_hs__mux2_1_365/X sky130_fd_sc_hs__buf_16_4/A
+ sky130_fd_sc_hs__mux2_1_365/A0 sky130_fd_sc_hs__dfrtp_2_3/Q VSS VDD sky130_fd_sc_hs__mux2_1
Xsky130_fd_sc_hs__mux2_1_376 VDD VSS sky130_fd_sc_hs__mux2_1_376/X sky130_fd_sc_hs__buf_16_3/X
+ sky130_fd_sc_hs__a22o_1_89/B2 sky130_fd_sc_hs__nand3_1_42/A VSS VDD sky130_fd_sc_hs__mux2_1
Xsky130_fd_sc_hs__mux2_1_387 VDD VSS sky130_fd_sc_hs__mux2_1_387/X sky130_fd_sc_hs__buf_16_0/A
+ sky130_fd_sc_hs__xor2_1_87/B sky130_fd_sc_hs__a22o_1_92/B2 VSS VDD sky130_fd_sc_hs__mux2_1
Xsky130_fd_sc_hs__mux2_1_398 VDD VSS sky130_fd_sc_hs__mux2_1_398/X sky130_fd_sc_hs__buf_16_14/A
+ sky130_fd_sc_hs__mux2_1_398/A0 sky130_fd_sc_hs__a22o_1_92/B2 VSS VDD sky130_fd_sc_hs__mux2_1
Xsky130_fd_sc_hs__xor2_1_10 VDD VSS sky130_fd_sc_hs__maj3_1_7/X sky130_fd_sc_hs__xor2_1_10/B
+ sky130_fd_sc_hs__xor2_1_10/X VSS VDD sky130_fd_sc_hs__xor2_1
Xsky130_fd_sc_hs__xor2_1_21 VDD VSS sky130_fd_sc_hs__xor2_1_21/A sky130_fd_sc_hs__xor2_1_22/X
+ sky130_fd_sc_hs__xor2_1_21/X VSS VDD sky130_fd_sc_hs__xor2_1
Xsky130_fd_sc_hs__xor2_1_32 VDD VSS sky130_fd_sc_hs__xor2_1_32/A sky130_fd_sc_hs__xor2_1_32/B
+ sky130_fd_sc_hs__xor2_1_32/X VSS VDD sky130_fd_sc_hs__xor2_1
Xsky130_fd_sc_hs__xor2_1_43 VDD VSS sky130_fd_sc_hs__xor2_1_43/A sky130_fd_sc_hs__or2_1_12/B
+ sky130_fd_sc_hs__xor2_1_43/X VSS VDD sky130_fd_sc_hs__xor2_1
Xsky130_fd_sc_hs__xor2_1_54 VDD VSS sky130_fd_sc_hs__xor2_1_54/A sky130_fd_sc_hs__xor2_1_54/B
+ sky130_fd_sc_hs__xor2_1_54/X VSS VDD sky130_fd_sc_hs__xor2_1
Xsky130_fd_sc_hs__xor2_1_65 VDD VSS sky130_fd_sc_hs__xor2_1_65/A sky130_fd_sc_hs__xor2_1_65/B
+ sky130_fd_sc_hs__xor2_1_65/X VSS VDD sky130_fd_sc_hs__xor2_1
Xsky130_fd_sc_hs__xor2_1_76 VDD VSS sky130_fd_sc_hs__xor2_1_76/A sky130_fd_sc_hs__xor2_1_76/B
+ sky130_fd_sc_hs__xor2_1_76/X VSS VDD sky130_fd_sc_hs__xor2_1
Xsky130_fd_sc_hs__xor2_1_87 VDD VSS sky130_fd_sc_hs__xor2_1_88/B sky130_fd_sc_hs__xor2_1_87/B
+ sky130_fd_sc_hs__xor2_1_87/X VSS VDD sky130_fd_sc_hs__xor2_1
Xsky130_fd_sc_hs__nand2b_1_12 VDD VSS sky130_fd_sc_hs__xor2_1_14/B sky130_fd_sc_hs__maj3_1_8/X
+ sky130_fd_sc_hs__o21a_1_9/B1 VSS VDD sky130_fd_sc_hs__nand2b_1
Xsky130_fd_sc_hs__nand2b_1_23 VDD VSS sky130_fd_sc_hs__xor2_1_36/B sky130_fd_sc_hs__xor2_1_36/A
+ sky130_fd_sc_hs__a31o_1_4/A3 VSS VDD sky130_fd_sc_hs__nand2b_1
Xsky130_fd_sc_hs__nand2b_1_34 VDD VSS sky130_fd_sc_hs__xor2_1_58/B sky130_fd_sc_hs__xor2_1_58/A
+ sky130_fd_sc_hs__and2_1_25/A VSS VDD sky130_fd_sc_hs__nand2b_1
Xsky130_fd_sc_hs__nand2b_1_45 VDD VSS sky130_fd_sc_hs__xnor2_1_101/B sky130_fd_sc_hs__maj3_1_41/X
+ sky130_fd_sc_hs__nand2b_1_45/Y VSS VDD sky130_fd_sc_hs__nand2b_1
Xsky130_fd_sc_hs__nand2b_1_56 VDD VSS sky130_fd_sc_hs__nor3_4_2/A sky130_fd_sc_hs__nor2_2_7/B
+ sky130_fd_sc_hs__a32o_1_10/A3 VSS VDD sky130_fd_sc_hs__nand2b_1
Xsky130_fd_sc_hs__nand2b_1_3 VDD VSS sky130_fd_sc_hs__nor2_1_10/A sky130_fd_sc_hs__nand2b_1_3/B
+ sky130_fd_sc_hs__o21ai_1_3/A1 VSS VDD sky130_fd_sc_hs__nand2b_1
Xsky130_fd_sc_hs__a221oi_1_1 VDD VSS sky130_fd_sc_hs__a222o_1_3/X sky130_fd_sc_hs__nand3_1_7/B
+ sky130_fd_sc_hs__mux2_1_64/A0 sky130_fd_sc_hs__nand2_1_33/B sky130_fd_sc_hs__mux2_1_82/A0
+ sky130_fd_sc_hs__a222o_1_2/A2 VSS VDD sky130_fd_sc_hs__a221oi_1
Xsky130_fd_sc_hs__dfrtp_1_180 sky130_fd_sc_hs__clkbuf_4_10/X VDD VSS sky130_fd_sc_hs__buf_1_43/A
+ sky130_fd_sc_hs__clkinv_1_43/A sky130_fd_sc_hs__mux2_1_169/X VSS VDD sky130_fd_sc_hs__dfrtp_1
Xsky130_fd_sc_hs__dfrtp_1_191 sky130_fd_sc_hs__clkbuf_4_10/X VDD VSS sky130_fd_sc_hs__maj3_1_8/C
+ sky130_fd_sc_hs__clkinv_2_1/A sky130_fd_sc_hs__mux2_1_142/X VSS VDD sky130_fd_sc_hs__dfrtp_1
Xsky130_fd_sc_hs__a32o_1_3 VDD VSS sky130_fd_sc_hs__a32o_1_3/X sky130_fd_sc_hs__a32o_1_3/B2
+ sky130_fd_sc_hs__nor2_1_48/Y sky130_fd_sc_hs__a32o_1_3/A2 sky130_fd_sc_hs__and2_1_15/X
+ sky130_fd_sc_hs__a32o_1_3/A3 VSS VDD sky130_fd_sc_hs__a32o_1
Xsky130_fd_sc_hs__mux2_1_140 VDD VSS sky130_fd_sc_hs__mux2_1_140/X sky130_fd_sc_hs__mux2_1_94/S
+ sky130_fd_sc_hs__maj3_1_8/B sky130_fd_sc_hs__a22o_1_60/B2 VSS VDD sky130_fd_sc_hs__mux2_1
Xsky130_fd_sc_hs__mux2_1_151 VDD VSS sky130_fd_sc_hs__mux2_1_151/X sky130_fd_sc_hs__buf_16_2/X
+ sky130_fd_sc_hs__a22o_1_40/B2 sky130_fd_sc_hs__mux2_1_151/A1 VSS VDD sky130_fd_sc_hs__mux2_1
Xsky130_fd_sc_hs__mux2_1_162 VDD VSS sky130_fd_sc_hs__mux2_1_162/X sky130_fd_sc_hs__buf_8_3/X
+ sky130_fd_sc_hs__buf_1_59/A sky130_fd_sc_hs__a22o_1_67/B2 VSS VDD sky130_fd_sc_hs__mux2_1
Xsky130_fd_sc_hs__mux2_1_173 VDD VSS sky130_fd_sc_hs__mux2_1_173/X sky130_fd_sc_hs__mux2_1_5/S
+ sky130_fd_sc_hs__mux2_1_173/A0 sky130_fd_sc_hs__a22o_1_60/B2 VSS VDD sky130_fd_sc_hs__mux2_1
Xsky130_fd_sc_hs__mux2_1_184 VDD VSS sky130_fd_sc_hs__mux2_1_184/X sky130_fd_sc_hs__mux2_1_6/S
+ sky130_fd_sc_hs__mux2_1_98/A1 sky130_fd_sc_hs__mux2_1_184/A1 VSS VDD sky130_fd_sc_hs__mux2_1
Xsky130_fd_sc_hs__mux2_1_195 VDD VSS sky130_fd_sc_hs__mux2_1_195/X sky130_fd_sc_hs__buf_16_5/X
+ sky130_fd_sc_hs__mux2_1_195/A0 sky130_fd_sc_hs__mux2_1_85/A0 VSS VDD sky130_fd_sc_hs__mux2_1
Xsky130_fd_sc_hs__buf_1_1 VDD VSS sky130_fd_sc_hs__buf_1_1/A srm_residue_o[2] VSS
+ VDD sky130_fd_sc_hs__buf_1
Xsky130_fd_sc_hs__and3_1_14 VDD VSS sky130_fd_sc_hs__and3_1_14/A sky130_fd_sc_hs__xor2_1_81/X
+ sky130_fd_sc_hs__and3_1_14/C sky130_fd_sc_hs__and3_1_14/X VSS VDD sky130_fd_sc_hs__and3_1
Xsky130_fd_sc_hs__buf_1_110 VDD VSS sky130_fd_sc_hs__o22ai_1_8/Y dac_p_force[4] VSS
+ VDD sky130_fd_sc_hs__buf_1
Xsky130_fd_sc_hs__buf_1_121 VDD VSS sky130_fd_sc_hs__buf_1_121/A dac_p_force[8] VSS
+ VDD sky130_fd_sc_hs__buf_1
Xsky130_fd_sc_hs__buf_1_132 VDD VSS sky130_fd_sc_hs__buf_1_132/A raw_code_o[3] VSS
+ VDD sky130_fd_sc_hs__buf_1
Xsky130_fd_sc_hs__buf_1_143 VDD VSS sky130_fd_sc_hs__buf_1_143/A calib_overrange_bits[15]
+ VSS VDD sky130_fd_sc_hs__buf_1
Xsky130_fd_sc_hs__buf_1_154 VDD VSS sky130_fd_sc_hs__buf_1_154/A calib_done VSS VDD
+ sky130_fd_sc_hs__buf_1
Xsky130_fd_sc_hs__buf_1_165 VDD VSS sky130_fd_sc_hs__buf_1_165/A w_wr_data[23] VSS
+ VDD sky130_fd_sc_hs__buf_1
Xsky130_fd_sc_hs__buf_1_176 VDD VSS sky130_fd_sc_hs__buf_8_34/X sky130_fd_sc_hs__buf_8_35/A
+ VSS VDD sky130_fd_sc_hs__buf_1
Xsky130_fd_sc_hs__buf_1_187 VDD VSS sky130_fd_sc_hs__buf_1_74/X sky130_fd_sc_hs__buf_8_6/A
+ VSS VDD sky130_fd_sc_hs__buf_1
Xsky130_fd_sc_hs__mux2i_1_1 VDD VSS sky130_fd_sc_hs__nor3_1_38/Y sky130_fd_sc_hs__or2_1_22/B
+ sky130_fd_sc_hs__nor2_1_150/A sky130_fd_sc_hs__mux2i_1_1/Y VSS VDD sky130_fd_sc_hs__mux2i_1
Xsky130_fd_sc_hs__a2111oi_1_0 VDD VSS sky130_fd_sc_hs__a21oi_1_164/Y sky130_fd_sc_hs__a21oi_1_165/Y
+ sky130_fd_sc_hs__nor2_1_150/Y sky130_fd_sc_hs__a22oi_1_67/A2 sky130_fd_sc_hs__o22ai_1_9/A1
+ sky130_fd_sc_hs__a2111oi_1_0/Y VSS VDD sky130_fd_sc_hs__a2111oi_1
Xsky130_fd_sc_hs__a21oi_1_202 VDD VSS sky130_fd_sc_hs__buf_8_2/A sky130_fd_sc_hs__a21oi_1_202/Y
+ sky130_fd_sc_hs__xnor2_1_147/Y sky130_fd_sc_hs__nand2_1_223/Y VSS VDD sky130_fd_sc_hs__a21oi_1
Xsky130_fd_sc_hs__o211ai_1_3 VDD VSS sky130_fd_sc_hs__xor2_1_28/X sky130_fd_sc_hs__o211ai_1_3/Y
+ sky130_fd_sc_hs__a21o_1_2/X sky130_fd_sc_hs__xor2_1_27/X sky130_fd_sc_hs__a31o_1_2/A2
+ VSS VDD sky130_fd_sc_hs__o211ai_1
Xsky130_fd_sc_hs__a31oi_1_1 VDD VSS sky130_fd_sc_hs__a31oi_1_1/Y sky130_fd_sc_hs__and3_1_2/C
+ sky130_fd_sc_hs__and2_1_8/X sky130_fd_sc_hs__and3_1_2/B sky130_fd_sc_hs__or2_1_3/X
+ VSS VDD sky130_fd_sc_hs__a31oi_1
Xsky130_fd_sc_hs__clkbuf_2_240 VDD VSS sky130_fd_sc_hs__buf_8_7/A sky130_fd_sc_hs__buf_8_6/A
+ VSS VDD sky130_fd_sc_hs__clkbuf_2
Xsky130_fd_sc_hs__o2111ai_1_3 VDD VSS sky130_fd_sc_hs__nor3_1_43/C sky130_fd_sc_hs__nand3b_1_2/Y
+ sky130_fd_sc_hs__nand2_1_131/Y sky130_fd_sc_hs__nand2b_1_50/Y sky130_fd_sc_hs__a21oi_1_145/Y
+ sky130_fd_sc_hs__o22ai_1_2/A2 VSS VDD sky130_fd_sc_hs__o2111ai_1
Xsky130_fd_sc_hs__a22o_1_2 VDD VSS sky130_fd_sc_hs__a22o_1_2/X sky130_fd_sc_hs__nor3_1_1/Y
+ sky130_fd_sc_hs__nor2_1_6/Y sky130_fd_sc_hs__nand2_1_9/B sky130_fd_sc_hs__buf_1_14/A
+ VSS VDD sky130_fd_sc_hs__a22o_1
Xsky130_fd_sc_hs__o2bb2ai_1_10 VDD VSS sky130_fd_sc_hs__dfrtp_1_226/D sky130_fd_sc_hs__xor2_1_21/X
+ sky130_fd_sc_hs__a22o_1_18/B2 sky130_fd_sc_hs__nand3_1_18/Y sky130_fd_sc_hs__nor2_1_45/B
+ VSS VDD sky130_fd_sc_hs__o2bb2ai_1
Xsky130_fd_sc_hs__o2bb2ai_1_21 VDD VSS sky130_fd_sc_hs__dfrtp_1_386/D sky130_fd_sc_hs__a31o_1_2/X
+ sky130_fd_sc_hs__maj3_1_15/C sky130_fd_sc_hs__a21oi_1_73/Y sky130_fd_sc_hs__a32o_1_7/B1
+ VSS VDD sky130_fd_sc_hs__o2bb2ai_1
Xsky130_fd_sc_hs__o2bb2ai_1_32 VDD VSS sky130_fd_sc_hs__dfrtp_1_522/D sky130_fd_sc_hs__a21oi_1_155/Y
+ sky130_fd_sc_hs__nor3_1_36/A sky130_fd_sc_hs__or2_1_22/A sky130_fd_sc_hs__or2_1_23/A
+ VSS VDD sky130_fd_sc_hs__o2bb2ai_1
Xsky130_fd_sc_hs__o2bb2ai_1_43 VDD VSS sky130_fd_sc_hs__dfrtp_1_490/D sky130_fd_sc_hs__mux2i_1_8/Y
+ sky130_fd_sc_hs__o22ai_1_2/A1 sky130_fd_sc_hs__nand2b_1_51/Y sky130_fd_sc_hs__or2_1_23/X
+ VSS VDD sky130_fd_sc_hs__o2bb2ai_1
Xsky130_fd_sc_hs__o2bb2ai_1_54 VDD VSS sky130_fd_sc_hs__buf_1_98/A sky130_fd_sc_hs__nand4_1_5/C
+ sky130_fd_sc_hs__o32ai_1_0/A1 sky130_fd_sc_hs__nand2_1_162/Y sky130_fd_sc_hs__nand2_1_125/Y
+ VSS VDD sky130_fd_sc_hs__o2bb2ai_1
Xsky130_fd_sc_hs__o2bb2ai_1_65 VDD VSS sky130_fd_sc_hs__buf_1_97/A sky130_fd_sc_hs__nand4_1_5/C
+ sky130_fd_sc_hs__o22a_1_0/A1 sky130_fd_sc_hs__nand2_1_153/Y sky130_fd_sc_hs__nand2_1_125/Y
+ VSS VDD sky130_fd_sc_hs__o2bb2ai_1
Xsky130_fd_sc_hs__o2bb2ai_1_76 VDD VSS sky130_fd_sc_hs__buf_1_173/A sky130_fd_sc_hs__nand2_1_165/Y
+ sky130_fd_sc_hs__nor3_1_32/A sky130_fd_sc_hs__nand4_1_5/D sky130_fd_sc_hs__buf_8_20/X
+ VSS VDD sky130_fd_sc_hs__o2bb2ai_1
Xsky130_fd_sc_hs__dfrtp_1_702 sky130_fd_sc_hs__clkbuf_4_51/X VDD VSS sky130_fd_sc_hs__nand2_1_219/A
+ sky130_fd_sc_hs__clkbuf_2_216/X sky130_fd_sc_hs__mux2_1_408/X VSS VDD sky130_fd_sc_hs__dfrtp_1
Xsky130_fd_sc_hs__dfrtp_1_713 sky130_fd_sc_hs__clkbuf_4_51/X VDD VSS sky130_fd_sc_hs__a211o_1_2/A1
+ sky130_fd_sc_hs__clkbuf_2_232/X sky130_fd_sc_hs__mux2_1_405/X VSS VDD sky130_fd_sc_hs__dfrtp_1
Xsky130_fd_sc_hs__dfrtp_1_724 sky130_fd_sc_hs__clkbuf_4_50/X VDD VSS sky130_fd_sc_hs__mux2_1_424/A1
+ sky130_fd_sc_hs__clkbuf_2_224/X sky130_fd_sc_hs__mux2_1_424/X VSS VDD sky130_fd_sc_hs__dfrtp_1
Xsky130_fd_sc_hs__dfrtp_1_735 sky130_fd_sc_hs__buf_8_34/X VDD VSS sky130_fd_sc_hs__nor2_1_183/B
+ sky130_fd_sc_hs__clkbuf_2_235/X sky130_fd_sc_hs__mux2_1_436/X VSS VDD sky130_fd_sc_hs__dfrtp_1
Xsky130_fd_sc_hs__dfrtp_1_746 sky130_fd_sc_hs__buf_8_35/X VDD VSS sky130_fd_sc_hs__mux2_1_456/A0
+ sky130_fd_sc_hs__clkbuf_2_234/X sky130_fd_sc_hs__mux2_1_456/X VSS VDD sky130_fd_sc_hs__dfrtp_1
Xsky130_fd_sc_hs__dfrtp_1_757 sky130_fd_sc_hs__clkbuf_4_51/X VDD VSS sky130_fd_sc_hs__mux2_1_419/A0
+ sky130_fd_sc_hs__clkbuf_2_237/X sky130_fd_sc_hs__mux2_1_419/X VSS VDD sky130_fd_sc_hs__dfrtp_1
Xsky130_fd_sc_hs__dfrtp_1_768 sky130_fd_sc_hs__clkbuf_4_30/X VDD VSS sky130_fd_sc_hs__mux2_1_359/A1
+ sky130_fd_sc_hs__clkbuf_2_201/X sky130_fd_sc_hs__mux2_1_359/X VSS VDD sky130_fd_sc_hs__dfrtp_1
Xsky130_fd_sc_hs__dfrtp_1_779 sky130_fd_sc_hs__clkbuf_4_5/X VDD VSS sky130_fd_sc_hs__xor2_1_18/B
+ sky130_fd_sc_hs__clkinv_1_113/A sky130_fd_sc_hs__mux2_1_469/X VSS VDD sky130_fd_sc_hs__dfrtp_1
Xsky130_fd_sc_hs__buf_1_90 VDD VSS sky130_fd_sc_hs__buf_1_90/A sky130_fd_sc_hs__buf_1_90/X
+ VSS VDD sky130_fd_sc_hs__buf_1
Xsky130_fd_sc_hs__nor3_1_9 VDD VSS sky130_fd_sc_hs__nor3_1_9/Y sky130_fd_sc_hs__nor3_1_9/C
+ sky130_fd_sc_hs__nor3_1_9/B sky130_fd_sc_hs__buf_8_2/X VSS VDD sky130_fd_sc_hs__nor3_1
Xsky130_fd_sc_hs__nor2b_1_0 VDD VSS sky130_fd_sc_hs__nor3_1_2/C sky130_fd_sc_hs__nor2_1_2/B
+ sky130_fd_sc_hs__nor3_1_2/A VSS VDD sky130_fd_sc_hs__nor2b_1
Xsky130_fd_sc_hs__xnor2_1_17 VDD VSS sky130_fd_sc_hs__a31oi_1_1/Y sky130_fd_sc_hs__xnor2_1_17/Y
+ sky130_fd_sc_hs__xnor2_1_17/B VSS VDD sky130_fd_sc_hs__xnor2_1
Xsky130_fd_sc_hs__xnor2_1_28 VDD VSS sky130_fd_sc_hs__o21a_1_9/X sky130_fd_sc_hs__xnor2_1_28/Y
+ sky130_fd_sc_hs__xor2_1_10/X VSS VDD sky130_fd_sc_hs__xnor2_1
Xsky130_fd_sc_hs__xnor2_1_39 VDD VSS sky130_fd_sc_hs__nor2b_1_9/Y sky130_fd_sc_hs__xnor2_1_39/Y
+ sky130_fd_sc_hs__xnor2_1_39/B VSS VDD sky130_fd_sc_hs__xnor2_1
Xsky130_fd_sc_hs__nand2_1_2 VDD VSS sky130_fd_sc_hs__nand2_1_2/B sky130_fd_sc_hs__nand2_1_2/Y
+ sky130_fd_sc_hs__nand2_1_9/Y VSS VDD sky130_fd_sc_hs__nand2_1
Xsky130_fd_sc_hs__a211oi_1_8 VDD VSS sky130_fd_sc_hs__and2_1_48/X sky130_fd_sc_hs__nor3_1_25/C
+ sky130_fd_sc_hs__and2_1_44/X sky130_fd_sc_hs__a21o_1_7/A2 sky130_fd_sc_hs__maj3_1_59/X
+ VSS VDD sky130_fd_sc_hs__a211oi_1
Xsky130_fd_sc_hs__a22oi_1_9 VDD VSS sky130_fd_sc_hs__mux2_1_37/A1 sky130_fd_sc_hs__and4_1_0/C
+ sky130_fd_sc_hs__buf_16_9/X sky130_fd_sc_hs__a22o_1_8/A2 sky130_fd_sc_hs__mux2_1_24/A0
+ VSS VDD sky130_fd_sc_hs__a22oi_1
Xsky130_fd_sc_hs__clkbuf_16_11 VDD VSS sky130_fd_sc_hs__clkbuf_4_23/A sky130_fd_sc_hs__clkbuf_4_21/A
+ VSS VDD sky130_fd_sc_hs__clkbuf_16
Xsky130_fd_sc_hs__clkbuf_16_22 VDD VSS sky130_fd_sc_hs__o21a_1_29/B1 sky130_fd_sc_hs__o31ai_2_0/B1
+ VSS VDD sky130_fd_sc_hs__clkbuf_16
Xsky130_fd_sc_hs__dfrtp_1_510 sky130_fd_sc_hs__clkbuf_4_22/X VDD VSS sky130_fd_sc_hs__maj3_1_37/C
+ sky130_fd_sc_hs__clkinv_2_9/A sky130_fd_sc_hs__dfrtp_1_510/D VSS VDD sky130_fd_sc_hs__dfrtp_1
Xsky130_fd_sc_hs__dfrtp_1_521 sky130_fd_sc_hs__clkbuf_4_22/X VDD VSS sky130_fd_sc_hs__and4_1_5/C
+ sky130_fd_sc_hs__clkbuf_2_139/X sky130_fd_sc_hs__dfrtp_1_521/D VSS VDD sky130_fd_sc_hs__dfrtp_1
Xsky130_fd_sc_hs__dfrtp_1_532 sky130_fd_sc_hs__clkbuf_2_61/X VDD VSS sky130_fd_sc_hs__buf_1_52/A
+ sky130_fd_sc_hs__clkinv_1_110/A sky130_fd_sc_hs__o31ai_1_15/Y VSS VDD sky130_fd_sc_hs__dfrtp_1
Xsky130_fd_sc_hs__dfrtp_1_543 sky130_fd_sc_hs__clkbuf_4_28/X VDD VSS sky130_fd_sc_hs__mux2_1_267/A0
+ sky130_fd_sc_hs__clkinv_1_113/A sky130_fd_sc_hs__mux2_1_267/X VSS VDD sky130_fd_sc_hs__dfrtp_1
Xsky130_fd_sc_hs__dfrtp_1_554 sky130_fd_sc_hs__buf_8_25/X VDD VSS sky130_fd_sc_hs__or2_1_30/A
+ sky130_fd_sc_hs__clkinv_1_123/A sky130_fd_sc_hs__a32o_1_10/X VSS VDD sky130_fd_sc_hs__dfrtp_1
Xsky130_fd_sc_hs__dfrtp_1_565 sky130_fd_sc_hs__clkbuf_4_28/X VDD VSS sky130_fd_sc_hs__a222o_1_5/C2
+ sky130_fd_sc_hs__dfstp_1_3/CLK sky130_fd_sc_hs__mux2_1_290/X VSS VDD sky130_fd_sc_hs__dfrtp_1
Xsky130_fd_sc_hs__dfrtp_1_576 sky130_fd_sc_hs__clkbuf_4_24/X VDD VSS sky130_fd_sc_hs__buf_1_29/A
+ sky130_fd_sc_hs__clkinv_1_126/A sky130_fd_sc_hs__mux2_1_288/X VSS VDD sky130_fd_sc_hs__dfrtp_1
Xsky130_fd_sc_hs__dfrtp_1_587 sky130_fd_sc_hs__clkbuf_2_61/X VDD VSS sky130_fd_sc_hs__buf_1_139/A
+ sky130_fd_sc_hs__clkinv_1_110/A sky130_fd_sc_hs__mux2_1_256/X VSS VDD sky130_fd_sc_hs__dfrtp_1
Xsky130_fd_sc_hs__dfrtp_1_598 sky130_fd_sc_hs__clkbuf_4_30/X VDD VSS sky130_fd_sc_hs__mux2_1_298/A1
+ sky130_fd_sc_hs__clkinv_1_129/A sky130_fd_sc_hs__mux2_1_298/X VSS VDD sky130_fd_sc_hs__dfrtp_1
Xsky130_fd_sc_hs__clkinv_2_10 VDD VSS sky130_fd_sc_hs__clkinv_2_10/Y sky130_fd_sc_hs__clkinv_2_10/A
+ VSS VDD sky130_fd_sc_hs__clkinv_2
Xsky130_fd_sc_hs__a21oi_1_50 VDD VSS sky130_fd_sc_hs__o21ai_1_7/B1 sky130_fd_sc_hs__a21oi_1_50/Y
+ sky130_fd_sc_hs__xnor2_1_32/Y sky130_fd_sc_hs__buf_1_22/X VSS VDD sky130_fd_sc_hs__a21oi_1
Xsky130_fd_sc_hs__a21oi_1_61 VDD VSS sky130_fd_sc_hs__and3_1_8/C sky130_fd_sc_hs__xnor2_1_45/B
+ sky130_fd_sc_hs__and3_1_8/B sky130_fd_sc_hs__and3_1_8/A VSS VDD sky130_fd_sc_hs__a21oi_1
Xsky130_fd_sc_hs__a21oi_1_72 VDD VSS sky130_fd_sc_hs__nor2_1_58/Y sky130_fd_sc_hs__a21oi_1_72/Y
+ sky130_fd_sc_hs__nor2_1_66/B sky130_fd_sc_hs__o21ai_1_15/Y VSS VDD sky130_fd_sc_hs__a21oi_1
Xsky130_fd_sc_hs__a21oi_1_83 VDD VSS sky130_fd_sc_hs__nor2_1_66/Y sky130_fd_sc_hs__a21oi_1_83/Y
+ sky130_fd_sc_hs__nor2_1_66/B sky130_fd_sc_hs__o21ai_1_5/Y VSS VDD sky130_fd_sc_hs__a21oi_1
Xsky130_fd_sc_hs__a21oi_1_94 VDD VSS sky130_fd_sc_hs__a21oi_1_97/Y sky130_fd_sc_hs__nor2_1_79/B
+ sky130_fd_sc_hs__o21a_1_17/X sky130_fd_sc_hs__nand2_1_99/B VSS VDD sky130_fd_sc_hs__a21oi_1
Xsky130_fd_sc_hs__dfrtp_1_70 sky130_fd_sc_hs__clkbuf_4_0/X VDD VSS sky130_fd_sc_hs__mux2_1_78/A0
+ sky130_fd_sc_hs__clkbuf_2_25/X sky130_fd_sc_hs__mux2_1_78/X VSS VDD sky130_fd_sc_hs__dfrtp_1
Xsky130_fd_sc_hs__dfrtp_1_81 sky130_fd_sc_hs__clkbuf_4_12/A VDD VSS sky130_fd_sc_hs__buf_1_1/A
+ sky130_fd_sc_hs__clkbuf_2_15/X sky130_fd_sc_hs__a22o_1_0/X VSS VDD sky130_fd_sc_hs__dfrtp_1
Xsky130_fd_sc_hs__dfrtp_1_92 sky130_fd_sc_hs__clkbuf_4_1/X VDD VSS sky130_fd_sc_hs__mux2_1_47/A0
+ sky130_fd_sc_hs__clkbuf_2_19/X sky130_fd_sc_hs__mux2_1_47/X VSS VDD sky130_fd_sc_hs__dfrtp_1
Xsky130_fd_sc_hs__a222oi_1_3 VDD VSS sky130_fd_sc_hs__a22oi_1_6/B1 sky130_fd_sc_hs__xor2_1_5/B
+ sky130_fd_sc_hs__buf_16_9/X sky130_fd_sc_hs__a222o_1_3/C2 sky130_fd_sc_hs__mux2_1_484/A1
+ sky130_fd_sc_hs__nand3_1_12/C sky130_fd_sc_hs__mux2_1_118/A1 VSS VDD sky130_fd_sc_hs__a222oi_1
Xsky130_fd_sc_hs__o31a_1_0 VDD VSS sky130_fd_sc_hs__o31a_1_0/B1 sky130_fd_sc_hs__nor2_1_2/B
+ sky130_fd_sc_hs__nor2_1_2/A sky130_fd_sc_hs__nor3_1_5/B sky130_fd_sc_hs__o31a_1_0/X
+ VSS VDD sky130_fd_sc_hs__o31a_1
Xsky130_fd_sc_hs__xor2_1_6 VDD VSS sky130_fd_sc_hs__xor2_1_6/A sky130_fd_sc_hs__xor2_1_6/B
+ sky130_fd_sc_hs__xor2_1_6/X VSS VDD sky130_fd_sc_hs__xor2_1
Xsky130_fd_sc_hs__dfrtp_1_340 sky130_fd_sc_hs__clkbuf_4_14/X VDD VSS sky130_fd_sc_hs__a22o_1_47/B2
+ sky130_fd_sc_hs__clkinv_1_63/A sky130_fd_sc_hs__a22o_1_47/X VSS VDD sky130_fd_sc_hs__dfrtp_1
Xsky130_fd_sc_hs__dfrtp_1_351 sky130_fd_sc_hs__clkbuf_4_56/X VDD VSS sky130_fd_sc_hs__xor2_1_51/A
+ sky130_fd_sc_hs__clkinv_1_70/A sky130_fd_sc_hs__a21oi_1_82/Y VSS VDD sky130_fd_sc_hs__dfrtp_1
Xsky130_fd_sc_hs__mux2_1_7 VDD VSS sky130_fd_sc_hs__mux2_1_7/X sky130_fd_sc_hs__mux2_1_7/S
+ sky130_fd_sc_hs__mux2_1_7/A0 sky130_fd_sc_hs__mux2_1_7/A1 VSS VDD sky130_fd_sc_hs__mux2_1
Xsky130_fd_sc_hs__dfrtp_1_362 sky130_fd_sc_hs__clkbuf_4_15/X VDD VSS sky130_fd_sc_hs__mux2_1_473/A1
+ sky130_fd_sc_hs__clkbuf_2_241/X sky130_fd_sc_hs__a22o_1_142/X VSS VDD sky130_fd_sc_hs__dfrtp_1
Xsky130_fd_sc_hs__dfrtp_1_373 sky130_fd_sc_hs__clkbuf_4_56/X VDD VSS sky130_fd_sc_hs__a22o_1_63/A1
+ sky130_fd_sc_hs__clkbuf_2_102/X sky130_fd_sc_hs__a22o_1_57/X VSS VDD sky130_fd_sc_hs__dfrtp_1
Xsky130_fd_sc_hs__dfrtp_1_384 sky130_fd_sc_hs__buf_8_5/A VDD VSS sky130_fd_sc_hs__o21a_1_16/A1
+ sky130_fd_sc_hs__clkbuf_8_4/X sky130_fd_sc_hs__o21a_1_16/X VSS VDD sky130_fd_sc_hs__dfrtp_1
Xsky130_fd_sc_hs__dfrtp_1_395 sky130_fd_sc_hs__buf_8_7/X VDD VSS sky130_fd_sc_hs__maj3_1_12/C
+ sky130_fd_sc_hs__clkinv_1_54/A sky130_fd_sc_hs__a32o_1_5/X VSS VDD sky130_fd_sc_hs__dfrtp_1
Xsky130_fd_sc_hs__dlygate4sd3_1_3 VSS VDD raw_bits_i[3] sky130_fd_sc_hs__buf_1_80/A
+ VSS VDD sky130_fd_sc_hs__dlygate4sd3_1
Xsky130_fd_sc_hs__and3_1_8 VDD VSS sky130_fd_sc_hs__and3_1_8/A sky130_fd_sc_hs__and3_1_8/B
+ sky130_fd_sc_hs__and3_1_8/C sky130_fd_sc_hs__or2_1_10/B VSS VDD sky130_fd_sc_hs__and3_1
Xsky130_fd_sc_hs__a21oi_1_8 VDD VSS sky130_fd_sc_hs__nor3_1_4/B sky130_fd_sc_hs__nor3_1_4/C
+ sky130_fd_sc_hs__nor3_1_3/C sky130_fd_sc_hs__nand2b_1_2/Y VSS VDD sky130_fd_sc_hs__a21oi_1
Xsky130_fd_sc_hs__clkbuf_4_50 VDD VSS sky130_fd_sc_hs__buf_8_34/A sky130_fd_sc_hs__clkbuf_4_50/X
+ VSS VDD sky130_fd_sc_hs__clkbuf_4
Xsky130_fd_sc_hs__mux2_1_300 VDD VSS sky130_fd_sc_hs__mux2_1_300/X sky130_fd_sc_hs__mux2_1_328/S
+ sky130_fd_sc_hs__mux2_1_300/A0 sky130_fd_sc_hs__a22o_1_61/B2 VSS VDD sky130_fd_sc_hs__mux2_1
Xsky130_fd_sc_hs__mux2_1_311 VDD VSS sky130_fd_sc_hs__mux2_1_311/X sky130_fd_sc_hs__mux2_1_98/S
+ sky130_fd_sc_hs__a221o_1_1/A1 sky130_fd_sc_hs__a22o_1_67/B2 VSS VDD sky130_fd_sc_hs__mux2_1
Xsky130_fd_sc_hs__mux2_1_322 VDD VSS sky130_fd_sc_hs__mux2_1_322/X sky130_fd_sc_hs__buf_8_28/X
+ sky130_fd_sc_hs__mux2_1_355/A1 sky130_fd_sc_hs__mux2_1_322/A1 VSS VDD sky130_fd_sc_hs__mux2_1
Xsky130_fd_sc_hs__mux2_1_333 VDD VSS sky130_fd_sc_hs__mux2_1_333/X sky130_fd_sc_hs__buf_8_28/X
+ sky130_fd_sc_hs__mux2_1_477/A1 sky130_fd_sc_hs__mux2_1_333/A1 VSS VDD sky130_fd_sc_hs__mux2_1
Xsky130_fd_sc_hs__mux2_1_344 VDD VSS sky130_fd_sc_hs__mux2_1_344/X sky130_fd_sc_hs__mux2_1_370/S
+ sky130_fd_sc_hs__maj3_1_52/C sky130_fd_sc_hs__a22o_1_95/B2 VSS VDD sky130_fd_sc_hs__mux2_1
Xsky130_fd_sc_hs__mux2_1_355 VDD VSS sky130_fd_sc_hs__mux2_1_355/X sky130_fd_sc_hs__mux2_1_368/S
+ sky130_fd_sc_hs__mux2_1_355/A0 sky130_fd_sc_hs__mux2_1_355/A1 VSS VDD sky130_fd_sc_hs__mux2_1
Xsky130_fd_sc_hs__mux2_1_366 VDD VSS sky130_fd_sc_hs__mux2_1_366/X sky130_fd_sc_hs__buf_8_28/X
+ sky130_fd_sc_hs__dfrtp_2_1/Q sky130_fd_sc_hs__mux2_1_366/A1 VSS VDD sky130_fd_sc_hs__mux2_1
Xsky130_fd_sc_hs__mux2_1_377 VDD VSS sky130_fd_sc_hs__mux2_1_377/X sky130_fd_sc_hs__buf_16_1/X
+ sky130_fd_sc_hs__mux2_1_377/A0 sky130_fd_sc_hs__a22o_1_89/B2 VSS VDD sky130_fd_sc_hs__mux2_1
Xsky130_fd_sc_hs__mux2_1_388 VDD VSS sky130_fd_sc_hs__mux2_1_388/X sky130_fd_sc_hs__buf_16_6/A
+ sky130_fd_sc_hs__mux2_1_388/A0 sky130_fd_sc_hs__a22o_1_92/B2 VSS VDD sky130_fd_sc_hs__mux2_1
Xsky130_fd_sc_hs__mux2_1_399 VDD VSS sky130_fd_sc_hs__mux2_1_399/X sky130_fd_sc_hs__buf_16_12/A
+ sky130_fd_sc_hs__mux2_1_399/A0 sky130_fd_sc_hs__dfrtp_2_2/Q VSS VDD sky130_fd_sc_hs__mux2_1
Xsky130_fd_sc_hs__xor2_1_11 VDD VSS sky130_fd_sc_hs__maj3_1_7/B sky130_fd_sc_hs__maj3_1_7/C
+ sky130_fd_sc_hs__xor2_1_11/X VSS VDD sky130_fd_sc_hs__xor2_1
Xsky130_fd_sc_hs__xor2_1_22 VDD VSS sky130_fd_sc_hs__xor2_1_22/A sky130_fd_sc_hs__xor2_1_22/B
+ sky130_fd_sc_hs__xor2_1_22/X VSS VDD sky130_fd_sc_hs__xor2_1
Xsky130_fd_sc_hs__xor2_1_33 VDD VSS sky130_fd_sc_hs__xor2_1_33/A sky130_fd_sc_hs__xor2_1_33/B
+ sky130_fd_sc_hs__xor2_1_33/X VSS VDD sky130_fd_sc_hs__xor2_1
Xsky130_fd_sc_hs__xor2_1_44 VDD VSS sky130_fd_sc_hs__xor2_1_44/A sky130_fd_sc_hs__or2_1_12/B
+ sky130_fd_sc_hs__xor2_1_44/X VSS VDD sky130_fd_sc_hs__xor2_1
Xsky130_fd_sc_hs__xor2_1_55 VDD VSS sky130_fd_sc_hs__xor2_1_55/A sky130_fd_sc_hs__xor2_1_55/B
+ sky130_fd_sc_hs__xor2_1_55/X VSS VDD sky130_fd_sc_hs__xor2_1
Xsky130_fd_sc_hs__xor2_1_66 VDD VSS sky130_fd_sc_hs__xor2_1_66/A sky130_fd_sc_hs__xor2_1_66/B
+ sky130_fd_sc_hs__xor2_1_66/X VSS VDD sky130_fd_sc_hs__xor2_1
Xsky130_fd_sc_hs__xor2_1_77 VDD VSS sky130_fd_sc_hs__xor2_1_77/A sky130_fd_sc_hs__xor2_1_77/B
+ sky130_fd_sc_hs__xor2_1_77/X VSS VDD sky130_fd_sc_hs__xor2_1
Xsky130_fd_sc_hs__xor2_1_88 VDD VSS sky130_fd_sc_hs__xor2_1_88/A sky130_fd_sc_hs__xor2_1_88/B
+ sky130_fd_sc_hs__xor2_1_88/X VSS VDD sky130_fd_sc_hs__xor2_1
Xsky130_fd_sc_hs__nand2b_1_13 VDD VSS sky130_fd_sc_hs__buf_1_12/A sky130_fd_sc_hs__buf_1_60/X
+ sky130_fd_sc_hs__nor2_2_1/A VSS VDD sky130_fd_sc_hs__nand2b_1
Xsky130_fd_sc_hs__nand2b_1_24 VDD VSS sky130_fd_sc_hs__xor2_1_37/B sky130_fd_sc_hs__xor2_1_37/A
+ sky130_fd_sc_hs__a31o_1_5/A1 VSS VDD sky130_fd_sc_hs__nand2b_1
Xsky130_fd_sc_hs__nand2b_1_35 VDD VSS sky130_fd_sc_hs__xor2_1_57/B sky130_fd_sc_hs__xor2_1_57/A
+ sky130_fd_sc_hs__a31o_1_11/A1 VSS VDD sky130_fd_sc_hs__nand2b_1
Xsky130_fd_sc_hs__nand2b_1_46 VDD VSS sky130_fd_sc_hs__xor2_1_72/B sky130_fd_sc_hs__xor2_1_72/A
+ sky130_fd_sc_hs__o21ai_1_56/B1 VSS VDD sky130_fd_sc_hs__nand2b_1
Xsky130_fd_sc_hs__nand2b_1_57 VDD VSS sky130_fd_sc_hs__nor2_1_160/B sky130_fd_sc_hs__nand4_1_9/C
+ sky130_fd_sc_hs__or2_1_26/A VSS VDD sky130_fd_sc_hs__nand2b_1
Xsky130_fd_sc_hs__nand2b_1_4 VDD VSS sky130_fd_sc_hs__xor2_1_2/B sky130_fd_sc_hs__xor2_1_2/A
+ sky130_fd_sc_hs__nand2b_1_4/Y VSS VDD sky130_fd_sc_hs__nand2b_1
Xsky130_fd_sc_hs__a221oi_1_2 VDD VSS sky130_fd_sc_hs__a222o_1_2/X sky130_fd_sc_hs__nand3_1_9/B
+ sky130_fd_sc_hs__mux2_1_68/A1 sky130_fd_sc_hs__a222o_1_3/C2 sky130_fd_sc_hs__mux2_1_67/A0
+ sky130_fd_sc_hs__nand2_1_33/B VSS VDD sky130_fd_sc_hs__a221oi_1
Xsky130_fd_sc_hs__dfrtp_1_170 sky130_fd_sc_hs__clkbuf_4_10/X VDD VSS sky130_fd_sc_hs__buf_1_39/A
+ sky130_fd_sc_hs__clkinv_1_43/A sky130_fd_sc_hs__mux2_1_161/X VSS VDD sky130_fd_sc_hs__dfrtp_1
Xsky130_fd_sc_hs__dfrtp_1_181 sky130_fd_sc_hs__clkbuf_16_5/X VDD VSS sky130_fd_sc_hs__buf_1_44/A
+ sky130_fd_sc_hs__clkinv_1_43/A sky130_fd_sc_hs__mux2_1_168/X VSS VDD sky130_fd_sc_hs__dfrtp_1
Xsky130_fd_sc_hs__dfrtp_1_192 sky130_fd_sc_hs__clkbuf_4_5/X VDD VSS sky130_fd_sc_hs__mux2_1_143/A0
+ sky130_fd_sc_hs__clkinv_1_38/A sky130_fd_sc_hs__mux2_1_143/X VSS VDD sky130_fd_sc_hs__dfrtp_1
Xsky130_fd_sc_hs__a32o_1_4 VDD VSS sky130_fd_sc_hs__a32o_1_4/X sky130_fd_sc_hs__or2_1_10/A
+ sky130_fd_sc_hs__a32o_1_4/B1 sky130_fd_sc_hs__or2_1_10/X sky130_fd_sc_hs__and2_1_14/X
+ sky130_fd_sc_hs__nor2_1_57/B VSS VDD sky130_fd_sc_hs__a32o_1
Xsky130_fd_sc_hs__clkinv_1_0 VDD VSS sky130_fd_sc_hs__clkinv_1_0/A sky130_fd_sc_hs__clkinv_1_0/Y
+ VSS VDD sky130_fd_sc_hs__clkinv_1
Xsky130_fd_sc_hs__mux2_1_130 VDD VSS sky130_fd_sc_hs__mux2_1_130/X sky130_fd_sc_hs__buf_8_3/X
+ sky130_fd_sc_hs__buf_1_27/A sky130_fd_sc_hs__mux2_1_98/A1 VSS VDD sky130_fd_sc_hs__mux2_1
Xsky130_fd_sc_hs__mux2_1_141 VDD VSS sky130_fd_sc_hs__mux2_1_141/X sky130_fd_sc_hs__mux2_1_98/S
+ sky130_fd_sc_hs__mux2_1_141/A0 sky130_fd_sc_hs__a22o_1_40/B2 VSS VDD sky130_fd_sc_hs__mux2_1
Xsky130_fd_sc_hs__mux2_1_152 VDD VSS sky130_fd_sc_hs__mux2_1_152/X sky130_fd_sc_hs__buf_16_0/A
+ sky130_fd_sc_hs__xor2_1_17/B sky130_fd_sc_hs__a22o_1_62/B2 VSS VDD sky130_fd_sc_hs__mux2_1
Xsky130_fd_sc_hs__mux2_1_163 VDD VSS sky130_fd_sc_hs__mux2_1_163/X sky130_fd_sc_hs__buf_16_3/X
+ sky130_fd_sc_hs__a22o_1_75/B2 sky130_fd_sc_hs__mux2_1_163/A1 VSS VDD sky130_fd_sc_hs__mux2_1
Xsky130_fd_sc_hs__mux2_1_174 VDD VSS sky130_fd_sc_hs__mux2_1_174/X sky130_fd_sc_hs__mux2_1_98/S
+ sky130_fd_sc_hs__mux2_1_174/A0 sky130_fd_sc_hs__a22o_1_60/B2 VSS VDD sky130_fd_sc_hs__mux2_1
Xsky130_fd_sc_hs__mux2_1_185 VDD VSS sky130_fd_sc_hs__dfrtp_1_8/D sky130_fd_sc_hs__mux2_1_94/S
+ sky130_fd_sc_hs__maj3_1_7/B sky130_fd_sc_hs__mux2_1_9/A1 VSS VDD sky130_fd_sc_hs__mux2_1
Xsky130_fd_sc_hs__mux2_1_196 VDD VSS sky130_fd_sc_hs__mux2_1_196/X sky130_fd_sc_hs__nor2_1_66/B
+ sky130_fd_sc_hs__xor2_1_24/B sky130_fd_sc_hs__nor2_1_63/Y VSS VDD sky130_fd_sc_hs__mux2_1
Xsky130_fd_sc_hs__buf_1_2 VDD VSS sky130_fd_sc_hs__buf_1_2/A srm_ones_count[1] VSS
+ VDD sky130_fd_sc_hs__buf_1
Xsky130_fd_sc_hs__buf_1_100 VDD VSS sky130_fd_sc_hs__buf_1_100/A dac_p_force[7] VSS
+ VDD sky130_fd_sc_hs__buf_1
Xsky130_fd_sc_hs__buf_1_111 VDD VSS sky130_fd_sc_hs__buf_1_111/A dac_n_force[11] VSS
+ VDD sky130_fd_sc_hs__buf_1
Xsky130_fd_sc_hs__buf_1_122 VDD VSS sky130_fd_sc_hs__buf_1_122/A dac_p_force[5] VSS
+ VDD sky130_fd_sc_hs__buf_1
Xsky130_fd_sc_hs__buf_1_133 VDD VSS sky130_fd_sc_hs__buf_1_133/A w_wr_addr[4] VSS
+ VDD sky130_fd_sc_hs__buf_1
Xsky130_fd_sc_hs__buf_1_144 VDD VSS sky130_fd_sc_hs__buf_1_144/A w_wr_data[7] VSS
+ VDD sky130_fd_sc_hs__buf_1
Xsky130_fd_sc_hs__buf_1_155 VDD VSS sky130_fd_sc_hs__buf_1_155/A raw_code_o[10] VSS
+ VDD sky130_fd_sc_hs__buf_1
Xsky130_fd_sc_hs__buf_1_166 VDD VSS sky130_fd_sc_hs__buf_1_166/A w_wr_data[28] VSS
+ VDD sky130_fd_sc_hs__buf_1
Xsky130_fd_sc_hs__buf_1_177 VDD VSS sky130_fd_sc_hs__buf_8_29/A sky130_fd_sc_hs__buf_8_25/A
+ VSS VDD sky130_fd_sc_hs__buf_1
Xsky130_fd_sc_hs__buf_1_188 VDD VSS sky130_fd_sc_hs__buf_1_188/A srm_ones_count[2]
+ VSS VDD sky130_fd_sc_hs__buf_1
Xsky130_fd_sc_hs__mux2i_1_2 VDD VSS sky130_fd_sc_hs__mux2i_1_2/S sky130_fd_sc_hs__o22ai_1_3/B2
+ sky130_fd_sc_hs__or2_1_22/B sky130_fd_sc_hs__mux2i_1_2/Y VSS VDD sky130_fd_sc_hs__mux2i_1
Xsky130_fd_sc_hs__a2111oi_1_1 VDD VSS sky130_fd_sc_hs__a222o_1_4/X sky130_fd_sc_hs__a22o_1_121/X
+ sky130_fd_sc_hs__a22o_1_123/X sky130_fd_sc_hs__buf_4_5/A sky130_fd_sc_hs__mux2_1_329/A0
+ sky130_fd_sc_hs__and3_1_12/C VSS VDD sky130_fd_sc_hs__a2111oi_1
Xsky130_fd_sc_hs__a21oi_1_203 VDD VSS sky130_fd_sc_hs__nor2_4_3/A sky130_fd_sc_hs__a21oi_1_203/Y
+ sky130_fd_sc_hs__o2bb2ai_1_73/Y sky130_fd_sc_hs__nor2_1_180/A VSS VDD sky130_fd_sc_hs__a21oi_1
Xsky130_fd_sc_hs__o211ai_1_4 VDD VSS sky130_fd_sc_hs__o211ai_1_4/B1 sky130_fd_sc_hs__a31o_1_2/A2
+ sky130_fd_sc_hs__a31o_1_3/A3 sky130_fd_sc_hs__nand2_1_72/Y sky130_fd_sc_hs__nor3_1_27/Y
+ VSS VDD sky130_fd_sc_hs__o211ai_1
Xsky130_fd_sc_hs__a31oi_1_2 VDD VSS sky130_fd_sc_hs__xnor3_1_0/B sky130_fd_sc_hs__and3_1_3/C
+ sky130_fd_sc_hs__nor2b_1_8/Y sky130_fd_sc_hs__and3_1_3/B sky130_fd_sc_hs__and3_1_3/A
+ VSS VDD sky130_fd_sc_hs__a31oi_1
Xsky130_fd_sc_hs__clkbuf_2_230 VDD VSS sky130_fd_sc_hs__clkinv_1_161/A sky130_fd_sc_hs__clkbuf_8_17/A
+ VSS VDD sky130_fd_sc_hs__clkbuf_2
Xsky130_fd_sc_hs__clkbuf_2_241 VDD VSS sky130_fd_sc_hs__clkbuf_2_241/X sky130_fd_sc_hs__clkinv_4_4/A
+ VSS VDD sky130_fd_sc_hs__clkbuf_2
Xsky130_fd_sc_hs__o2111ai_1_4 VDD VSS sky130_fd_sc_hs__nor3_1_43/B sky130_fd_sc_hs__a22oi_1_67/Y
+ sky130_fd_sc_hs__nand2_1_161/Y sky130_fd_sc_hs__nand3b_1_3/Y sky130_fd_sc_hs__nor3_1_42/Y
+ sky130_fd_sc_hs__o22ai_1_6/A1 VSS VDD sky130_fd_sc_hs__o2111ai_1
Xsky130_fd_sc_hs__nand2_1_230 VDD VSS sky130_fd_sc_hs__nand2_1_230/B sky130_fd_sc_hs__nand2_1_230/Y
+ sky130_fd_sc_hs__nand2_1_230/A VSS VDD sky130_fd_sc_hs__nand2_1
Xsky130_fd_sc_hs__a22o_1_3 VDD VSS sky130_fd_sc_hs__a22o_1_3/X sky130_fd_sc_hs__or2_1_0/A
+ sky130_fd_sc_hs__a22o_1_6/B1 sky130_fd_sc_hs__nand2_1_9/B sky130_fd_sc_hs__buf_1_3/A
+ VSS VDD sky130_fd_sc_hs__a22o_1
Xsky130_fd_sc_hs__o2bb2ai_1_11 VDD VSS sky130_fd_sc_hs__dfrtp_1_229/D sky130_fd_sc_hs__xor2_1_22/B
+ sky130_fd_sc_hs__a22o_1_20/B2 sky130_fd_sc_hs__nand3_1_18/Y sky130_fd_sc_hs__nor2_1_45/B
+ VSS VDD sky130_fd_sc_hs__o2bb2ai_1
Xsky130_fd_sc_hs__o2bb2ai_1_22 VDD VSS sky130_fd_sc_hs__dfrtp_1_398/D sky130_fd_sc_hs__a31o_1_3/X
+ sky130_fd_sc_hs__maj3_1_17/C sky130_fd_sc_hs__a21oi_1_77/Y sky130_fd_sc_hs__a32o_1_7/B1
+ VSS VDD sky130_fd_sc_hs__o2bb2ai_1
Xsky130_fd_sc_hs__o2bb2ai_1_33 VDD VSS sky130_fd_sc_hs__dfrtp_1_505/D sky130_fd_sc_hs__mux2i_1_2/Y
+ sky130_fd_sc_hs__o22ai_1_3/B2 sky130_fd_sc_hs__nand2b_1_51/Y sky130_fd_sc_hs__or2_1_23/X
+ VSS VDD sky130_fd_sc_hs__o2bb2ai_1
Xsky130_fd_sc_hs__o2bb2ai_1_44 VDD VSS sky130_fd_sc_hs__dfrtp_1_489/D sky130_fd_sc_hs__mux2i_1_6/Y
+ sky130_fd_sc_hs__o22ai_1_2/B2 sky130_fd_sc_hs__nand2b_1_51/Y sky130_fd_sc_hs__or2_1_23/X
+ VSS VDD sky130_fd_sc_hs__o2bb2ai_1
Xsky130_fd_sc_hs__o2bb2ai_1_55 VDD VSS sky130_fd_sc_hs__buf_1_108/A sky130_fd_sc_hs__nand4_1_5/C
+ sky130_fd_sc_hs__nand2_1_156/A sky130_fd_sc_hs__nand2_1_163/Y sky130_fd_sc_hs__nand2_1_125/Y
+ VSS VDD sky130_fd_sc_hs__o2bb2ai_1
Xsky130_fd_sc_hs__o2bb2ai_1_66 VDD VSS sky130_fd_sc_hs__dfrtp_1_501/D sky130_fd_sc_hs__mux2i_1_0/Y
+ sky130_fd_sc_hs__nor3_1_33/A sky130_fd_sc_hs__nand2b_1_51/Y sky130_fd_sc_hs__or2_1_23/X
+ VSS VDD sky130_fd_sc_hs__o2bb2ai_1
Xsky130_fd_sc_hs__dfrtp_1_703 sky130_fd_sc_hs__clkbuf_4_51/X VDD VSS sky130_fd_sc_hs__mux2_1_406/A0
+ sky130_fd_sc_hs__clkbuf_2_216/X sky130_fd_sc_hs__mux2_1_406/X VSS VDD sky130_fd_sc_hs__dfrtp_1
Xsky130_fd_sc_hs__dfrtp_1_714 sky130_fd_sc_hs__clkbuf_4_51/X VDD VSS sky130_fd_sc_hs__mux2_1_401/A1
+ sky130_fd_sc_hs__clkbuf_2_219/X sky130_fd_sc_hs__mux2_1_401/X VSS VDD sky130_fd_sc_hs__dfrtp_1
Xsky130_fd_sc_hs__dfrtp_1_725 sky130_fd_sc_hs__clkbuf_4_50/X VDD VSS sky130_fd_sc_hs__mux2_1_426/A0
+ sky130_fd_sc_hs__clkbuf_2_235/X sky130_fd_sc_hs__mux2_1_426/X VSS VDD sky130_fd_sc_hs__dfrtp_1
Xsky130_fd_sc_hs__dfrtp_1_736 sky130_fd_sc_hs__buf_8_34/X VDD VSS sky130_fd_sc_hs__mux2_1_438/A0
+ sky130_fd_sc_hs__clkbuf_2_228/X sky130_fd_sc_hs__mux2_1_438/X VSS VDD sky130_fd_sc_hs__dfrtp_1
Xsky130_fd_sc_hs__dfrtp_1_747 sky130_fd_sc_hs__clkbuf_4_51/X VDD VSS sky130_fd_sc_hs__mux2_1_455/A1
+ sky130_fd_sc_hs__clkbuf_2_234/X sky130_fd_sc_hs__mux2_1_455/X VSS VDD sky130_fd_sc_hs__dfrtp_1
Xsky130_fd_sc_hs__dfrtp_1_758 sky130_fd_sc_hs__buf_8_35/X VDD VSS sky130_fd_sc_hs__mux2_1_459/A0
+ sky130_fd_sc_hs__clkbuf_2_232/X sky130_fd_sc_hs__mux2_1_459/X VSS VDD sky130_fd_sc_hs__dfrtp_1
Xsky130_fd_sc_hs__dfrtp_1_769 sky130_fd_sc_hs__buf_8_30/X VDD VSS sky130_fd_sc_hs__mux2_1_470/A1
+ sky130_fd_sc_hs__clkinv_1_144/A sky130_fd_sc_hs__mux2_1_470/X VSS VDD sky130_fd_sc_hs__dfrtp_1
Xsky130_fd_sc_hs__buf_1_80 VDD VSS sky130_fd_sc_hs__buf_1_80/A sky130_fd_sc_hs__buf_1_80/X
+ VSS VDD sky130_fd_sc_hs__buf_1
Xsky130_fd_sc_hs__buf_1_91 VDD VSS sky130_fd_sc_hs__buf_1_91/A sky130_fd_sc_hs__buf_1_91/X
+ VSS VDD sky130_fd_sc_hs__buf_1
Xsky130_fd_sc_hs__nor2b_1_1 VDD VSS sky130_fd_sc_hs__nor3_1_2/A sky130_fd_sc_hs__nor3_1_3/A
+ sky130_fd_sc_hs__xnor2_1_5/A VSS VDD sky130_fd_sc_hs__nor2b_1
Xsky130_fd_sc_hs__xnor2_1_18 VDD VSS sky130_fd_sc_hs__maj3_1_2/A sky130_fd_sc_hs__o21a_1_5/B1
+ sky130_fd_sc_hs__maj3_1_2/B VSS VDD sky130_fd_sc_hs__xnor2_1
Xsky130_fd_sc_hs__xnor2_1_29 VDD VSS sky130_fd_sc_hs__maj3_1_7/A sky130_fd_sc_hs__xor2_1_14/B
+ sky130_fd_sc_hs__xor2_1_11/X VSS VDD sky130_fd_sc_hs__xnor2_1
Xsky130_fd_sc_hs__nand2_1_3 VDD VSS sky130_fd_sc_hs__nand2_1_4/Y sky130_fd_sc_hs__nand2_1_8/A
+ sky130_fd_sc_hs__nand2_1_3/A VSS VDD sky130_fd_sc_hs__nand2_1
Xsky130_fd_sc_hs__a311oi_1_10 VDD VSS sky130_fd_sc_hs__and2_1_28/X sky130_fd_sc_hs__or2_1_14/A
+ sky130_fd_sc_hs__and2_1_27/B sky130_fd_sc_hs__o21a_1_20/A1 sky130_fd_sc_hs__or2_1_18/X
+ sky130_fd_sc_hs__nor2_1_78/B VSS VDD sky130_fd_sc_hs__a311oi_1
Xsky130_fd_sc_hs__a211oi_1_9 VDD VSS sky130_fd_sc_hs__nand3_1_43/Y sky130_fd_sc_hs__a211oi_1_9/Y
+ sky130_fd_sc_hs__a222o_1_6/X sky130_fd_sc_hs__buf_16_7/X sky130_fd_sc_hs__mux2_1_373/A0
+ VSS VDD sky130_fd_sc_hs__a211oi_1
Xsky130_fd_sc_hs__clkbuf_16_12 VDD VSS sky130_fd_sc_hs__a22o_1_93/A2 sky130_fd_sc_hs__a22o_1_90/A2
+ VSS VDD sky130_fd_sc_hs__clkbuf_16
Xsky130_fd_sc_hs__clkbuf_16_23 VDD VSS sky130_fd_sc_hs__clkinv_2_11/A sky130_fd_sc_hs__clkbuf_8_19/X
+ VSS VDD sky130_fd_sc_hs__clkbuf_16
Xsky130_fd_sc_hs__dfrtp_1_500 sky130_fd_sc_hs__clkbuf_4_23/X VDD VSS sky130_fd_sc_hs__dfrtp_1_500/Q
+ sky130_fd_sc_hs__clkinv_1_106/A sky130_fd_sc_hs__dfrtp_1_500/D VSS VDD sky130_fd_sc_hs__dfrtp_1
Xsky130_fd_sc_hs__dfrtp_1_511 sky130_fd_sc_hs__clkbuf_4_22/A VDD VSS sky130_fd_sc_hs__mux2i_1_4/A1
+ sky130_fd_sc_hs__clkbuf_2_154/X sky130_fd_sc_hs__dfrtp_1_511/D VSS VDD sky130_fd_sc_hs__dfrtp_1
Xsky130_fd_sc_hs__dfrtp_1_522 sky130_fd_sc_hs__clkbuf_4_19/X VDD VSS sky130_fd_sc_hs__nor3_1_36/A
+ sky130_fd_sc_hs__clkinv_1_102/A sky130_fd_sc_hs__dfrtp_1_522/D VSS VDD sky130_fd_sc_hs__dfrtp_1
Xsky130_fd_sc_hs__dfrtp_1_533 sky130_fd_sc_hs__clkbuf_4_24/X VDD VSS sky130_fd_sc_hs__buf_1_138/A
+ sky130_fd_sc_hs__clkinv_1_111/A sky130_fd_sc_hs__o21ai_1_73/Y VSS VDD sky130_fd_sc_hs__dfrtp_1
Xsky130_fd_sc_hs__dfrtp_1_544 sky130_fd_sc_hs__clkbuf_4_28/X VDD VSS sky130_fd_sc_hs__mux2_1_462/A0
+ sky130_fd_sc_hs__clkinv_2_12/A sky130_fd_sc_hs__mux2_1_462/X VSS VDD sky130_fd_sc_hs__dfrtp_1
Xsky130_fd_sc_hs__dfrtp_1_555 sky130_fd_sc_hs__clkbuf_4_28/X VDD VSS sky130_fd_sc_hs__a222o_1_5/B2
+ sky130_fd_sc_hs__dfstp_1_3/CLK sky130_fd_sc_hs__mux2_1_270/X VSS VDD sky130_fd_sc_hs__dfrtp_1
Xsky130_fd_sc_hs__dfrtp_1_566 sky130_fd_sc_hs__clkbuf_4_28/X VDD VSS sky130_fd_sc_hs__mux2_1_272/A1
+ sky130_fd_sc_hs__clkinv_1_121/A sky130_fd_sc_hs__mux2_1_272/X VSS VDD sky130_fd_sc_hs__dfrtp_1
Xsky130_fd_sc_hs__dfrtp_1_577 sky130_fd_sc_hs__clkbuf_4_24/X VDD VSS sky130_fd_sc_hs__buf_1_162/A
+ sky130_fd_sc_hs__clkinv_1_127/A sky130_fd_sc_hs__dfrtp_1_577/D VSS VDD sky130_fd_sc_hs__dfrtp_1
Xsky130_fd_sc_hs__dfrtp_1_588 sky130_fd_sc_hs__buf_8_29/X VDD VSS sky130_fd_sc_hs__mux2_1_276/A1
+ sky130_fd_sc_hs__clkinv_1_125/A sky130_fd_sc_hs__mux2_1_276/X VSS VDD sky130_fd_sc_hs__dfrtp_1
Xsky130_fd_sc_hs__dfrtp_1_599 sky130_fd_sc_hs__clkbuf_4_30/X VDD VSS sky130_fd_sc_hs__mux2_1_300/A0
+ sky130_fd_sc_hs__clkbuf_2_179/X sky130_fd_sc_hs__mux2_1_300/X VSS VDD sky130_fd_sc_hs__dfrtp_1
Xsky130_fd_sc_hs__clkinv_2_11 VDD VSS sky130_fd_sc_hs__clkinv_2_11/Y sky130_fd_sc_hs__clkinv_2_11/A
+ VSS VDD sky130_fd_sc_hs__clkinv_2
Xsky130_fd_sc_hs__a21oi_1_40 VDD VSS sky130_fd_sc_hs__o21ai_1_18/Y sky130_fd_sc_hs__a21oi_1_40/Y
+ sky130_fd_sc_hs__xnor2_1_6/Y sky130_fd_sc_hs__buf_8_10/X VSS VDD sky130_fd_sc_hs__a21oi_1
Xsky130_fd_sc_hs__a21oi_1_51 VDD VSS sky130_fd_sc_hs__o21ai_1_7/B1 sky130_fd_sc_hs__a21oi_1_51/Y
+ sky130_fd_sc_hs__xnor2_1_33/Y sky130_fd_sc_hs__buf_1_22/X VSS VDD sky130_fd_sc_hs__a21oi_1
Xsky130_fd_sc_hs__a21oi_1_62 VDD VSS sky130_fd_sc_hs__nor2_1_48/A sky130_fd_sc_hs__o21a_1_16/B1
+ sky130_fd_sc_hs__nor2_1_57/Y sky130_fd_sc_hs__o21a_1_16/A1 VSS VDD sky130_fd_sc_hs__a21oi_1
Xsky130_fd_sc_hs__a21oi_1_73 VDD VSS sky130_fd_sc_hs__xor2_1_27/X sky130_fd_sc_hs__a21oi_1_73/Y
+ sky130_fd_sc_hs__a31o_1_2/A2 sky130_fd_sc_hs__a31o_1_2/A1 VSS VDD sky130_fd_sc_hs__a21oi_1
Xsky130_fd_sc_hs__a21oi_1_84 VDD VSS sky130_fd_sc_hs__a31o_1_9/A3 sky130_fd_sc_hs__a21oi_1_84/Y
+ sky130_fd_sc_hs__a31o_1_9/A2 sky130_fd_sc_hs__a31o_1_9/A1 VSS VDD sky130_fd_sc_hs__a21oi_1
Xsky130_fd_sc_hs__a21oi_1_95 VDD VSS sky130_fd_sc_hs__nor2b_1_23/Y sky130_fd_sc_hs__xor2_1_55/A
+ sky130_fd_sc_hs__and2_1_24/X sky130_fd_sc_hs__xnor2_1_81/A VSS VDD sky130_fd_sc_hs__a21oi_1
Xsky130_fd_sc_hs__dfrtp_1_60 sky130_fd_sc_hs__clkbuf_4_1/X VDD VSS sky130_fd_sc_hs__mux2_1_50/A1
+ sky130_fd_sc_hs__clkinv_1_8/A sky130_fd_sc_hs__mux2_1_50/X VSS VDD sky130_fd_sc_hs__dfrtp_1
Xsky130_fd_sc_hs__dfrtp_1_71 sky130_fd_sc_hs__buf_8_0/X VDD VSS sky130_fd_sc_hs__a22o_1_8/A1
+ sky130_fd_sc_hs__clkinv_1_11/A sky130_fd_sc_hs__mux2_1_72/X VSS VDD sky130_fd_sc_hs__dfrtp_1
Xsky130_fd_sc_hs__dfrtp_1_82 sky130_fd_sc_hs__clkbuf_4_12/A VDD VSS sky130_fd_sc_hs__buf_1_0/A
+ sky130_fd_sc_hs__clkbuf_2_13/X sky130_fd_sc_hs__a22o_1_4/X VSS VDD sky130_fd_sc_hs__dfrtp_1
Xsky130_fd_sc_hs__dfrtp_1_93 sky130_fd_sc_hs__clkbuf_4_0/X VDD VSS sky130_fd_sc_hs__mux2_1_86/A1
+ sky130_fd_sc_hs__clkinv_1_13/A sky130_fd_sc_hs__mux2_1_86/X VSS VDD sky130_fd_sc_hs__dfrtp_1
Xsky130_fd_sc_hs__a222oi_1_4 VDD VSS sky130_fd_sc_hs__nand2_1_33/B sky130_fd_sc_hs__mux2_1_111/A0
+ sky130_fd_sc_hs__a22o_1_8/B1 sky130_fd_sc_hs__a22oi_1_5/A2 sky130_fd_sc_hs__mux2_1_120/A0
+ sky130_fd_sc_hs__nand3_1_12/B sky130_fd_sc_hs__xor2_1_5/A VSS VDD sky130_fd_sc_hs__a222oi_1
Xsky130_fd_sc_hs__o31a_1_1 VDD VSS sky130_fd_sc_hs__buf_8_14/X sky130_fd_sc_hs__o31a_1_1/A2
+ sky130_fd_sc_hs__o31a_1_1/A1 sky130_fd_sc_hs__o31a_1_1/A3 sky130_fd_sc_hs__o31a_1_1/X
+ VSS VDD sky130_fd_sc_hs__o31a_1
Xsky130_fd_sc_hs__xor2_1_7 VDD VSS sky130_fd_sc_hs__xor2_1_7/A sky130_fd_sc_hs__xor2_1_7/B
+ sky130_fd_sc_hs__xor2_1_7/X VSS VDD sky130_fd_sc_hs__xor2_1
Xsky130_fd_sc_hs__dfrtp_1_330 sky130_fd_sc_hs__clkbuf_4_14/X VDD VSS sky130_fd_sc_hs__xor2_1_33/A
+ sky130_fd_sc_hs__clkinv_2_6/A sky130_fd_sc_hs__mux2_1_216/X VSS VDD sky130_fd_sc_hs__dfrtp_1
Xsky130_fd_sc_hs__dfrtp_1_341 sky130_fd_sc_hs__clkbuf_4_56/X VDD VSS sky130_fd_sc_hs__xor2_1_38/B
+ sky130_fd_sc_hs__clkinv_1_64/A sky130_fd_sc_hs__mux2_1_221/X VSS VDD sky130_fd_sc_hs__dfrtp_1
Xsky130_fd_sc_hs__dfrtp_1_352 sky130_fd_sc_hs__clkbuf_4_56/X VDD VSS sky130_fd_sc_hs__a22o_1_67/A1
+ sky130_fd_sc_hs__clkinv_1_69/A sky130_fd_sc_hs__a22o_1_53/X VSS VDD sky130_fd_sc_hs__dfrtp_1
Xsky130_fd_sc_hs__mux2_1_8 VDD VSS sky130_fd_sc_hs__mux2_1_8/X sky130_fd_sc_hs__mux2_1_8/S
+ sky130_fd_sc_hs__mux2_1_8/A0 sky130_fd_sc_hs__mux2_1_9/A1 VSS VDD sky130_fd_sc_hs__mux2_1
Xsky130_fd_sc_hs__dfrtp_1_363 sky130_fd_sc_hs__clkbuf_4_15/X VDD VSS sky130_fd_sc_hs__a22o_1_64/B2
+ sky130_fd_sc_hs__clkinv_1_73/A sky130_fd_sc_hs__a22o_1_64/X VSS VDD sky130_fd_sc_hs__dfrtp_1
Xsky130_fd_sc_hs__dfrtp_1_374 sky130_fd_sc_hs__clkbuf_4_56/X VDD VSS sky130_fd_sc_hs__a22o_1_56/B2
+ sky130_fd_sc_hs__clkbuf_2_102/X sky130_fd_sc_hs__a22o_1_56/X VSS VDD sky130_fd_sc_hs__dfrtp_1
Xsky130_fd_sc_hs__dfrtp_1_385 sky130_fd_sc_hs__buf_8_7/A VDD VSS sky130_fd_sc_hs__maj3_1_16/C
+ sky130_fd_sc_hs__clkinv_2_8/A sky130_fd_sc_hs__a22o_1_36/X VSS VDD sky130_fd_sc_hs__dfrtp_1
Xsky130_fd_sc_hs__dfrtp_1_396 sky130_fd_sc_hs__buf_8_7/X VDD VSS sky130_fd_sc_hs__maj3_1_14/C
+ sky130_fd_sc_hs__clkinv_1_54/A sky130_fd_sc_hs__a22o_1_35/X VSS VDD sky130_fd_sc_hs__dfrtp_1
Xsky130_fd_sc_hs__dlygate4sd3_1_4 VSS VDD raw_bits_i[5] sky130_fd_sc_hs__buf_1_68/A
+ VSS VDD sky130_fd_sc_hs__dlygate4sd3_1
Xsky130_fd_sc_hs__and3_1_9 VDD VSS sky130_fd_sc_hs__and3_1_9/A sky130_fd_sc_hs__and3_1_9/B
+ sky130_fd_sc_hs__and3_1_9/C sky130_fd_sc_hs__and3_1_9/X VSS VDD sky130_fd_sc_hs__and3_1
Xsky130_fd_sc_hs__a21oi_1_9 VDD VSS sky130_fd_sc_hs__nand3_1_6/Y sky130_fd_sc_hs__nand3_1_7/C
+ sky130_fd_sc_hs__buf_16_9/X sky130_fd_sc_hs__mux2_1_54/A1 VSS VDD sky130_fd_sc_hs__a21oi_1
Xsky130_fd_sc_hs__buf_16_10 sky130_fd_sc_hs__mux2_1_98/S VDD VSS sky130_fd_sc_hs__buf_16_10/A
+ VSS VDD sky130_fd_sc_hs__buf_16
Xsky130_fd_sc_hs__clkbuf_4_40 VDD VSS sky130_fd_sc_hs__nor3b_4_0/Y sky130_fd_sc_hs__a22o_1_8/B1
+ VSS VDD sky130_fd_sc_hs__clkbuf_4
Xsky130_fd_sc_hs__clkbuf_4_51 VDD VSS sky130_fd_sc_hs__buf_8_34/A sky130_fd_sc_hs__clkbuf_4_51/X
+ VSS VDD sky130_fd_sc_hs__clkbuf_4
Xsky130_fd_sc_hs__mux2_1_301 VDD VSS sky130_fd_sc_hs__mux2_1_301/X sky130_fd_sc_hs__buf_8_27/X
+ sky130_fd_sc_hs__mux2_1_301/A0 sky130_fd_sc_hs__mux2_1_473/A1 VSS VDD sky130_fd_sc_hs__mux2_1
Xsky130_fd_sc_hs__mux2_1_312 VDD VSS sky130_fd_sc_hs__mux2_1_312/X sky130_fd_sc_hs__buf_16_3/A
+ sky130_fd_sc_hs__a22o_1_67/B2 sky130_fd_sc_hs__mux2_1_312/A1 VSS VDD sky130_fd_sc_hs__mux2_1
Xsky130_fd_sc_hs__mux2_1_323 VDD VSS sky130_fd_sc_hs__mux2_1_323/X sky130_fd_sc_hs__buf_8_24/X
+ sky130_fd_sc_hs__a22o_1_67/B2 sky130_fd_sc_hs__nand2_1_200/A VSS VDD sky130_fd_sc_hs__mux2_1
Xsky130_fd_sc_hs__mux2_1_334 VDD VSS sky130_fd_sc_hs__mux2_1_334/X sky130_fd_sc_hs__buf_16_4/A
+ sky130_fd_sc_hs__mux2_1_334/A0 sky130_fd_sc_hs__a22o_1_95/B2 VSS VDD sky130_fd_sc_hs__mux2_1
Xsky130_fd_sc_hs__mux2_1_345 VDD VSS sky130_fd_sc_hs__mux2_1_345/X sky130_fd_sc_hs__buf_16_14/A
+ sky130_fd_sc_hs__mux2_1_345/A0 sky130_fd_sc_hs__a22o_1_95/B2 VSS VDD sky130_fd_sc_hs__mux2_1
Xsky130_fd_sc_hs__mux2_1_356 VDD VSS sky130_fd_sc_hs__mux2_1_356/X sky130_fd_sc_hs__mux2_1_5/S
+ sky130_fd_sc_hs__mux2_1_356/A0 sky130_fd_sc_hs__dfrtp_2_3/Q VSS VDD sky130_fd_sc_hs__mux2_1
Xsky130_fd_sc_hs__mux2_1_367 VDD VSS sky130_fd_sc_hs__mux2_1_367/X sky130_fd_sc_hs__mux2_1_464/S
+ sky130_fd_sc_hs__dfrtp_2_1/Q sky130_fd_sc_hs__mux2_1_367/A1 VSS VDD sky130_fd_sc_hs__mux2_1
Xsky130_fd_sc_hs__mux2_1_378 VDD VSS sky130_fd_sc_hs__mux2_1_378/X sky130_fd_sc_hs__buf_16_5/A
+ sky130_fd_sc_hs__mux2_1_378/A0 sky130_fd_sc_hs__a22o_1_89/B2 VSS VDD sky130_fd_sc_hs__mux2_1
Xsky130_fd_sc_hs__mux2_1_389 VDD VSS sky130_fd_sc_hs__mux2_1_389/X sky130_fd_sc_hs__buf_16_13/A
+ sky130_fd_sc_hs__xor2_1_88/B sky130_fd_sc_hs__a22o_1_92/B2 VSS VDD sky130_fd_sc_hs__mux2_1
Xsky130_fd_sc_hs__xor2_1_12 VDD VSS sky130_fd_sc_hs__maj3_1_8/B sky130_fd_sc_hs__maj3_1_8/C
+ sky130_fd_sc_hs__xor2_1_12/X VSS VDD sky130_fd_sc_hs__xor2_1
Xsky130_fd_sc_hs__xor2_1_23 VDD VSS sky130_fd_sc_hs__and3_1_6/A sky130_fd_sc_hs__and3_1_6/B
+ sky130_fd_sc_hs__xor2_1_23/X VSS VDD sky130_fd_sc_hs__xor2_1
Xsky130_fd_sc_hs__xor2_1_34 VDD VSS sky130_fd_sc_hs__xor2_1_34/A sky130_fd_sc_hs__xor2_1_34/B
+ sky130_fd_sc_hs__xor2_1_34/X VSS VDD sky130_fd_sc_hs__xor2_1
Xsky130_fd_sc_hs__xor2_1_45 VDD VSS sky130_fd_sc_hs__xor2_1_45/A sky130_fd_sc_hs__or2_1_12/B
+ sky130_fd_sc_hs__xor2_1_45/X VSS VDD sky130_fd_sc_hs__xor2_1
Xsky130_fd_sc_hs__xor2_1_56 VDD VSS sky130_fd_sc_hs__xor2_1_56/A sky130_fd_sc_hs__xor2_1_56/B
+ sky130_fd_sc_hs__xor2_1_56/X VSS VDD sky130_fd_sc_hs__xor2_1
Xsky130_fd_sc_hs__xor2_1_67 VDD VSS sky130_fd_sc_hs__xor2_1_67/A sky130_fd_sc_hs__xor2_1_67/B
+ sky130_fd_sc_hs__xor2_1_67/X VSS VDD sky130_fd_sc_hs__xor2_1
Xsky130_fd_sc_hs__xor2_1_78 VDD VSS sky130_fd_sc_hs__xor2_1_78/A sky130_fd_sc_hs__xor2_1_78/B
+ sky130_fd_sc_hs__xor2_1_78/X VSS VDD sky130_fd_sc_hs__xor2_1
Xsky130_fd_sc_hs__xor2_1_89 VDD VSS sky130_fd_sc_hs__xor2_1_89/A sky130_fd_sc_hs__xor2_1_89/B
+ sky130_fd_sc_hs__xor2_1_89/X VSS VDD sky130_fd_sc_hs__xor2_1
Xsky130_fd_sc_hs__nand2b_1_14 VDD VSS sky130_fd_sc_hs__or2_1_9/A sky130_fd_sc_hs__nor3_1_15/C
+ sky130_fd_sc_hs__a32o_1_3/A2 VSS VDD sky130_fd_sc_hs__nand2b_1
Xsky130_fd_sc_hs__nand2b_1_25 VDD VSS sky130_fd_sc_hs__nor2b_1_18/Y sky130_fd_sc_hs__o21ai_1_39/B1
+ sky130_fd_sc_hs__xnor2_1_73/B VSS VDD sky130_fd_sc_hs__nand2b_1
Xsky130_fd_sc_hs__nand2b_1_36 VDD VSS sky130_fd_sc_hs__maj3_1_39/X sky130_fd_sc_hs__xnor2_1_90/Y
+ sky130_fd_sc_hs__and2_1_26/A VSS VDD sky130_fd_sc_hs__nand2b_1
Xsky130_fd_sc_hs__nand2b_1_47 VDD VSS sky130_fd_sc_hs__xor2_1_73/B sky130_fd_sc_hs__xor2_1_73/A
+ sky130_fd_sc_hs__o21a_1_22/B1 VSS VDD sky130_fd_sc_hs__nand2b_1
Xsky130_fd_sc_hs__nand2b_1_58 VDD VSS sky130_fd_sc_hs__nor2b_1_45/A sky130_fd_sc_hs__xnor2_1_119/Y
+ sky130_fd_sc_hs__or2_1_24/B VSS VDD sky130_fd_sc_hs__nand2b_1
Xsky130_fd_sc_hs__nand2b_1_5 VDD VSS sky130_fd_sc_hs__maj3_1_4/X sky130_fd_sc_hs__nor2b_1_3/A
+ sky130_fd_sc_hs__a31o_1_1/A1 VSS VDD sky130_fd_sc_hs__nand2b_1
Xsky130_fd_sc_hs__a221oi_1_3 VDD VSS sky130_fd_sc_hs__nand2_1_16/Y sky130_fd_sc_hs__and3_1_4/B
+ sky130_fd_sc_hs__mux2_1_121/A0 sky130_fd_sc_hs__nand2_1_33/B sky130_fd_sc_hs__mux2_1_71/A0
+ sky130_fd_sc_hs__a22oi_1_5/A2 VSS VDD sky130_fd_sc_hs__a221oi_1
Xsky130_fd_sc_hs__dfrtp_1_160 sky130_fd_sc_hs__clkbuf_4_5/X VDD VSS sky130_fd_sc_hs__mux2_1_147/A1
+ sky130_fd_sc_hs__clkinv_1_39/A sky130_fd_sc_hs__mux2_1_147/X VSS VDD sky130_fd_sc_hs__dfrtp_1
Xsky130_fd_sc_hs__dfrtp_1_171 sky130_fd_sc_hs__clkbuf_4_10/X VDD VSS sky130_fd_sc_hs__buf_1_59/A
+ sky130_fd_sc_hs__clkinv_1_41/A sky130_fd_sc_hs__mux2_1_162/X VSS VDD sky130_fd_sc_hs__dfrtp_1
Xsky130_fd_sc_hs__dfrtp_1_182 sky130_fd_sc_hs__clkbuf_4_10/X VDD VSS sky130_fd_sc_hs__buf_1_58/A
+ sky130_fd_sc_hs__clkinv_1_41/A sky130_fd_sc_hs__a21oi_1_47/Y VSS VDD sky130_fd_sc_hs__dfrtp_1
Xsky130_fd_sc_hs__dfrtp_1_193 sky130_fd_sc_hs__clkbuf_4_10/X VDD VSS sky130_fd_sc_hs__mux2_1_145/A0
+ sky130_fd_sc_hs__clkinv_1_38/A sky130_fd_sc_hs__mux2_1_145/X VSS VDD sky130_fd_sc_hs__dfrtp_1
Xsky130_fd_sc_hs__a221o_1_0 VDD VSS sky130_fd_sc_hs__a221o_1_0/X sky130_fd_sc_hs__nor3_1_26/Y
+ sky130_fd_sc_hs__buf_8_14/X sky130_fd_sc_hs__buf_8_13/X sky130_fd_sc_hs__maj3_1_38/C
+ sky130_fd_sc_hs__a221o_1_0/B1 VSS VDD sky130_fd_sc_hs__a221o_1
Xsky130_fd_sc_hs__o21a_1_0 VDD VSS sky130_fd_sc_hs__o21a_1_0/X sky130_fd_sc_hs__nor2_1_8/Y
+ sky130_fd_sc_hs__nor2_1_2/A sky130_fd_sc_hs__o21a_1_0/A1 VSS VDD sky130_fd_sc_hs__o21a_1
Xsky130_fd_sc_hs__a32o_1_5 VDD VSS sky130_fd_sc_hs__a32o_1_5/X sky130_fd_sc_hs__maj3_1_12/C
+ sky130_fd_sc_hs__a32o_1_7/B1 sky130_fd_sc_hs__a32o_1_5/A2 sky130_fd_sc_hs__buf_8_14/X
+ sky130_fd_sc_hs__a32o_1_5/A3 VSS VDD sky130_fd_sc_hs__a32o_1
Xsky130_fd_sc_hs__clkinv_1_1 VDD VSS sky130_fd_sc_hs__maj3_1_0/A sky130_fd_sc_hs__xnor2_1_2/A
+ VSS VDD sky130_fd_sc_hs__clkinv_1
Xsky130_fd_sc_hs__nor2_1_180 VDD VSS sky130_fd_sc_hs__nor2_1_181/Y sky130_fd_sc_hs__nor2_1_182/A
+ sky130_fd_sc_hs__nor2_1_180/A VSS VDD sky130_fd_sc_hs__nor2_1
Xsky130_fd_sc_hs__xnor3_1_0 VDD VSS sky130_fd_sc_hs__xnor3_1_0/X sky130_fd_sc_hs__xnor3_1_0/B
+ sky130_fd_sc_hs__xnor3_1_0/C sky130_fd_sc_hs__maj3_1_8/A VSS VDD sky130_fd_sc_hs__xnor3_1
Xsky130_fd_sc_hs__mux2_1_120 VDD VSS sky130_fd_sc_hs__mux2_1_120/X sky130_fd_sc_hs__buf_16_5/X
+ sky130_fd_sc_hs__mux2_1_120/A0 sky130_fd_sc_hs__a22o_1_61/B2 VSS VDD sky130_fd_sc_hs__mux2_1
Xsky130_fd_sc_hs__mux2_1_131 VDD VSS sky130_fd_sc_hs__mux2_1_131/X sky130_fd_sc_hs__buf_8_3/X
+ sky130_fd_sc_hs__buf_1_26/A sky130_fd_sc_hs__mux2_1_99/A0 VSS VDD sky130_fd_sc_hs__mux2_1
Xsky130_fd_sc_hs__mux2_1_142 VDD VSS sky130_fd_sc_hs__mux2_1_142/X sky130_fd_sc_hs__buf_16_0/X
+ sky130_fd_sc_hs__maj3_1_8/C sky130_fd_sc_hs__a22o_1_60/B2 VSS VDD sky130_fd_sc_hs__mux2_1
Xsky130_fd_sc_hs__mux2_1_153 VDD VSS sky130_fd_sc_hs__mux2_1_153/X sky130_fd_sc_hs__mux2_1_4/S
+ sky130_fd_sc_hs__a22o_1_75/B2 sky130_fd_sc_hs__mux2_1_153/A1 VSS VDD sky130_fd_sc_hs__mux2_1
Xsky130_fd_sc_hs__mux2_1_164 VDD VSS sky130_fd_sc_hs__mux2_1_164/X sky130_fd_sc_hs__mux2_1_99/S
+ sky130_fd_sc_hs__a22o_1_75/B2 sky130_fd_sc_hs__mux2_1_164/A1 VSS VDD sky130_fd_sc_hs__mux2_1
Xsky130_fd_sc_hs__mux2_1_175 VDD VSS sky130_fd_sc_hs__mux2_1_175/X sky130_fd_sc_hs__mux2_1_6/S
+ sky130_fd_sc_hs__a22o_1_40/B2 sky130_fd_sc_hs__mux2_1_175/A1 VSS VDD sky130_fd_sc_hs__mux2_1
Xsky130_fd_sc_hs__mux2_1_186 VDD VSS sky130_fd_sc_hs__mux2_1_186/X sky130_fd_sc_hs__nor2_1_42/Y
+ sky130_fd_sc_hs__buf_1_12/A sky130_fd_sc_hs__o41ai_1_0/A4 VSS VDD sky130_fd_sc_hs__mux2_1
Xsky130_fd_sc_hs__mux2_1_197 VDD VSS sky130_fd_sc_hs__mux2_1_197/X sky130_fd_sc_hs__nor2_1_66/B
+ sky130_fd_sc_hs__xor2_1_32/B sky130_fd_sc_hs__o21a_1_4/X VSS VDD sky130_fd_sc_hs__mux2_1
Xsky130_fd_sc_hs__buf_1_3 VDD VSS sky130_fd_sc_hs__buf_1_3/A srm_count_shortfall VSS
+ VDD sky130_fd_sc_hs__buf_1
Xsky130_fd_sc_hs__buf_1_101 VDD VSS sky130_fd_sc_hs__buf_1_101/A dac_p_force[3] VSS
+ VDD sky130_fd_sc_hs__buf_1
Xsky130_fd_sc_hs__buf_1_112 VDD VSS sky130_fd_sc_hs__buf_1_112/A dac_n_force[5] VSS
+ VDD sky130_fd_sc_hs__buf_1
Xsky130_fd_sc_hs__buf_1_123 VDD VSS sky130_fd_sc_hs__o22ai_1_6/Y dac_p_force[1] VSS
+ VDD sky130_fd_sc_hs__buf_1
Xsky130_fd_sc_hs__buf_1_134 VDD VSS sky130_fd_sc_hs__buf_1_134/A w_wr_addr[0] VSS
+ VDD sky130_fd_sc_hs__buf_1
Xsky130_fd_sc_hs__buf_1_145 VDD VSS sky130_fd_sc_hs__buf_1_145/A raw_code_o[16] VSS
+ VDD sky130_fd_sc_hs__buf_1
Xsky130_fd_sc_hs__buf_1_156 VDD VSS sky130_fd_sc_hs__buf_1_156/A calib_done_pulse
+ VSS VDD sky130_fd_sc_hs__buf_1
Xsky130_fd_sc_hs__buf_1_167 VDD VSS sky130_fd_sc_hs__buf_1_167/A raw_code_o[7] VSS
+ VDD sky130_fd_sc_hs__buf_1
Xsky130_fd_sc_hs__buf_1_178 VDD VSS sky130_fd_sc_hs__buf_1_178/A calib_overrange_bits[14]
+ VSS VDD sky130_fd_sc_hs__buf_1
Xsky130_fd_sc_hs__buf_1_189 VDD VSS sky130_fd_sc_hs__buf_8_6/A sky130_fd_sc_hs__buf_8_9/A
+ VSS VDD sky130_fd_sc_hs__buf_1
Xsky130_fd_sc_hs__mux2i_1_3 VDD VSS sky130_fd_sc_hs__nor3b_1_0/Y sky130_fd_sc_hs__or2_1_22/B
+ sky130_fd_sc_hs__mux2i_1_3/A0 sky130_fd_sc_hs__mux2i_1_3/Y VSS VDD sky130_fd_sc_hs__mux2i_1
Xsky130_fd_sc_hs__a2111oi_1_2 VDD VSS sky130_fd_sc_hs__a222o_1_5/X sky130_fd_sc_hs__nand2_1_204/Y
+ sky130_fd_sc_hs__nand2_1_202/Y sky130_fd_sc_hs__buf_8_33/X sky130_fd_sc_hs__mux2_1_354/A0
+ sky130_fd_sc_hs__nand2_1_196/B VSS VDD sky130_fd_sc_hs__a2111oi_1
Xsky130_fd_sc_hs__a21oi_1_204 VDD VSS sky130_fd_sc_hs__nor2_1_180/A sky130_fd_sc_hs__nor3_1_53/C
+ sky130_fd_sc_hs__nor2_1_183/B sky130_fd_sc_hs__nor2_1_183/A VSS VDD sky130_fd_sc_hs__a21oi_1
Xsky130_fd_sc_hs__o211ai_1_5 VDD VSS sky130_fd_sc_hs__nand2_1_85/A sky130_fd_sc_hs__o211ai_1_5/Y
+ sky130_fd_sc_hs__nand2_1_79/Y sky130_fd_sc_hs__nor2_1_68/Y sky130_fd_sc_hs__or2_1_13/B
+ VSS VDD sky130_fd_sc_hs__o211ai_1
Xsky130_fd_sc_hs__a31oi_1_3 VDD VSS sky130_fd_sc_hs__a31oi_1_3/Y sky130_fd_sc_hs__o311ai_1_3/Y
+ sky130_fd_sc_hs__nor2b_1_9/A sky130_fd_sc_hs__nand3_1_14/Y sky130_fd_sc_hs__and2_1_10/B
+ VSS VDD sky130_fd_sc_hs__a31oi_1
Xsky130_fd_sc_hs__clkbuf_2_220 VDD VSS sky130_fd_sc_hs__dfstp_1_4/CLK sky130_fd_sc_hs__clkbuf_8_17/A
+ VSS VDD sky130_fd_sc_hs__clkbuf_2
Xsky130_fd_sc_hs__clkbuf_2_231 VDD VSS sky130_fd_sc_hs__clkbuf_2_231/X sky130_fd_sc_hs__clkbuf_8_17/A
+ VSS VDD sky130_fd_sc_hs__clkbuf_2
Xsky130_fd_sc_hs__clkbuf_2_242 VDD VSS sky130_fd_sc_hs__buf_8_38/A sky130_fd_sc_hs__buf_1_74/X
+ VSS VDD sky130_fd_sc_hs__clkbuf_2
Xsky130_fd_sc_hs__o2111ai_1_5 VDD VSS sky130_fd_sc_hs__nor3_1_43/A sky130_fd_sc_hs__o211ai_1_11/Y
+ sky130_fd_sc_hs__nand2_1_160/Y sky130_fd_sc_hs__nand2_1_156/Y sky130_fd_sc_hs__nor2_1_150/B
+ sky130_fd_sc_hs__o22ai_1_8/A1 VSS VDD sky130_fd_sc_hs__o2111ai_1
Xsky130_fd_sc_hs__nand2_1_220 VDD VSS sky130_fd_sc_hs__a222o_1_2/A2 sky130_fd_sc_hs__nand4_1_14/A
+ sky130_fd_sc_hs__nand2_1_220/A VSS VDD sky130_fd_sc_hs__nand2_1
Xsky130_fd_sc_hs__nand2_1_231 VDD VSS sky130_fd_sc_hs__nand2_1_33/Y sky130_fd_sc_hs__nand2_1_231/Y
+ sky130_fd_sc_hs__nand3_1_39/Y VSS VDD sky130_fd_sc_hs__nand2_1
Xsky130_fd_sc_hs__a22o_1_4 VDD VSS sky130_fd_sc_hs__a22o_1_4/X sky130_fd_sc_hs__nor3_1_2/A
+ sky130_fd_sc_hs__a22o_1_6/B1 sky130_fd_sc_hs__nand2_1_9/B sky130_fd_sc_hs__buf_1_0/A
+ VSS VDD sky130_fd_sc_hs__a22o_1
Xsky130_fd_sc_hs__o2bb2ai_1_12 VDD VSS sky130_fd_sc_hs__dfrtp_1_240/D sky130_fd_sc_hs__and3_1_6/B
+ sky130_fd_sc_hs__dfrtp_1_240/Q sky130_fd_sc_hs__nor3_1_15/A sky130_fd_sc_hs__nor2_1_48/Y
+ VSS VDD sky130_fd_sc_hs__o2bb2ai_1
Xsky130_fd_sc_hs__o2bb2ai_1_23 VDD VSS sky130_fd_sc_hs__dfrtp_1_339/D sky130_fd_sc_hs__a31o_1_5/X
+ sky130_fd_sc_hs__maj3_1_24/C sky130_fd_sc_hs__a21oi_1_79/Y sky130_fd_sc_hs__a32o_1_7/B1
+ VSS VDD sky130_fd_sc_hs__o2bb2ai_1
Xsky130_fd_sc_hs__o2bb2ai_1_34 VDD VSS sky130_fd_sc_hs__dfrtp_1_498/D sky130_fd_sc_hs__mux2i_1_1/Y
+ sky130_fd_sc_hs__nor2_1_150/A sky130_fd_sc_hs__nand2b_1_51/Y sky130_fd_sc_hs__or2_1_23/X
+ VSS VDD sky130_fd_sc_hs__o2bb2ai_1
Xsky130_fd_sc_hs__o2bb2ai_1_45 VDD VSS sky130_fd_sc_hs__dfrtp_1_502/D sky130_fd_sc_hs__mux2i_1_13/Y
+ sky130_fd_sc_hs__nor3_1_41/A sky130_fd_sc_hs__nand2b_1_51/Y sky130_fd_sc_hs__or2_1_23/X
+ VSS VDD sky130_fd_sc_hs__o2bb2ai_1
Xsky130_fd_sc_hs__o2bb2ai_1_56 VDD VSS sky130_fd_sc_hs__buf_1_122/A sky130_fd_sc_hs__nand2_1_166/Y
+ sky130_fd_sc_hs__o22ai_1_2/A1 sky130_fd_sc_hs__nand4_1_5/D sky130_fd_sc_hs__buf_8_20/X
+ VSS VDD sky130_fd_sc_hs__o2bb2ai_1
Xsky130_fd_sc_hs__o2bb2ai_1_67 VDD VSS sky130_fd_sc_hs__dfrtp_1_559/D sky130_fd_sc_hs__nor3_1_48/A
+ sky130_fd_sc_hs__or2_1_21/A sky130_fd_sc_hs__or3_1_6/A sky130_fd_sc_hs__nand4_1_4/Y
+ VSS VDD sky130_fd_sc_hs__o2bb2ai_1
Xsky130_fd_sc_hs__nand3_1_40 VDD VSS sky130_fd_sc_hs__a41o_1_0/A4 sky130_fd_sc_hs__nor3b_1_4/A
+ sky130_fd_sc_hs__a41o_1_0/A3 sky130_fd_sc_hs__a41o_1_0/A1 VSS VDD sky130_fd_sc_hs__nand3_1
Xsky130_fd_sc_hs__dfrtp_1_704 sky130_fd_sc_hs__clkbuf_4_51/X VDD VSS sky130_fd_sc_hs__mux2_1_407/A1
+ sky130_fd_sc_hs__clkbuf_2_218/X sky130_fd_sc_hs__mux2_1_407/X VSS VDD sky130_fd_sc_hs__dfrtp_1
Xsky130_fd_sc_hs__dfrtp_1_715 sky130_fd_sc_hs__clkbuf_4_50/X VDD VSS sky130_fd_sc_hs__mux2_1_430/A0
+ sky130_fd_sc_hs__dfstp_1_4/CLK sky130_fd_sc_hs__mux2_1_430/X VSS VDD sky130_fd_sc_hs__dfrtp_1
Xsky130_fd_sc_hs__dfrtp_1_726 sky130_fd_sc_hs__clkbuf_4_50/X VDD VSS sky130_fd_sc_hs__mux2_1_422/A1
+ sky130_fd_sc_hs__clkbuf_2_222/X sky130_fd_sc_hs__mux2_1_422/X VSS VDD sky130_fd_sc_hs__dfrtp_1
Xsky130_fd_sc_hs__dfrtp_1_737 sky130_fd_sc_hs__buf_8_34/X VDD VSS sky130_fd_sc_hs__mux2_1_437/A1
+ sky130_fd_sc_hs__clkbuf_2_229/X sky130_fd_sc_hs__mux2_1_437/X VSS VDD sky130_fd_sc_hs__dfrtp_1
Xsky130_fd_sc_hs__dfrtp_1_748 sky130_fd_sc_hs__clkbuf_4_51/X VDD VSS sky130_fd_sc_hs__mux2_1_453/A1
+ sky130_fd_sc_hs__clkbuf_2_234/X sky130_fd_sc_hs__mux2_1_453/X VSS VDD sky130_fd_sc_hs__dfrtp_1
Xsky130_fd_sc_hs__dfrtp_1_759 sky130_fd_sc_hs__buf_8_35/X VDD VSS sky130_fd_sc_hs__mux2_1_461/A0
+ sky130_fd_sc_hs__clkbuf_2_231/X sky130_fd_sc_hs__mux2_1_461/X VSS VDD sky130_fd_sc_hs__dfrtp_1
Xsky130_fd_sc_hs__buf_1_70 VDD VSS sky130_fd_sc_hs__buf_1_70/A sky130_fd_sc_hs__buf_1_70/X
+ VSS VDD sky130_fd_sc_hs__buf_1
Xsky130_fd_sc_hs__buf_1_81 VDD VSS sky130_fd_sc_hs__buf_1_81/A sky130_fd_sc_hs__buf_1_81/X
+ VSS VDD sky130_fd_sc_hs__buf_1
Xsky130_fd_sc_hs__buf_1_92 VDD VSS sky130_fd_sc_hs__buf_1_92/A sky130_fd_sc_hs__buf_1_92/X
+ VSS VDD sky130_fd_sc_hs__buf_1
Xsky130_fd_sc_hs__nor2b_1_2 VDD VSS sky130_fd_sc_hs__maj3_1_1/X sky130_fd_sc_hs__nor2b_1_2/Y
+ sky130_fd_sc_hs__xnor2_1_9/B VSS VDD sky130_fd_sc_hs__nor2b_1
Xsky130_fd_sc_hs__xnor2_1_19 VDD VSS sky130_fd_sc_hs__xor2_1_6/X sky130_fd_sc_hs__xnor2_1_19/Y
+ sky130_fd_sc_hs__or2_1_2/X VSS VDD sky130_fd_sc_hs__xnor2_1
Xsky130_fd_sc_hs__nand2_1_4 VDD VSS sky130_fd_sc_hs__nor2_1_7/A sky130_fd_sc_hs__nand2_1_4/Y
+ sky130_fd_sc_hs__xor2_1_0/A VSS VDD sky130_fd_sc_hs__nand2_1
Xsky130_fd_sc_hs__a311oi_1_11 VDD VSS sky130_fd_sc_hs__nor2_1_99/Y sky130_fd_sc_hs__a21oi_1_183/Y
+ sky130_fd_sc_hs__a31o_1_14/A3 sky130_fd_sc_hs__xnor2_1_122/Y sky130_fd_sc_hs__maj3_1_68/X
+ sky130_fd_sc_hs__xnor2_1_91/A VSS VDD sky130_fd_sc_hs__a311oi_1
Xsky130_fd_sc_hs__clkbuf_16_13 VDD VSS sky130_fd_sc_hs__a22o_1_93/B1 sky130_fd_sc_hs__a22o_1_90/B1
+ VSS VDD sky130_fd_sc_hs__clkbuf_16
Xsky130_fd_sc_hs__clkbuf_16_24 VDD VSS sky130_fd_sc_hs__clkbuf_8_17/A sky130_fd_sc_hs__clkbuf_8_19/X
+ VSS VDD sky130_fd_sc_hs__clkbuf_16
Xsky130_fd_sc_hs__nor2_1_0 VDD VSS sky130_fd_sc_hs__nor2_1_8/A sky130_fd_sc_hs__nor2_1_0/Y
+ sky130_fd_sc_hs__nor2_1_2/A VSS VDD sky130_fd_sc_hs__nor2_1
Xsky130_fd_sc_hs__dfrtp_1_501 sky130_fd_sc_hs__clkbuf_4_23/X VDD VSS sky130_fd_sc_hs__nor3_1_33/A
+ sky130_fd_sc_hs__clkinv_1_103/A sky130_fd_sc_hs__dfrtp_1_501/D VSS VDD sky130_fd_sc_hs__dfrtp_1
Xsky130_fd_sc_hs__dfrtp_1_512 sky130_fd_sc_hs__clkbuf_4_22/A VDD VSS sky130_fd_sc_hs__nor3_1_32/A
+ sky130_fd_sc_hs__clkbuf_2_155/X sky130_fd_sc_hs__dfrtp_1_512/D VSS VDD sky130_fd_sc_hs__dfrtp_1
Xsky130_fd_sc_hs__dfrtp_1_523 sky130_fd_sc_hs__clkbuf_4_22/X VDD VSS sky130_fd_sc_hs__maj3_1_38/C
+ sky130_fd_sc_hs__clkinv_1_94/A sky130_fd_sc_hs__a221o_1_0/X VSS VDD sky130_fd_sc_hs__dfrtp_1
Xsky130_fd_sc_hs__dfrtp_1_534 sky130_fd_sc_hs__clkbuf_4_24/X VDD VSS sky130_fd_sc_hs__buf_1_143/A
+ sky130_fd_sc_hs__clkinv_1_111/A sky130_fd_sc_hs__o21ai_1_83/Y VSS VDD sky130_fd_sc_hs__dfrtp_1
Xsky130_fd_sc_hs__dfrtp_1_545 sky130_fd_sc_hs__clkbuf_4_28/X VDD VSS sky130_fd_sc_hs__mux2_1_263/A1
+ sky130_fd_sc_hs__clkinv_1_114/A sky130_fd_sc_hs__mux2_1_263/X VSS VDD sky130_fd_sc_hs__dfrtp_1
Xsky130_fd_sc_hs__dfrtp_1_556 sky130_fd_sc_hs__clkbuf_4_28/X VDD VSS sky130_fd_sc_hs__mux2_1_274/A0
+ sky130_fd_sc_hs__clkinv_1_121/A sky130_fd_sc_hs__mux2_1_274/X VSS VDD sky130_fd_sc_hs__dfrtp_1
Xsky130_fd_sc_hs__dfrtp_1_567 sky130_fd_sc_hs__clkbuf_4_24/X VDD VSS sky130_fd_sc_hs__buf_1_158/A
+ sky130_fd_sc_hs__clkbuf_2_171/X sky130_fd_sc_hs__buf_8_3/A VSS VDD sky130_fd_sc_hs__dfrtp_1
Xsky130_fd_sc_hs__dfrtp_1_578 sky130_fd_sc_hs__clkbuf_4_24/X VDD VSS sky130_fd_sc_hs__buf_1_47/A
+ sky130_fd_sc_hs__clkbuf_2_171/X sky130_fd_sc_hs__dfrtp_1_578/D VSS VDD sky130_fd_sc_hs__dfrtp_1
Xsky130_fd_sc_hs__dfrtp_1_589 sky130_fd_sc_hs__clkbuf_4_28/X VDD VSS sky130_fd_sc_hs__a222o_1_5/A1
+ sky130_fd_sc_hs__dfstp_1_1/CLK sky130_fd_sc_hs__mux2_1_271/X VSS VDD sky130_fd_sc_hs__dfrtp_1
Xsky130_fd_sc_hs__clkinv_2_12 VDD VSS sky130_fd_sc_hs__clkinv_2_12/Y sky130_fd_sc_hs__clkinv_2_12/A
+ VSS VDD sky130_fd_sc_hs__clkinv_2
Xsky130_fd_sc_hs__a21oi_1_30 VDD VSS sky130_fd_sc_hs__o31ai_1_4/A1 sky130_fd_sc_hs__o21ai_1_9/B1
+ sky130_fd_sc_hs__nor2_1_22/Y sky130_fd_sc_hs__o21ai_1_9/A1 VSS VDD sky130_fd_sc_hs__a21oi_1
Xsky130_fd_sc_hs__a21oi_1_41 VDD VSS sky130_fd_sc_hs__o21ai_1_2/Y sky130_fd_sc_hs__o21a_1_4/A1
+ sky130_fd_sc_hs__xor2_1_7/X sky130_fd_sc_hs__buf_8_10/X VSS VDD sky130_fd_sc_hs__a21oi_1
Xsky130_fd_sc_hs__a21oi_1_52 VDD VSS sky130_fd_sc_hs__nor2_2_1/Y sky130_fd_sc_hs__nor2_1_42/B
+ sky130_fd_sc_hs__or2_1_8/B sky130_fd_sc_hs__nor2_2_1/B VSS VDD sky130_fd_sc_hs__a21oi_1
Xsky130_fd_sc_hs__a21oi_1_63 VDD VSS sky130_fd_sc_hs__o21bai_1_0/Y sky130_fd_sc_hs__a21oi_1_63/Y
+ sky130_fd_sc_hs__nor3_1_16/B sky130_fd_sc_hs__o21bai_1_0/A1 VSS VDD sky130_fd_sc_hs__a21oi_1
Xsky130_fd_sc_hs__a21oi_1_74 VDD VSS sky130_fd_sc_hs__nor2_1_61/Y sky130_fd_sc_hs__a21oi_1_74/Y
+ sky130_fd_sc_hs__nand2_1_89/Y sky130_fd_sc_hs__nor2_1_82/B VSS VDD sky130_fd_sc_hs__a21oi_1
Xsky130_fd_sc_hs__a21oi_1_85 VDD VSS sky130_fd_sc_hs__o21ai_1_40/Y sky130_fd_sc_hs__a21oi_1_85/Y
+ sky130_fd_sc_hs__nor2_1_73/Y sky130_fd_sc_hs__a21oi_1_87/Y VSS VDD sky130_fd_sc_hs__a21oi_1
Xsky130_fd_sc_hs__nor3b_4_0 VDD VSS sky130_fd_sc_hs__nor3b_4_0/Y sky130_fd_sc_hs__or3b_1_0/A
+ sky130_fd_sc_hs__or3b_1_1/X sky130_fd_sc_hs__or2_1_29/A VSS VDD sky130_fd_sc_hs__nor3b_4
Xsky130_fd_sc_hs__a21oi_1_96 VDD VSS sky130_fd_sc_hs__o21ai_1_46/Y sky130_fd_sc_hs__a21oi_1_96/Y
+ sky130_fd_sc_hs__xnor2_1_94/Y sky130_fd_sc_hs__buf_8_10/A VSS VDD sky130_fd_sc_hs__a21oi_1
Xsky130_fd_sc_hs__dfrtp_1_50 sky130_fd_sc_hs__clkbuf_4_12/A VDD VSS sky130_fd_sc_hs__buf_1_6/A
+ sky130_fd_sc_hs__clkinv_1_6/A sky130_fd_sc_hs__nand2_1_2/Y VSS VDD sky130_fd_sc_hs__dfrtp_1
Xsky130_fd_sc_hs__dfrtp_1_61 sky130_fd_sc_hs__clkbuf_4_1/X VDD VSS sky130_fd_sc_hs__mux2_1_52/A0
+ sky130_fd_sc_hs__clkinv_1_7/A sky130_fd_sc_hs__mux2_1_52/X VSS VDD sky130_fd_sc_hs__dfrtp_1
Xsky130_fd_sc_hs__dfrtp_1_72 sky130_fd_sc_hs__buf_8_0/X VDD VSS sky130_fd_sc_hs__mux2_1_76/A0
+ sky130_fd_sc_hs__clkinv_1_13/A sky130_fd_sc_hs__mux2_1_76/X VSS VDD sky130_fd_sc_hs__dfrtp_1
Xsky130_fd_sc_hs__dfrtp_1_83 sky130_fd_sc_hs__clkbuf_4_1/X VDD VSS sky130_fd_sc_hs__a22o_1_9/B2
+ sky130_fd_sc_hs__clkbuf_2_23/X sky130_fd_sc_hs__mux2_1_59/X VSS VDD sky130_fd_sc_hs__dfrtp_1
Xsky130_fd_sc_hs__dfrtp_1_94 sky130_fd_sc_hs__clkbuf_4_0/X VDD VSS sky130_fd_sc_hs__mux2_1_93/A1
+ sky130_fd_sc_hs__clkinv_1_18/A sky130_fd_sc_hs__mux2_1_93/X VSS VDD sky130_fd_sc_hs__dfrtp_1
Xsky130_fd_sc_hs__a222oi_1_5 VDD VSS sky130_fd_sc_hs__nand2_1_33/B sky130_fd_sc_hs__mux2_1_137/A0
+ sky130_fd_sc_hs__a22o_1_8/B1 sky130_fd_sc_hs__a22oi_1_5/A2 sky130_fd_sc_hs__mux2_1_127/A0
+ sky130_fd_sc_hs__nand3_1_15/B sky130_fd_sc_hs__maj3_1_8/B VSS VDD sky130_fd_sc_hs__a222oi_1
Xsky130_fd_sc_hs__o31a_1_2 VDD VSS sky130_fd_sc_hs__buf_8_14/X sky130_fd_sc_hs__o31a_1_2/A2
+ sky130_fd_sc_hs__o31a_1_2/A1 sky130_fd_sc_hs__or2_1_16/A sky130_fd_sc_hs__o31a_1_2/X
+ VSS VDD sky130_fd_sc_hs__o31a_1
Xsky130_fd_sc_hs__a22o_1_140 VDD VSS sky130_fd_sc_hs__a22o_1_140/X sky130_fd_sc_hs__mux2_1_259/A1
+ sky130_fd_sc_hs__a222o_1_3/C2 sky130_fd_sc_hs__a22oi_1_6/B1 sky130_fd_sc_hs__xor2_1_17/B
+ VSS VDD sky130_fd_sc_hs__a22o_1
Xsky130_fd_sc_hs__xor2_1_8 VDD VSS sky130_fd_sc_hs__xor2_1_8/A sky130_fd_sc_hs__xor2_1_8/B
+ sky130_fd_sc_hs__xor2_1_8/X VSS VDD sky130_fd_sc_hs__xor2_1
Xsky130_fd_sc_hs__dfrtp_1_320 sky130_fd_sc_hs__clkbuf_4_13/X VDD VSS sky130_fd_sc_hs__xor2_1_26/A
+ sky130_fd_sc_hs__clkinv_1_57/A sky130_fd_sc_hs__mux2_1_199/X VSS VDD sky130_fd_sc_hs__dfrtp_1
Xsky130_fd_sc_hs__dfrtp_1_331 sky130_fd_sc_hs__clkbuf_4_15/X VDD VSS sky130_fd_sc_hs__maj3_1_19/C
+ sky130_fd_sc_hs__clkbuf_2_104/X sky130_fd_sc_hs__a22o_1_41/X VSS VDD sky130_fd_sc_hs__dfrtp_1
Xsky130_fd_sc_hs__dfrtp_1_342 sky130_fd_sc_hs__clkbuf_4_56/X VDD VSS sky130_fd_sc_hs__xor2_1_38/A
+ sky130_fd_sc_hs__clkinv_1_64/A sky130_fd_sc_hs__mux2_1_217/X VSS VDD sky130_fd_sc_hs__dfrtp_1
Xsky130_fd_sc_hs__dfrtp_1_353 sky130_fd_sc_hs__clkbuf_4_56/X VDD VSS sky130_fd_sc_hs__a22o_1_71/B2
+ sky130_fd_sc_hs__clkinv_1_71/A sky130_fd_sc_hs__a22o_1_71/X VSS VDD sky130_fd_sc_hs__dfrtp_1
Xsky130_fd_sc_hs__mux2_1_9 VDD VSS sky130_fd_sc_hs__mux2_1_9/X sky130_fd_sc_hs__mux2_1_9/S
+ sky130_fd_sc_hs__mux2_1_9/A0 sky130_fd_sc_hs__mux2_1_9/A1 VSS VDD sky130_fd_sc_hs__mux2_1
Xsky130_fd_sc_hs__dfrtp_1_364 sky130_fd_sc_hs__clkbuf_4_15/X VDD VSS sky130_fd_sc_hs__mux2_1_7/A1
+ sky130_fd_sc_hs__clkbuf_2_241/X sky130_fd_sc_hs__a22o_1_63/X VSS VDD sky130_fd_sc_hs__dfrtp_1
Xsky130_fd_sc_hs__dfrtp_1_375 sky130_fd_sc_hs__clkbuf_4_56/X VDD VSS sky130_fd_sc_hs__xor2_1_43/A
+ sky130_fd_sc_hs__clkbuf_2_103/X sky130_fd_sc_hs__a22o_1_51/X VSS VDD sky130_fd_sc_hs__dfrtp_1
Xsky130_fd_sc_hs__dfrtp_1_386 sky130_fd_sc_hs__buf_8_7/X VDD VSS sky130_fd_sc_hs__maj3_1_15/C
+ sky130_fd_sc_hs__clkinv_2_8/A sky130_fd_sc_hs__dfrtp_1_386/D VSS VDD sky130_fd_sc_hs__dfrtp_1
Xsky130_fd_sc_hs__dfrtp_1_397 sky130_fd_sc_hs__buf_8_7/X VDD VSS sky130_fd_sc_hs__maj3_1_13/C
+ sky130_fd_sc_hs__clkinv_2_8/A sky130_fd_sc_hs__dfrtp_1_397/D VSS VDD sky130_fd_sc_hs__dfrtp_1
Xsky130_fd_sc_hs__dlygate4sd3_1_5 VSS VDD raw_bits_i[0] sky130_fd_sc_hs__buf_1_69/A
+ VSS VDD sky130_fd_sc_hs__dlygate4sd3_1
Xsky130_fd_sc_hs__buf_16_11 sky130_fd_sc_hs__mux2_1_1/S VDD VSS sky130_fd_sc_hs__mux2_1_4/S
+ VSS VDD sky130_fd_sc_hs__buf_16
Xsky130_fd_sc_hs__clkbuf_4_30 VDD VSS sky130_fd_sc_hs__buf_8_30/A sky130_fd_sc_hs__clkbuf_4_30/X
+ VSS VDD sky130_fd_sc_hs__clkbuf_4
Xsky130_fd_sc_hs__clkbuf_4_41 VDD VSS sky130_fd_sc_hs__nor3_4_7/Y sky130_fd_sc_hs__buf_16_7/A
+ VSS VDD sky130_fd_sc_hs__clkbuf_4
Xsky130_fd_sc_hs__clkbuf_4_52 VDD VSS sky130_fd_sc_hs__nor2_2_8/Y sky130_fd_sc_hs__buf_16_10/A
+ VSS VDD sky130_fd_sc_hs__clkbuf_4
Xsky130_fd_sc_hs__mux2_1_302 VDD VSS sky130_fd_sc_hs__mux2_1_302/X sky130_fd_sc_hs__mux2_1_464/S
+ sky130_fd_sc_hs__mux2_1_477/A1 sky130_fd_sc_hs__mux2_1_302/A1 VSS VDD sky130_fd_sc_hs__mux2_1
Xsky130_fd_sc_hs__mux2_1_313 VDD VSS sky130_fd_sc_hs__mux2_1_313/X sky130_fd_sc_hs__buf_16_2/X
+ sky130_fd_sc_hs__a22o_1_64/B2 sky130_fd_sc_hs__mux2_1_313/A1 VSS VDD sky130_fd_sc_hs__mux2_1
Xsky130_fd_sc_hs__mux2_1_324 VDD VSS sky130_fd_sc_hs__mux2_1_324/X sky130_fd_sc_hs__mux2_1_464/S
+ sky130_fd_sc_hs__a22o_1_67/B2 sky130_fd_sc_hs__nand2_1_198/A VSS VDD sky130_fd_sc_hs__mux2_1
Xsky130_fd_sc_hs__mux2_1_335 VDD VSS sky130_fd_sc_hs__mux2_1_335/X sky130_fd_sc_hs__buf_8_24/X
+ sky130_fd_sc_hs__mux2_1_355/A1 sky130_fd_sc_hs__mux2_1_335/A1 VSS VDD sky130_fd_sc_hs__mux2_1
Xsky130_fd_sc_hs__mux2_1_346 VDD VSS sky130_fd_sc_hs__mux2_1_346/X sky130_fd_sc_hs__mux2_1_5/S
+ sky130_fd_sc_hs__mux2_1_346/A0 sky130_fd_sc_hs__a22o_1_95/B2 VSS VDD sky130_fd_sc_hs__mux2_1
Xsky130_fd_sc_hs__mux2_1_357 VDD VSS sky130_fd_sc_hs__mux2_1_357/X sky130_fd_sc_hs__buf_8_22/X
+ sky130_fd_sc_hs__mux2_1_357/A0 sky130_fd_sc_hs__dfrtp_2_1/Q VSS VDD sky130_fd_sc_hs__mux2_1
Xsky130_fd_sc_hs__mux2_1_368 VDD VSS sky130_fd_sc_hs__mux2_1_368/X sky130_fd_sc_hs__mux2_1_368/S
+ sky130_fd_sc_hs__mux2_1_368/A0 sky130_fd_sc_hs__dfrtp_2_1/Q VSS VDD sky130_fd_sc_hs__mux2_1
Xsky130_fd_sc_hs__mux2_1_379 VDD VSS sky130_fd_sc_hs__mux2_1_379/X sky130_fd_sc_hs__buf_16_2/A
+ sky130_fd_sc_hs__a22o_1_89/B2 sky130_fd_sc_hs__mux2_1_379/A1 VSS VDD sky130_fd_sc_hs__mux2_1
Xsky130_fd_sc_hs__xor2_1_13 VDD VSS sky130_fd_sc_hs__xor2_1_13/A sky130_fd_sc_hs__xor2_1_13/B
+ sky130_fd_sc_hs__xor2_1_13/X VSS VDD sky130_fd_sc_hs__xor2_1
Xsky130_fd_sc_hs__xor2_1_24 VDD VSS sky130_fd_sc_hs__xor2_1_24/A sky130_fd_sc_hs__xor2_1_24/B
+ sky130_fd_sc_hs__xor2_1_24/X VSS VDD sky130_fd_sc_hs__xor2_1
Xsky130_fd_sc_hs__xor2_1_35 VDD VSS sky130_fd_sc_hs__xor2_1_35/A sky130_fd_sc_hs__xor2_1_35/B
+ sky130_fd_sc_hs__xor2_1_35/X VSS VDD sky130_fd_sc_hs__xor2_1
Xsky130_fd_sc_hs__xor2_1_46 VDD VSS sky130_fd_sc_hs__xor2_1_46/A sky130_fd_sc_hs__xor2_1_46/B
+ sky130_fd_sc_hs__xor2_1_46/X VSS VDD sky130_fd_sc_hs__xor2_1
Xsky130_fd_sc_hs__xor2_1_57 VDD VSS sky130_fd_sc_hs__xor2_1_57/A sky130_fd_sc_hs__xor2_1_57/B
+ sky130_fd_sc_hs__xor2_1_57/X VSS VDD sky130_fd_sc_hs__xor2_1
Xsky130_fd_sc_hs__xor2_1_68 VDD VSS sky130_fd_sc_hs__xor2_1_68/A sky130_fd_sc_hs__xor2_1_68/B
+ sky130_fd_sc_hs__xor2_1_68/X VSS VDD sky130_fd_sc_hs__xor2_1
Xsky130_fd_sc_hs__xor2_1_79 VDD VSS sky130_fd_sc_hs__nor3_4_2/A sky130_fd_sc_hs__xor2_1_79/B
+ sky130_fd_sc_hs__xor2_1_79/X VSS VDD sky130_fd_sc_hs__xor2_1
Xsky130_fd_sc_hs__nand2b_1_15 VDD VSS sky130_fd_sc_hs__nor3_1_15/C sky130_fd_sc_hs__or2_1_9/A
+ sky130_fd_sc_hs__a32o_1_3/A3 VSS VDD sky130_fd_sc_hs__nand2b_1
Xsky130_fd_sc_hs__nand2b_1_26 VDD VSS sky130_fd_sc_hs__xnor2_1_64/Y sky130_fd_sc_hs__o21ai_1_39/Y
+ sky130_fd_sc_hs__a32o_1_6/A2 VSS VDD sky130_fd_sc_hs__nand2b_1
Xsky130_fd_sc_hs__nand2b_1_37 VDD VSS sky130_fd_sc_hs__xnor2_1_89/B sky130_fd_sc_hs__maj3_1_33/X
+ sky130_fd_sc_hs__nand2b_1_37/Y VSS VDD sky130_fd_sc_hs__nand2b_1
Xsky130_fd_sc_hs__nand2b_1_48 VDD VSS sky130_fd_sc_hs__mux2i_1_5/A1 sky130_fd_sc_hs__or2_1_30/B
+ sky130_fd_sc_hs__nand2b_1_48/Y VSS VDD sky130_fd_sc_hs__nand2b_1
Xsky130_fd_sc_hs__nand2b_1_59 VDD VSS sky130_fd_sc_hs__nor3_4_2/A sky130_fd_sc_hs__xor2_1_79/B
+ sky130_fd_sc_hs__nor2_1_162/B VSS VDD sky130_fd_sc_hs__nand2b_1
Xsky130_fd_sc_hs__nand2b_1_6 VDD VSS sky130_fd_sc_hs__and2_1_2/X sky130_fd_sc_hs__nand3_1_11/Y
+ sky130_fd_sc_hs__nand2b_1_6/Y VSS VDD sky130_fd_sc_hs__nand2b_1
Xsky130_fd_sc_hs__a221oi_1_4 VDD VSS sky130_fd_sc_hs__nand2_1_17/Y sky130_fd_sc_hs__and3_1_0/B
+ sky130_fd_sc_hs__mux2_1_88/A0 sky130_fd_sc_hs__nand2_1_51/B sky130_fd_sc_hs__mux2_1_86/A1
+ sky130_fd_sc_hs__a22o_1_9/A2 VSS VDD sky130_fd_sc_hs__a221oi_1
Xsky130_fd_sc_hs__dfrtp_1_150 sky130_fd_sc_hs__clkbuf_4_10/X VDD VSS sky130_fd_sc_hs__buf_1_28/A
+ sky130_fd_sc_hs__clkinv_1_37/A sky130_fd_sc_hs__mux2_1_136/X VSS VDD sky130_fd_sc_hs__dfrtp_1
Xsky130_fd_sc_hs__dfrtp_1_161 sky130_fd_sc_hs__clkbuf_4_5/X VDD VSS sky130_fd_sc_hs__xor2_1_18/A
+ sky130_fd_sc_hs__clkbuf_2_55/X sky130_fd_sc_hs__o31ai_1_4/Y VSS VDD sky130_fd_sc_hs__dfrtp_1
Xsky130_fd_sc_hs__dfrtp_1_172 sky130_fd_sc_hs__clkbuf_4_10/X VDD VSS sky130_fd_sc_hs__buf_1_38/A
+ sky130_fd_sc_hs__clkinv_1_43/A sky130_fd_sc_hs__mux2_1_160/X VSS VDD sky130_fd_sc_hs__dfrtp_1
Xsky130_fd_sc_hs__dfrtp_1_183 sky130_fd_sc_hs__clkbuf_4_10/X VDD VSS sky130_fd_sc_hs__buf_1_55/A
+ sky130_fd_sc_hs__clkinv_1_42/A sky130_fd_sc_hs__o41ai_1_2/Y VSS VDD sky130_fd_sc_hs__dfrtp_1
Xsky130_fd_sc_hs__dfrtp_1_194 sky130_fd_sc_hs__clkbuf_4_10/X VDD VSS sky130_fd_sc_hs__mux2_1_175/A1
+ sky130_fd_sc_hs__clkinv_1_38/A sky130_fd_sc_hs__mux2_1_175/X VSS VDD sky130_fd_sc_hs__dfrtp_1
Xsky130_fd_sc_hs__a221o_1_1 VDD VSS sky130_fd_sc_hs__a221o_1_1/X sky130_fd_sc_hs__a22o_1_118/X
+ sky130_fd_sc_hs__xor2_1_52/B sky130_fd_sc_hs__a22o_1_8/A2 sky130_fd_sc_hs__a221o_1_1/A1
+ sky130_fd_sc_hs__a22oi_1_6/B1 VSS VDD sky130_fd_sc_hs__a221o_1
Xsky130_fd_sc_hs__o21a_1_1 VDD VSS sky130_fd_sc_hs__o21a_1_1/X sky130_fd_sc_hs__and2_1_1/X
+ sky130_fd_sc_hs__nor2_4_3/Y sky130_fd_sc_hs__o21a_1_1/A1 VSS VDD sky130_fd_sc_hs__o21a_1
Xsky130_fd_sc_hs__a32o_1_6 VDD VSS sky130_fd_sc_hs__a32o_1_6/X sky130_fd_sc_hs__maj3_1_27/C
+ sky130_fd_sc_hs__a32o_1_7/B1 sky130_fd_sc_hs__a32o_1_6/A2 sky130_fd_sc_hs__buf_8_14/X
+ sky130_fd_sc_hs__a32o_1_6/A3 VSS VDD sky130_fd_sc_hs__a32o_1
Xsky130_fd_sc_hs__clkinv_1_2 VDD VSS sky130_fd_sc_hs__clkinv_1_2/A sky130_fd_sc_hs__clkinv_1_2/Y
+ VSS VDD sky130_fd_sc_hs__clkinv_1
Xsky130_fd_sc_hs__nor2_1_170 VDD VSS sky130_fd_sc_hs__or3_1_8/A sky130_fd_sc_hs__nor2_1_170/Y
+ sky130_fd_sc_hs__nor2_1_170/A VSS VDD sky130_fd_sc_hs__nor2_1
Xsky130_fd_sc_hs__nor2_1_181 VDD VSS sky130_fd_sc_hs__nor3_1_52/Y sky130_fd_sc_hs__nor2_1_181/Y
+ sky130_fd_sc_hs__nor2_4_3/B VSS VDD sky130_fd_sc_hs__nor2_1
Xsky130_fd_sc_hs__a22oi_1_90 VDD VSS sky130_fd_sc_hs__mux2_1_349/A1 sky130_fd_sc_hs__a22oi_1_90/Y
+ sky130_fd_sc_hs__buf_16_9/X sky130_fd_sc_hs__buf_16_7/X sky130_fd_sc_hs__mux2_1_348/A0
+ VSS VDD sky130_fd_sc_hs__a22oi_1
Xsky130_fd_sc_hs__o31ai_4_0 VDD VSS sky130_fd_sc_hs__o31ai_4_0/Y sky130_fd_sc_hs__nor4b_1_1/Y
+ sky130_fd_sc_hs__o31ai_4_0/A3 sky130_fd_sc_hs__o31ai_4_0/A2 sky130_fd_sc_hs__nor2_4_3/A
+ VSS VDD sky130_fd_sc_hs__o31ai_4
Xsky130_fd_sc_hs__mux2_1_110 VDD VSS sky130_fd_sc_hs__mux2_1_110/X sky130_fd_sc_hs__mux2_1_1/S
+ sky130_fd_sc_hs__a22o_1_64/B2 sky130_fd_sc_hs__mux2_1_110/A1 VSS VDD sky130_fd_sc_hs__mux2_1
Xsky130_fd_sc_hs__xnor3_1_1 VDD VSS sky130_fd_sc_hs__xnor3_1_1/X sky130_fd_sc_hs__xnor3_1_1/B
+ sky130_fd_sc_hs__xnor3_1_1/C sky130_fd_sc_hs__xnor3_1_1/A VSS VDD sky130_fd_sc_hs__xnor3_1
Xsky130_fd_sc_hs__mux2_1_121 VDD VSS sky130_fd_sc_hs__mux2_1_121/X sky130_fd_sc_hs__mux2_1_9/S
+ sky130_fd_sc_hs__mux2_1_121/A0 sky130_fd_sc_hs__mux2_1_96/A0 VSS VDD sky130_fd_sc_hs__mux2_1
Xsky130_fd_sc_hs__mux2_1_132 VDD VSS sky130_fd_sc_hs__mux2_1_132/X sky130_fd_sc_hs__mux2_1_7/S
+ sky130_fd_sc_hs__mux2_1_132/A0 sky130_fd_sc_hs__a22o_1_60/B2 VSS VDD sky130_fd_sc_hs__mux2_1
Xsky130_fd_sc_hs__mux2_1_143 VDD VSS sky130_fd_sc_hs__mux2_1_143/X sky130_fd_sc_hs__mux2_1_98/S
+ sky130_fd_sc_hs__mux2_1_143/A0 sky130_fd_sc_hs__a22o_1_75/B2 VSS VDD sky130_fd_sc_hs__mux2_1
Xsky130_fd_sc_hs__mux2_1_154 VDD VSS sky130_fd_sc_hs__mux2_1_154/X sky130_fd_sc_hs__buf_16_5/X
+ sky130_fd_sc_hs__mux2_1_154/A0 sky130_fd_sc_hs__a22o_1_75/B2 VSS VDD sky130_fd_sc_hs__mux2_1
Xsky130_fd_sc_hs__mux2_1_165 VDD VSS sky130_fd_sc_hs__mux2_1_165/X sky130_fd_sc_hs__buf_16_1/A
+ sky130_fd_sc_hs__mux2_1_165/A0 sky130_fd_sc_hs__a22o_1_75/B2 VSS VDD sky130_fd_sc_hs__mux2_1
Xsky130_fd_sc_hs__mux2_1_176 VDD VSS sky130_fd_sc_hs__mux2_1_176/X sky130_fd_sc_hs__mux2_1_94/S
+ sky130_fd_sc_hs__xor2_1_9/B sky130_fd_sc_hs__mux2_1_40/A0 VSS VDD sky130_fd_sc_hs__mux2_1
Xsky130_fd_sc_hs__mux2_1_187 VDD VSS sky130_fd_sc_hs__mux2_1_187/X sky130_fd_sc_hs__buf_16_3/A
+ sky130_fd_sc_hs__mux2_1_61/A0 sky130_fd_sc_hs__mux2_1_187/A1 VSS VDD sky130_fd_sc_hs__mux2_1
Xsky130_fd_sc_hs__mux2_1_198 VDD VSS sky130_fd_sc_hs__mux2_1_198/X sky130_fd_sc_hs__nor2_1_82/B
+ sky130_fd_sc_hs__xor2_1_24/A sky130_fd_sc_hs__nor2_1_63/Y VSS VDD sky130_fd_sc_hs__mux2_1
Xsky130_fd_sc_hs__a221oi_1_10 VDD VSS sky130_fd_sc_hs__nand2_1_24/Y sky130_fd_sc_hs__nand3_1_9/C
+ sky130_fd_sc_hs__mux2_1_207/A0 sky130_fd_sc_hs__nand2_1_51/B sky130_fd_sc_hs__mux2_1_100/A0
+ sky130_fd_sc_hs__a22o_1_8/A2 VSS VDD sky130_fd_sc_hs__a221oi_1
Xsky130_fd_sc_hs__buf_1_4 VDD VSS sky130_fd_sc_hs__buf_1_4/A srm_residue_o[5] VSS
+ VDD sky130_fd_sc_hs__buf_1
Xsky130_fd_sc_hs__or3_1_0 VDD VSS sky130_fd_sc_hs__or3_1_0/A sky130_fd_sc_hs__or3_1_0/B
+ sky130_fd_sc_hs__or3_1_0/C sky130_fd_sc_hs__or3_1_0/X VSS VDD sky130_fd_sc_hs__or3_1
Xsky130_fd_sc_hs__buf_1_102 VDD VSS sky130_fd_sc_hs__buf_1_102/A dac_n_force[10] VSS
+ VDD sky130_fd_sc_hs__buf_1
Xsky130_fd_sc_hs__buf_1_113 VDD VSS sky130_fd_sc_hs__o22ai_1_7/Y dac_n_force[4] VSS
+ VDD sky130_fd_sc_hs__buf_1
Xsky130_fd_sc_hs__buf_1_124 VDD VSS sky130_fd_sc_hs__buf_1_124/A dac_p_force[2] VSS
+ VDD sky130_fd_sc_hs__buf_1
Xsky130_fd_sc_hs__buf_1_135 VDD VSS sky130_fd_sc_hs__buf_1_135/A calib_overrange_bits[3]
+ VSS VDD sky130_fd_sc_hs__buf_1
Xsky130_fd_sc_hs__buf_1_146 VDD VSS sky130_fd_sc_hs__buf_1_146/A w_wr_data[12] VSS
+ VDD sky130_fd_sc_hs__buf_1
Xsky130_fd_sc_hs__buf_1_157 VDD VSS sky130_fd_sc_hs__buf_1_157/A w_wr_addr[3] VSS
+ VDD sky130_fd_sc_hs__buf_1
Xsky130_fd_sc_hs__buf_1_168 VDD VSS sky130_fd_sc_hs__buf_1_168/A calib_overrange_bits[17]
+ VSS VDD sky130_fd_sc_hs__buf_1
Xsky130_fd_sc_hs__buf_1_179 VDD VSS sky130_fd_sc_hs__buf_1_179/A sky130_fd_sc_hs__buf_1_179/X
+ VSS VDD sky130_fd_sc_hs__buf_1
Xsky130_fd_sc_hs__mux2i_1_4 VDD VSS sky130_fd_sc_hs__nand4_1_6/Y sky130_fd_sc_hs__mux2i_1_4/A1
+ sky130_fd_sc_hs__or2_1_22/B sky130_fd_sc_hs__mux2i_1_4/Y VSS VDD sky130_fd_sc_hs__mux2i_1
Xsky130_fd_sc_hs__a2111oi_1_3 VDD VSS sky130_fd_sc_hs__a222o_1_7/X sky130_fd_sc_hs__a22o_1_133/X
+ sky130_fd_sc_hs__nand2_1_221/Y sky130_fd_sc_hs__buf_16_7/X sky130_fd_sc_hs__mux2_1_430/A0
+ sky130_fd_sc_hs__nand3_1_33/C VSS VDD sky130_fd_sc_hs__a2111oi_1
Xsky130_fd_sc_hs__a21oi_1_205 VDD VSS sky130_fd_sc_hs__nor2_4_3/B sky130_fd_sc_hs__nor2_1_182/B
+ sky130_fd_sc_hs__o31ai_1_21/Y sky130_fd_sc_hs__o21a_1_4/B1 VSS VDD sky130_fd_sc_hs__a21oi_1
Xsky130_fd_sc_hs__o211ai_1_6 VDD VSS sky130_fd_sc_hs__o211ai_1_6/B1 sky130_fd_sc_hs__and2_1_24/B
+ sky130_fd_sc_hs__o21a_1_19/B1 sky130_fd_sc_hs__xor2_1_64/X sky130_fd_sc_hs__xnor2_1_91/A
+ VSS VDD sky130_fd_sc_hs__o211ai_1
Xsky130_fd_sc_hs__a31oi_1_4 VDD VSS sky130_fd_sc_hs__maj3_1_10/C sky130_fd_sc_hs__nand2_1_49/Y
+ sky130_fd_sc_hs__nor2_1_34/Y sky130_fd_sc_hs__nand2_1_48/B sky130_fd_sc_hs__nand2_1_50/Y
+ VSS VDD sky130_fd_sc_hs__a31oi_1
Xsky130_fd_sc_hs__a211o_1_0 VDD VSS sky130_fd_sc_hs__a211o_1_0/X sky130_fd_sc_hs__o21ai_1_7/B1
+ sky130_fd_sc_hs__nor2_1_35/Y sky130_fd_sc_hs__xnor2_1_37/Y sky130_fd_sc_hs__buf_1_22/X
+ VSS VDD sky130_fd_sc_hs__a211o_1
Xsky130_fd_sc_hs__clkbuf_2_210 VDD VSS sky130_fd_sc_hs__clkbuf_2_210/X sky130_fd_sc_hs__clkinv_2_11/A
+ VSS VDD sky130_fd_sc_hs__clkbuf_2
Xsky130_fd_sc_hs__clkbuf_2_221 VDD VSS sky130_fd_sc_hs__clkbuf_2_221/X sky130_fd_sc_hs__dfstp_1_4/CLK
+ VSS VDD sky130_fd_sc_hs__clkbuf_2
Xsky130_fd_sc_hs__clkbuf_2_232 VDD VSS sky130_fd_sc_hs__clkbuf_2_232/X sky130_fd_sc_hs__clkbuf_8_17/A
+ VSS VDD sky130_fd_sc_hs__clkbuf_2
Xsky130_fd_sc_hs__nand2_1_210 VDD VSS sky130_fd_sc_hs__nor2_4_3/B sky130_fd_sc_hs__nand2_1_210/Y
+ sky130_fd_sc_hs__xor2_1_89/A VSS VDD sky130_fd_sc_hs__nand2_1
Xsky130_fd_sc_hs__clkbuf_2_243 VDD VSS sky130_fd_sc_hs__buf_8_1/A sky130_fd_sc_hs__buf_8_38/A
+ VSS VDD sky130_fd_sc_hs__clkbuf_2
Xsky130_fd_sc_hs__nand2_1_221 VDD VSS sky130_fd_sc_hs__a32oi_1_1/Y sky130_fd_sc_hs__nand2_1_221/Y
+ sky130_fd_sc_hs__nand2_1_221/A VSS VDD sky130_fd_sc_hs__nand2_1
Xsky130_fd_sc_hs__nand2_1_232 VDD VSS sky130_fd_sc_hs__nand2_1_233/Y sky130_fd_sc_hs__xor2_1_57/A
+ sky130_fd_sc_hs__nand2_1_85/A VSS VDD sky130_fd_sc_hs__nand2_1
Xsky130_fd_sc_hs__and2_1_50 VDD VSS sky130_fd_sc_hs__and2_1_50/A sky130_fd_sc_hs__or2_1_1/X
+ sky130_fd_sc_hs__xor2_1_47/B VSS VDD sky130_fd_sc_hs__and2_1
Xsky130_fd_sc_hs__a22o_1_5 VDD VSS sky130_fd_sc_hs__a22o_1_5/X sky130_fd_sc_hs__and2_1_0/A
+ sky130_fd_sc_hs__a22o_1_6/B1 sky130_fd_sc_hs__nand2_1_9/B sky130_fd_sc_hs__buf_1_17/A
+ VSS VDD sky130_fd_sc_hs__a22o_1
Xsky130_fd_sc_hs__o2bb2ai_1_13 VDD VSS sky130_fd_sc_hs__dfrtp_1_245/D sky130_fd_sc_hs__nor3_1_15/A
+ sky130_fd_sc_hs__dfrtp_1_245/Q sky130_fd_sc_hs__xnor2_1_44/Y sky130_fd_sc_hs__nor2_1_48/Y
+ VSS VDD sky130_fd_sc_hs__o2bb2ai_1
Xsky130_fd_sc_hs__o2bb2ai_1_24 VDD VSS sky130_fd_sc_hs__dfrtp_1_357/D sky130_fd_sc_hs__a31o_1_7/X
+ sky130_fd_sc_hs__or2_1_12/A sky130_fd_sc_hs__a21oi_1_81/Y sky130_fd_sc_hs__a32o_1_7/B1
+ VSS VDD sky130_fd_sc_hs__o2bb2ai_1
Xsky130_fd_sc_hs__o2bb2ai_1_35 VDD VSS sky130_fd_sc_hs__o21ai_1_65/B1 sky130_fd_sc_hs__nor2_1_136/Y
+ sky130_fd_sc_hs__o21a_1_26/A2 sky130_fd_sc_hs__nor3_1_37/C sky130_fd_sc_hs__nand2_1_148/Y
+ VSS VDD sky130_fd_sc_hs__o2bb2ai_1
Xsky130_fd_sc_hs__o2bb2ai_1_46 VDD VSS sky130_fd_sc_hs__dfrtp_1_499/D sky130_fd_sc_hs__mux2i_1_11/Y
+ sky130_fd_sc_hs__o32ai_1_0/A1 sky130_fd_sc_hs__nand2b_1_51/Y sky130_fd_sc_hs__or2_1_23/X
+ VSS VDD sky130_fd_sc_hs__o2bb2ai_1
Xsky130_fd_sc_hs__o2bb2ai_1_57 VDD VSS sky130_fd_sc_hs__buf_1_124/A sky130_fd_sc_hs__nand2_1_163/Y
+ sky130_fd_sc_hs__nand2_1_156/A sky130_fd_sc_hs__nand4_1_5/D sky130_fd_sc_hs__buf_8_20/X
+ VSS VDD sky130_fd_sc_hs__o2bb2ai_1
Xsky130_fd_sc_hs__o2bb2ai_1_68 VDD VSS sky130_fd_sc_hs__dfrtp_1_578/D sky130_fd_sc_hs__nand4_1_9/Y
+ sky130_fd_sc_hs__buf_1_47/A sky130_fd_sc_hs__nor2_2_5/B sky130_fd_sc_hs__nand2_1_187/Y
+ VSS VDD sky130_fd_sc_hs__o2bb2ai_1
Xsky130_fd_sc_hs__nand3_1_30 VDD VSS sky130_fd_sc_hs__nand3_1_30/C sky130_fd_sc_hs__or2_1_23/A
+ sky130_fd_sc_hs__nor2_4_3/A sky130_fd_sc_hs__or3_1_1/C VSS VDD sky130_fd_sc_hs__nand3_1
Xsky130_fd_sc_hs__nand3_1_41 VDD VSS sky130_fd_sc_hs__nor3b_1_2/Y sky130_fd_sc_hs__nand4_1_13/C
+ sky130_fd_sc_hs__and2_1_49/X sky130_fd_sc_hs__nand3_1_41/A VSS VDD sky130_fd_sc_hs__nand3_1
Xsky130_fd_sc_hs__o2bb2ai_1_0 VDD VSS sky130_fd_sc_hs__o2bb2ai_1_0/Y sky130_fd_sc_hs__a21oi_1_3/Y
+ sky130_fd_sc_hs__buf_1_19/A sky130_fd_sc_hs__or2_1_0/X sky130_fd_sc_hs__nand2_1_9/B
+ VSS VDD sky130_fd_sc_hs__o2bb2ai_1
Xsky130_fd_sc_hs__dfrtp_1_705 sky130_fd_sc_hs__clkbuf_4_51/X VDD VSS sky130_fd_sc_hs__mux2_1_409/A1
+ sky130_fd_sc_hs__clkbuf_2_217/X sky130_fd_sc_hs__mux2_1_409/X VSS VDD sky130_fd_sc_hs__dfrtp_1
Xsky130_fd_sc_hs__dfrtp_1_716 sky130_fd_sc_hs__clkbuf_4_50/X VDD VSS sky130_fd_sc_hs__mux2_1_418/A0
+ sky130_fd_sc_hs__dfstp_1_4/CLK sky130_fd_sc_hs__mux2_1_418/X VSS VDD sky130_fd_sc_hs__dfrtp_1
Xsky130_fd_sc_hs__dfrtp_1_727 sky130_fd_sc_hs__clkbuf_4_50/X VDD VSS sky130_fd_sc_hs__mux2_1_431/A0
+ sky130_fd_sc_hs__clkbuf_2_225/X sky130_fd_sc_hs__mux2_1_431/X VSS VDD sky130_fd_sc_hs__dfrtp_1
Xsky130_fd_sc_hs__dfrtp_1_738 sky130_fd_sc_hs__clkbuf_4_50/X VDD VSS sky130_fd_sc_hs__mux2_1_439/A1
+ sky130_fd_sc_hs__clkbuf_2_229/X sky130_fd_sc_hs__mux2_1_439/X VSS VDD sky130_fd_sc_hs__dfrtp_1
Xsky130_fd_sc_hs__dfrtp_1_749 sky130_fd_sc_hs__buf_8_35/X VDD VSS sky130_fd_sc_hs__mux2_1_450/A0
+ sky130_fd_sc_hs__clkbuf_2_232/X sky130_fd_sc_hs__mux2_1_450/X VSS VDD sky130_fd_sc_hs__dfrtp_1
Xsky130_fd_sc_hs__buf_1_60 VDD VSS srm_start sky130_fd_sc_hs__buf_1_60/X VSS VDD sky130_fd_sc_hs__buf_1
Xsky130_fd_sc_hs__buf_1_71 VDD VSS sky130_fd_sc_hs__buf_1_71/A sky130_fd_sc_hs__buf_1_71/X
+ VSS VDD sky130_fd_sc_hs__buf_1
Xsky130_fd_sc_hs__buf_1_82 VDD VSS sky130_fd_sc_hs__buf_8_6/X sky130_fd_sc_hs__buf_8_8/A
+ VSS VDD sky130_fd_sc_hs__buf_1
Xsky130_fd_sc_hs__buf_1_93 VDD VSS sky130_fd_sc_hs__buf_1_93/A sky130_fd_sc_hs__buf_1_93/X
+ VSS VDD sky130_fd_sc_hs__buf_1
Xsky130_fd_sc_hs__nor2b_1_3 VDD VSS sky130_fd_sc_hs__maj3_1_4/X sky130_fd_sc_hs__nor2b_1_4/A
+ sky130_fd_sc_hs__nor2b_1_3/A VSS VDD sky130_fd_sc_hs__nor2b_1
Xsky130_fd_sc_hs__nand2_1_5 VDD VSS sky130_fd_sc_hs__nand2_1_5/B sky130_fd_sc_hs__nor2_1_2/A
+ sky130_fd_sc_hs__and2_1_0/B VSS VDD sky130_fd_sc_hs__nand2_1
Xsky130_fd_sc_hs__a311oi_1_12 VDD VSS sky130_fd_sc_hs__clkinv_1_91/Y sky130_fd_sc_hs__o31a_1_3/A2
+ sky130_fd_sc_hs__nand3_1_22/C sky130_fd_sc_hs__xnor2_1_97/Y sky130_fd_sc_hs__nand3_1_22/A
+ sky130_fd_sc_hs__or3_1_9/C VSS VDD sky130_fd_sc_hs__a311oi_1
Xsky130_fd_sc_hs__clkbuf_16_14 VDD VSS sky130_fd_sc_hs__clkinv_4_6/A sky130_fd_sc_hs__clkbuf_8_19/X
+ VSS VDD sky130_fd_sc_hs__clkbuf_16
Xsky130_fd_sc_hs__clkbuf_16_25 VDD VSS sky130_fd_sc_hs__clkbuf_2_236/A sky130_fd_sc_hs__clkbuf_8_19/X
+ VSS VDD sky130_fd_sc_hs__clkbuf_16
Xsky130_fd_sc_hs__nor2_1_1 VDD VSS sky130_fd_sc_hs__nor3_1_5/Y sky130_fd_sc_hs__nor3_1_4/B
+ sky130_fd_sc_hs__o31a_1_0/X VSS VDD sky130_fd_sc_hs__nor2_1
Xsky130_fd_sc_hs__dfrtp_1_502 sky130_fd_sc_hs__clkbuf_4_23/X VDD VSS sky130_fd_sc_hs__nor3_1_41/A
+ sky130_fd_sc_hs__clkbuf_2_157/A sky130_fd_sc_hs__dfrtp_1_502/D VSS VDD sky130_fd_sc_hs__dfrtp_1
Xsky130_fd_sc_hs__dfrtp_1_513 sky130_fd_sc_hs__clkbuf_4_22/A VDD VSS sky130_fd_sc_hs__mux2i_1_5/A1
+ sky130_fd_sc_hs__clkbuf_2_144/X sky130_fd_sc_hs__dfrtp_1_513/D VSS VDD sky130_fd_sc_hs__dfrtp_1
Xsky130_fd_sc_hs__dfrtp_1_524 sky130_fd_sc_hs__clkbuf_4_22/X VDD VSS sky130_fd_sc_hs__maj3_1_50/C
+ sky130_fd_sc_hs__clkinv_1_82/A sky130_fd_sc_hs__a22o_1_100/X VSS VDD sky130_fd_sc_hs__dfrtp_1
Xsky130_fd_sc_hs__dfrtp_1_535 sky130_fd_sc_hs__clkbuf_4_24/X VDD VSS sky130_fd_sc_hs__buf_1_168/A
+ sky130_fd_sc_hs__clkinv_1_109/A sky130_fd_sc_hs__o31ai_1_18/Y VSS VDD sky130_fd_sc_hs__dfrtp_1
Xsky130_fd_sc_hs__dfrtp_1_546 sky130_fd_sc_hs__clkbuf_4_28/X VDD VSS sky130_fd_sc_hs__mux2_1_269/A0
+ sky130_fd_sc_hs__clkinv_1_116/A sky130_fd_sc_hs__mux2_1_269/X VSS VDD sky130_fd_sc_hs__dfrtp_1
Xsky130_fd_sc_hs__dfrtp_1_557 sky130_fd_sc_hs__clkbuf_4_28/X VDD VSS sky130_fd_sc_hs__a222o_1_7/C2
+ sky130_fd_sc_hs__clkbuf_2_222/X sky130_fd_sc_hs__mux2_1_421/X VSS VDD sky130_fd_sc_hs__dfrtp_1
Xsky130_fd_sc_hs__dfrtp_1_568 sky130_fd_sc_hs__clkbuf_4_24/X VDD VSS sky130_fd_sc_hs__buf_1_157/A
+ sky130_fd_sc_hs__clkinv_1_127/A sky130_fd_sc_hs__mux2_1_289/X VSS VDD sky130_fd_sc_hs__dfrtp_1
Xsky130_fd_sc_hs__dfrtp_1_579 sky130_fd_sc_hs__clkbuf_4_24/X VDD VSS sky130_fd_sc_hs__buf_1_161/A
+ sky130_fd_sc_hs__clkinv_1_126/A sky130_fd_sc_hs__dfrtp_1_579/D VSS VDD sky130_fd_sc_hs__dfrtp_1
Xsky130_fd_sc_hs__a21oi_1_20 VDD VSS sky130_fd_sc_hs__buf_8_19/X sky130_fd_sc_hs__a21oi_1_20/Y
+ sky130_fd_sc_hs__o21ai_1_4/Y sky130_fd_sc_hs__o21ai_1_28/Y VSS VDD sky130_fd_sc_hs__a21oi_1
Xsky130_fd_sc_hs__a21oi_1_31 VDD VSS sky130_fd_sc_hs__nor2_1_24/Y sky130_fd_sc_hs__o31ai_1_2/A3
+ sky130_fd_sc_hs__or3_1_0/X sky130_fd_sc_hs__nand2_1_32/A VSS VDD sky130_fd_sc_hs__a21oi_1
Xsky130_fd_sc_hs__a21oi_1_42 VDD VSS sky130_fd_sc_hs__buf_8_2/A sky130_fd_sc_hs__a21oi_1_42/Y
+ sky130_fd_sc_hs__maj3_1_10/C sky130_fd_sc_hs__xor2_1_16/X VSS VDD sky130_fd_sc_hs__a21oi_1
Xsky130_fd_sc_hs__a21oi_1_53 VDD VSS sky130_fd_sc_hs__or2_1_8/X sky130_fd_sc_hs__o32a_1_0/B1
+ sky130_fd_sc_hs__nor3_1_12/Y sky130_fd_sc_hs__o32a_1_0/A1 VSS VDD sky130_fd_sc_hs__a21oi_1
Xsky130_fd_sc_hs__a21oi_1_64 VDD VSS sky130_fd_sc_hs__nor3_1_17/A sky130_fd_sc_hs__nor2_1_53/B
+ sky130_fd_sc_hs__nor3_1_16/B sky130_fd_sc_hs__o21bai_1_0/A1 VSS VDD sky130_fd_sc_hs__a21oi_1
Xsky130_fd_sc_hs__a21oi_1_75 VDD VSS sky130_fd_sc_hs__nor2_1_60/Y sky130_fd_sc_hs__a21oi_1_75/Y
+ sky130_fd_sc_hs__nor2_1_66/B sky130_fd_sc_hs__nand2_1_89/Y VSS VDD sky130_fd_sc_hs__a21oi_1
Xsky130_fd_sc_hs__a21oi_1_86 VDD VSS sky130_fd_sc_hs__nor3_1_21/B sky130_fd_sc_hs__xor2_1_47/A
+ sky130_fd_sc_hs__xor2_1_35/A sky130_fd_sc_hs__and2_1_6/A VSS VDD sky130_fd_sc_hs__a21oi_1
Xsky130_fd_sc_hs__a21oi_1_97 VDD VSS sky130_fd_sc_hs__o21ai_1_47/Y sky130_fd_sc_hs__a21oi_1_97/Y
+ sky130_fd_sc_hs__xnor2_1_81/Y sky130_fd_sc_hs__buf_8_10/A VSS VDD sky130_fd_sc_hs__a21oi_1
Xsky130_fd_sc_hs__dfrtp_1_40 sky130_fd_sc_hs__clkbuf_4_4/X VDD VSS sky130_fd_sc_hs__mux2_1_5/A0
+ sky130_fd_sc_hs__clkbuf_2_12/X sky130_fd_sc_hs__mux2_1_5/X VSS VDD sky130_fd_sc_hs__dfrtp_1
Xsky130_fd_sc_hs__dfrtp_1_51 sky130_fd_sc_hs__dfrtp_1_259/Q VDD VSS sky130_fd_sc_hs__buf_1_17/A
+ sky130_fd_sc_hs__clkinv_1_6/A sky130_fd_sc_hs__a22o_1_5/X VSS VDD sky130_fd_sc_hs__dfrtp_1
Xsky130_fd_sc_hs__dfrtp_1_62 sky130_fd_sc_hs__clkbuf_4_1/X VDD VSS sky130_fd_sc_hs__mux2_1_45/A0
+ sky130_fd_sc_hs__clkbuf_2_23/X sky130_fd_sc_hs__mux2_1_45/X VSS VDD sky130_fd_sc_hs__dfrtp_1
Xsky130_fd_sc_hs__dfrtp_1_73 sky130_fd_sc_hs__clkbuf_4_0/X VDD VSS sky130_fd_sc_hs__mux2_1_75/A1
+ sky130_fd_sc_hs__clkbuf_2_29/X sky130_fd_sc_hs__mux2_1_75/X VSS VDD sky130_fd_sc_hs__dfrtp_1
Xsky130_fd_sc_hs__dfrtp_1_84 sky130_fd_sc_hs__clkbuf_4_12/A VDD VSS sky130_fd_sc_hs__buf_1_4/A
+ sky130_fd_sc_hs__clkbuf_2_15/X sky130_fd_sc_hs__a22o_1_7/X VSS VDD sky130_fd_sc_hs__dfrtp_1
Xsky130_fd_sc_hs__dfrtp_1_95 sky130_fd_sc_hs__clkbuf_4_0/X VDD VSS sky130_fd_sc_hs__mux2_1_87/A0
+ sky130_fd_sc_hs__clkinv_1_18/A sky130_fd_sc_hs__mux2_1_87/X VSS VDD sky130_fd_sc_hs__dfrtp_1
Xsky130_fd_sc_hs__a222oi_1_6 VDD VSS sky130_fd_sc_hs__mux2_1_126/A1 sky130_fd_sc_hs__buf_16_9/X
+ sky130_fd_sc_hs__buf_16_7/X sky130_fd_sc_hs__a222o_1_2/A2 sky130_fd_sc_hs__mux2_1_132/A0
+ sky130_fd_sc_hs__nand3_1_15/C sky130_fd_sc_hs__mux2_1_135/A0 VSS VDD sky130_fd_sc_hs__a222oi_1
Xsky130_fd_sc_hs__o221ai_1_0 VDD VSS sky130_fd_sc_hs__o221ai_1_0/Y sky130_fd_sc_hs__nor2_1_32/Y
+ sky130_fd_sc_hs__o21a_1_8/X sky130_fd_sc_hs__o21a_1_11/B1 sky130_fd_sc_hs__and2_1_13/X
+ sky130_fd_sc_hs__xor2_1_8/X VSS VDD sky130_fd_sc_hs__o221ai_1
Xsky130_fd_sc_hs__a22o_1_130 VDD VSS sky130_fd_sc_hs__buf_1_170/A sky130_fd_sc_hs__nand2_1_125/Y
+ sky130_fd_sc_hs__buf_8_36/A sky130_fd_sc_hs__buf_8_20/X sky130_fd_sc_hs__mux2i_1_14/A0
+ VSS VDD sky130_fd_sc_hs__a22o_1
Xsky130_fd_sc_hs__o31a_1_3 VDD VSS sky130_fd_sc_hs__buf_8_14/X sky130_fd_sc_hs__o31a_1_3/A2
+ sky130_fd_sc_hs__o31a_1_3/A1 sky130_fd_sc_hs__or3_1_9/A sky130_fd_sc_hs__o31a_1_3/X
+ VSS VDD sky130_fd_sc_hs__o31a_1
Xsky130_fd_sc_hs__a22o_1_141 VDD VSS sky130_fd_sc_hs__a22o_1_141/X sky130_fd_sc_hs__mux2_1_40/A0
+ sky130_fd_sc_hs__a22o_1_75/B1 sky130_fd_sc_hs__nor2_1_92/Y sky130_fd_sc_hs__a22o_1_77/B2
+ VSS VDD sky130_fd_sc_hs__a22o_1
Xsky130_fd_sc_hs__xor2_1_9 VDD VSS sky130_fd_sc_hs__xor2_1_9/A sky130_fd_sc_hs__xor2_1_9/B
+ sky130_fd_sc_hs__or2_1_7/A VSS VDD sky130_fd_sc_hs__xor2_1
Xsky130_fd_sc_hs__dfrtp_1_310 sky130_fd_sc_hs__clkbuf_4_13/X VDD VSS sky130_fd_sc_hs__buf_1_155/A
+ sky130_fd_sc_hs__clkinv_1_55/A sky130_fd_sc_hs__buf_1_81/X VSS VDD sky130_fd_sc_hs__dfrtp_1
Xsky130_fd_sc_hs__dfrtp_1_321 sky130_fd_sc_hs__buf_8_7/X VDD VSS sky130_fd_sc_hs__xor2_1_29/B
+ sky130_fd_sc_hs__clkinv_2_5/A sky130_fd_sc_hs__a21oi_1_75/Y VSS VDD sky130_fd_sc_hs__dfrtp_1
Xsky130_fd_sc_hs__dfrtp_1_332 sky130_fd_sc_hs__clkbuf_4_15/X VDD VSS sky130_fd_sc_hs__xor2_1_46/B
+ sky130_fd_sc_hs__clkbuf_2_94/X sky130_fd_sc_hs__mux2_1_213/X VSS VDD sky130_fd_sc_hs__dfrtp_1
Xsky130_fd_sc_hs__dfrtp_1_343 sky130_fd_sc_hs__clkbuf_4_56/X VDD VSS sky130_fd_sc_hs__xor2_1_41/B
+ sky130_fd_sc_hs__clkinv_1_64/A sky130_fd_sc_hs__mux2_1_223/X VSS VDD sky130_fd_sc_hs__dfrtp_1
Xsky130_fd_sc_hs__dfrtp_1_354 sky130_fd_sc_hs__clkbuf_4_56/X VDD VSS sky130_fd_sc_hs__a22o_1_55/B2
+ sky130_fd_sc_hs__clkinv_1_71/A sky130_fd_sc_hs__a22o_1_55/X VSS VDD sky130_fd_sc_hs__dfrtp_1
Xsky130_fd_sc_hs__dfrtp_1_365 sky130_fd_sc_hs__clkbuf_4_15/X VDD VSS sky130_fd_sc_hs__a22o_1_61/B2
+ sky130_fd_sc_hs__clkbuf_2_104/X sky130_fd_sc_hs__a22o_1_61/X VSS VDD sky130_fd_sc_hs__dfrtp_1
Xsky130_fd_sc_hs__dfrtp_1_376 sky130_fd_sc_hs__clkbuf_4_56/X VDD VSS sky130_fd_sc_hs__maj3_1_27/C
+ sky130_fd_sc_hs__clkinv_1_65/A sky130_fd_sc_hs__a32o_1_6/X VSS VDD sky130_fd_sc_hs__dfrtp_1
Xsky130_fd_sc_hs__dfrtp_1_387 sky130_fd_sc_hs__buf_8_6/X VDD VSS sky130_fd_sc_hs__a22o_1_32/A1
+ sky130_fd_sc_hs__clkinv_2_3/A sky130_fd_sc_hs__a22o_1_31/X VSS VDD sky130_fd_sc_hs__dfrtp_1
Xsky130_fd_sc_hs__dfrtp_1_398 sky130_fd_sc_hs__buf_8_7/A VDD VSS sky130_fd_sc_hs__maj3_1_17/C
+ sky130_fd_sc_hs__clkinv_1_59/A sky130_fd_sc_hs__dfrtp_1_398/D VSS VDD sky130_fd_sc_hs__dfrtp_1
Xsky130_fd_sc_hs__dlygate4sd3_1_6 VSS VDD raw_bits_i[7] sky130_fd_sc_hs__buf_1_185/A
+ VSS VDD sky130_fd_sc_hs__dlygate4sd3_1
Xsky130_fd_sc_hs__buf_16_12 sky130_fd_sc_hs__mux2_1_7/S VDD VSS sky130_fd_sc_hs__buf_16_12/A
+ VSS VDD sky130_fd_sc_hs__buf_16
Xsky130_fd_sc_hs__and2_1_0 VDD VSS sky130_fd_sc_hs__and2_1_0/A sky130_fd_sc_hs__and2_1_0/B
+ sky130_fd_sc_hs__nor3_1_5/A VSS VDD sky130_fd_sc_hs__and2_1
Xsky130_fd_sc_hs__clkbuf_4_20 VDD VSS sky130_fd_sc_hs__o211ai_1_8/Y sky130_fd_sc_hs__a22o_1_75/B1
+ VSS VDD sky130_fd_sc_hs__clkbuf_4
Xsky130_fd_sc_hs__clkbuf_4_31 VDD VSS sky130_fd_sc_hs__buf_8_30/A sky130_fd_sc_hs__clkbuf_4_31/X
+ VSS VDD sky130_fd_sc_hs__clkbuf_4
Xsky130_fd_sc_hs__clkbuf_4_42 VDD VSS sky130_fd_sc_hs__nor3_4_5/Y sky130_fd_sc_hs__a22oi_1_6/A2
+ VSS VDD sky130_fd_sc_hs__clkbuf_4
Xsky130_fd_sc_hs__clkbuf_4_53 VDD VSS sky130_fd_sc_hs__nor3_4_2/Y sky130_fd_sc_hs__buf_16_13/A
+ VSS VDD sky130_fd_sc_hs__clkbuf_4
Xsky130_fd_sc_hs__mux2_1_303 VDD VSS sky130_fd_sc_hs__mux2_1_303/X sky130_fd_sc_hs__mux2_1_328/S
+ sky130_fd_sc_hs__mux2_1_303/A0 sky130_fd_sc_hs__mux2_1_473/A1 VSS VDD sky130_fd_sc_hs__mux2_1
Xsky130_fd_sc_hs__mux2_1_314 VDD VSS sky130_fd_sc_hs__mux2_1_314/X sky130_fd_sc_hs__mux2_1_341/S
+ sky130_fd_sc_hs__mux2_1_355/A1 sky130_fd_sc_hs__mux2_1_314/A1 VSS VDD sky130_fd_sc_hs__mux2_1
Xsky130_fd_sc_hs__mux2_1_325 VDD VSS sky130_fd_sc_hs__mux2_1_325/X sky130_fd_sc_hs__buf_8_27/X
+ sky130_fd_sc_hs__mux2_1_325/A0 sky130_fd_sc_hs__mux2_1_477/A1 VSS VDD sky130_fd_sc_hs__mux2_1
Xsky130_fd_sc_hs__mux2_1_336 VDD VSS sky130_fd_sc_hs__mux2_1_336/X sky130_fd_sc_hs__buf_8_22/X
+ sky130_fd_sc_hs__mux2_1_336/A0 sky130_fd_sc_hs__a22o_1_67/B2 VSS VDD sky130_fd_sc_hs__mux2_1
Xsky130_fd_sc_hs__mux2_1_347 VDD VSS sky130_fd_sc_hs__mux2_1_347/X sky130_fd_sc_hs__buf_16_2/X
+ sky130_fd_sc_hs__dfrtp_2_3/Q sky130_fd_sc_hs__mux2_1_347/A1 VSS VDD sky130_fd_sc_hs__mux2_1
Xsky130_fd_sc_hs__mux2_1_358 VDD VSS sky130_fd_sc_hs__mux2_1_358/X sky130_fd_sc_hs__buf_16_4/A
+ sky130_fd_sc_hs__mux2_1_358/A0 sky130_fd_sc_hs__dfrtp_2_1/Q VSS VDD sky130_fd_sc_hs__mux2_1
Xsky130_fd_sc_hs__mux2_1_369 VDD VSS sky130_fd_sc_hs__mux2_1_369/X sky130_fd_sc_hs__mux2_1_7/S
+ sky130_fd_sc_hs__nand4b_1_3/C sky130_fd_sc_hs__a22o_1_89/B2 VSS VDD sky130_fd_sc_hs__mux2_1
Xsky130_fd_sc_hs__xor2_1_14 VDD VSS sky130_fd_sc_hs__maj3_1_8/X sky130_fd_sc_hs__xor2_1_14/B
+ sky130_fd_sc_hs__xor2_1_14/X VSS VDD sky130_fd_sc_hs__xor2_1
Xsky130_fd_sc_hs__xor2_1_25 VDD VSS sky130_fd_sc_hs__xor2_1_25/A sky130_fd_sc_hs__xor2_1_25/B
+ sky130_fd_sc_hs__xor2_1_25/X VSS VDD sky130_fd_sc_hs__xor2_1
Xsky130_fd_sc_hs__xor2_1_36 VDD VSS sky130_fd_sc_hs__xor2_1_36/A sky130_fd_sc_hs__xor2_1_36/B
+ sky130_fd_sc_hs__xor2_1_36/X VSS VDD sky130_fd_sc_hs__xor2_1
Xsky130_fd_sc_hs__xor2_1_47 VDD VSS sky130_fd_sc_hs__xor2_1_47/A sky130_fd_sc_hs__xor2_1_47/B
+ sky130_fd_sc_hs__xor2_1_47/X VSS VDD sky130_fd_sc_hs__xor2_1
Xsky130_fd_sc_hs__xor2_1_58 VDD VSS sky130_fd_sc_hs__xor2_1_58/A sky130_fd_sc_hs__xor2_1_58/B
+ sky130_fd_sc_hs__or2_1_17/A VSS VDD sky130_fd_sc_hs__xor2_1
Xsky130_fd_sc_hs__xor2_1_69 VDD VSS sky130_fd_sc_hs__xor2_1_69/A sky130_fd_sc_hs__xor2_1_69/B
+ sky130_fd_sc_hs__xor2_1_69/X VSS VDD sky130_fd_sc_hs__xor2_1
Xsky130_fd_sc_hs__nand2b_1_16 VDD VSS sky130_fd_sc_hs__maj3_1_13/X sky130_fd_sc_hs__xnor2_1_52/Y
+ sky130_fd_sc_hs__o31ai_1_7/B1 VSS VDD sky130_fd_sc_hs__nand2b_1
Xsky130_fd_sc_hs__nand2b_1_27 VDD VSS sky130_fd_sc_hs__xor2_1_40/B sky130_fd_sc_hs__xor2_1_40/A
+ sky130_fd_sc_hs__nand2_1_75/A VSS VDD sky130_fd_sc_hs__nand2b_1
Xsky130_fd_sc_hs__nand2b_1_38 VDD VSS sky130_fd_sc_hs__and2_1_34/A sky130_fd_sc_hs__nor2_1_131/B
+ sky130_fd_sc_hs__nand4_1_3/B VSS VDD sky130_fd_sc_hs__nand2b_1
Xsky130_fd_sc_hs__nand2b_1_49 VDD VSS sky130_fd_sc_hs__or2_1_21/A sky130_fd_sc_hs__or2_1_21/B
+ sky130_fd_sc_hs__nor2_4_2/A VSS VDD sky130_fd_sc_hs__nand2b_1
Xsky130_fd_sc_hs__nand2b_1_7 VDD VSS sky130_fd_sc_hs__maj3_1_5/X sky130_fd_sc_hs__nand2b_1_7/B
+ sky130_fd_sc_hs__and2_1_10/B VSS VDD sky130_fd_sc_hs__nand2b_1
Xsky130_fd_sc_hs__a221oi_1_5 VDD VSS sky130_fd_sc_hs__nand2_1_26/Y sky130_fd_sc_hs__nand3_1_10/B
+ sky130_fd_sc_hs__mux2_1_101/A1 sky130_fd_sc_hs__buf_16_9/X sky130_fd_sc_hs__mux2_1_106/A0
+ sky130_fd_sc_hs__a222o_1_2/A2 VSS VDD sky130_fd_sc_hs__a221oi_1
Xsky130_fd_sc_hs__dfrtp_1_140 sky130_fd_sc_hs__clkbuf_4_10/X VDD VSS sky130_fd_sc_hs__buf_1_31/A
+ sky130_fd_sc_hs__clkinv_1_36/A sky130_fd_sc_hs__mux2_1_133/X VSS VDD sky130_fd_sc_hs__dfrtp_1
Xsky130_fd_sc_hs__dfrtp_1_151 sky130_fd_sc_hs__clkbuf_4_3/X VDD VSS sky130_fd_sc_hs__mux2_1_128/A1
+ sky130_fd_sc_hs__clkinv_1_37/A sky130_fd_sc_hs__mux2_1_128/X VSS VDD sky130_fd_sc_hs__dfrtp_1
Xsky130_fd_sc_hs__dfrtp_1_162 sky130_fd_sc_hs__clkbuf_4_5/X VDD VSS sky130_fd_sc_hs__mux2_1_150/A1
+ sky130_fd_sc_hs__clkbuf_2_55/X sky130_fd_sc_hs__mux2_1_150/X VSS VDD sky130_fd_sc_hs__dfrtp_1
Xsky130_fd_sc_hs__dfrtp_1_173 sky130_fd_sc_hs__clkbuf_4_10/X VDD VSS sky130_fd_sc_hs__nand2_1_51/A
+ sky130_fd_sc_hs__clkinv_1_41/A sky130_fd_sc_hs__mux2_1_177/X VSS VDD sky130_fd_sc_hs__dfrtp_1
Xsky130_fd_sc_hs__dfrtp_1_184 sky130_fd_sc_hs__clkbuf_16_5/X VDD VSS sky130_fd_sc_hs__buf_1_57/A
+ sky130_fd_sc_hs__clkbuf_2_62/X sky130_fd_sc_hs__o21ai_1_25/Y VSS VDD sky130_fd_sc_hs__dfrtp_1
Xsky130_fd_sc_hs__dfrtp_1_195 sky130_fd_sc_hs__clkbuf_4_3/X VDD VSS sky130_fd_sc_hs__mux2_1_137/A0
+ sky130_fd_sc_hs__clkinv_1_33/A sky130_fd_sc_hs__mux2_1_137/X VSS VDD sky130_fd_sc_hs__dfrtp_1
Xsky130_fd_sc_hs__o21a_1_2 VDD VSS sky130_fd_sc_hs__o21a_1_2/X sky130_fd_sc_hs__o21a_1_2/A2
+ sky130_fd_sc_hs__o21a_1_2/B1 sky130_fd_sc_hs__o21a_1_2/A1 VSS VDD sky130_fd_sc_hs__o21a_1
Xsky130_fd_sc_hs__o311ai_1_20 VDD VSS sky130_fd_sc_hs__or3_1_7/B sky130_fd_sc_hs__or3_1_7/A
+ sky130_fd_sc_hs__and2_1_42/A sky130_fd_sc_hs__o311ai_1_20/B1 sky130_fd_sc_hs__and2_1_40/B
+ sky130_fd_sc_hs__or3_1_7/C VSS VDD sky130_fd_sc_hs__o311ai_1
Xsky130_fd_sc_hs__a32o_1_7 VDD VSS sky130_fd_sc_hs__a32o_1_7/X sky130_fd_sc_hs__xor2_1_44/A
+ sky130_fd_sc_hs__a32o_1_7/B1 sky130_fd_sc_hs__a32o_1_7/A2 sky130_fd_sc_hs__buf_8_14/X
+ sky130_fd_sc_hs__a32o_1_7/A3 VSS VDD sky130_fd_sc_hs__a32o_1
Xsky130_fd_sc_hs__nor2_1_160 VDD VSS sky130_fd_sc_hs__nor2_1_160/B sky130_fd_sc_hs__nor2_1_160/Y
+ sky130_fd_sc_hs__nand4_1_9/C VSS VDD sky130_fd_sc_hs__nor2_1
Xsky130_fd_sc_hs__clkinv_1_3 VDD VSS sky130_fd_sc_hs__clkinv_1_3/A sky130_fd_sc_hs__clkinv_1_3/Y
+ VSS VDD sky130_fd_sc_hs__clkinv_1
Xsky130_fd_sc_hs__nor2_1_171 VDD VSS sky130_fd_sc_hs__and2_1_45/B sky130_fd_sc_hs__nor2_1_172/B
+ sky130_fd_sc_hs__maj3_1_56/A VSS VDD sky130_fd_sc_hs__nor2_1
Xsky130_fd_sc_hs__nor2_1_182 VDD VSS sky130_fd_sc_hs__nor2_1_182/B sky130_fd_sc_hs__nor2_1_182/Y
+ sky130_fd_sc_hs__nor2_1_182/A VSS VDD sky130_fd_sc_hs__nor2_1
Xsky130_fd_sc_hs__a22oi_1_80 VDD VSS sky130_fd_sc_hs__mux2_1_293/A0 sky130_fd_sc_hs__and4_1_7/C
+ sky130_fd_sc_hs__buf_4_3/X sky130_fd_sc_hs__a22o_1_8/A2 sky130_fd_sc_hs__mux2_1_295/A0
+ VSS VDD sky130_fd_sc_hs__a22oi_1
Xsky130_fd_sc_hs__a22oi_1_91 VDD VSS sky130_fd_sc_hs__mux2_1_308/A0 sky130_fd_sc_hs__a22oi_1_91/Y
+ sky130_fd_sc_hs__nor2_2_9/Y sky130_fd_sc_hs__buf_4_7/X sky130_fd_sc_hs__mux2_1_304/A0
+ VSS VDD sky130_fd_sc_hs__a22oi_1
Xsky130_fd_sc_hs__mux2_1_100 VDD VSS sky130_fd_sc_hs__mux2_1_100/X sky130_fd_sc_hs__mux2_1_98/S
+ sky130_fd_sc_hs__mux2_1_100/A0 sky130_fd_sc_hs__mux2_1_99/A0 VSS VDD sky130_fd_sc_hs__mux2_1
Xsky130_fd_sc_hs__xnor3_1_2 VDD VSS sky130_fd_sc_hs__xnor3_1_2/X sky130_fd_sc_hs__xnor3_1_2/B
+ sky130_fd_sc_hs__xnor3_1_2/C sky130_fd_sc_hs__xnor3_1_2/A VSS VDD sky130_fd_sc_hs__xnor3_1
Xsky130_fd_sc_hs__mux2_1_111 VDD VSS sky130_fd_sc_hs__mux2_1_111/X sky130_fd_sc_hs__mux2_1_9/S
+ sky130_fd_sc_hs__mux2_1_111/A0 sky130_fd_sc_hs__a22o_1_61/B2 VSS VDD sky130_fd_sc_hs__mux2_1
Xsky130_fd_sc_hs__mux2_1_122 VDD VSS sky130_fd_sc_hs__mux2_1_122/X sky130_fd_sc_hs__buf_8_3/X
+ sky130_fd_sc_hs__buf_1_32/A sky130_fd_sc_hs__mux2_1_96/A0 VSS VDD sky130_fd_sc_hs__mux2_1
Xsky130_fd_sc_hs__mux2_1_133 VDD VSS sky130_fd_sc_hs__mux2_1_133/X sky130_fd_sc_hs__buf_8_3/X
+ sky130_fd_sc_hs__buf_1_31/A sky130_fd_sc_hs__dfrtp_2_3/Q VSS VDD sky130_fd_sc_hs__mux2_1
Xsky130_fd_sc_hs__mux2_1_144 VDD VSS sky130_fd_sc_hs__mux2_1_144/X sky130_fd_sc_hs__buf_16_0/X
+ sky130_fd_sc_hs__maj3_1_9/C sky130_fd_sc_hs__a22o_1_75/B2 VSS VDD sky130_fd_sc_hs__mux2_1
Xsky130_fd_sc_hs__mux2_1_155 VDD VSS sky130_fd_sc_hs__mux2_1_155/X sky130_fd_sc_hs__mux2_1_7/S
+ sky130_fd_sc_hs__mux2_1_155/A0 sky130_fd_sc_hs__a22o_1_75/B2 VSS VDD sky130_fd_sc_hs__mux2_1
Xsky130_fd_sc_hs__mux2_1_166 VDD VSS sky130_fd_sc_hs__mux2_1_166/X sky130_fd_sc_hs__buf_8_3/X
+ sky130_fd_sc_hs__buf_1_49/A sky130_fd_sc_hs__dfrtp_2_2/Q VSS VDD sky130_fd_sc_hs__mux2_1
Xsky130_fd_sc_hs__mux2_1_177 VDD VSS sky130_fd_sc_hs__mux2_1_177/X sky130_fd_sc_hs__mux2_1_5/S
+ sky130_fd_sc_hs__nand2_1_51/A sky130_fd_sc_hs__a22o_1_75/B2 VSS VDD sky130_fd_sc_hs__mux2_1
Xsky130_fd_sc_hs__mux2_1_188 VDD VSS sky130_fd_sc_hs__mux2_1_188/X sky130_fd_sc_hs__mux2_1_5/S
+ sky130_fd_sc_hs__mux2_1_188/A0 sky130_fd_sc_hs__mux2_1_61/A0 VSS VDD sky130_fd_sc_hs__mux2_1
Xsky130_fd_sc_hs__mux2_1_199 VDD VSS sky130_fd_sc_hs__mux2_1_199/X sky130_fd_sc_hs__nor2_1_82/B
+ sky130_fd_sc_hs__xor2_1_26/A sky130_fd_sc_hs__nor2_1_17/Y VSS VDD sky130_fd_sc_hs__mux2_1
Xsky130_fd_sc_hs__buf_1_5 VDD VSS sky130_fd_sc_hs__buf_1_5/A srm_residue_o[8] VSS
+ VDD sky130_fd_sc_hs__buf_1
Xsky130_fd_sc_hs__or3_1_1 VDD VSS sky130_fd_sc_hs__or3_1_1/A sky130_fd_sc_hs__or3_1_1/B
+ sky130_fd_sc_hs__or3_1_1/C sky130_fd_sc_hs__or3_1_1/X VSS VDD sky130_fd_sc_hs__or3_1
Xsky130_fd_sc_hs__buf_1_103 VDD VSS sky130_fd_sc_hs__buf_1_103/A dac_p_force[15] VSS
+ VDD sky130_fd_sc_hs__buf_1
Xsky130_fd_sc_hs__buf_1_114 VDD VSS sky130_fd_sc_hs__buf_1_114/A dac_p_force[14] VSS
+ VDD sky130_fd_sc_hs__buf_1
Xsky130_fd_sc_hs__buf_1_125 VDD VSS sky130_fd_sc_hs__buf_1_125/A dac_n_force[3] VSS
+ VDD sky130_fd_sc_hs__buf_1
Xsky130_fd_sc_hs__buf_1_136 VDD VSS sky130_fd_sc_hs__buf_1_136/A calib_overrange_bits[18]
+ VSS VDD sky130_fd_sc_hs__buf_1
Xsky130_fd_sc_hs__buf_1_147 VDD VSS sky130_fd_sc_hs__buf_1_147/A raw_code_o[6] VSS
+ VDD sky130_fd_sc_hs__buf_1
Xsky130_fd_sc_hs__buf_1_158 VDD VSS sky130_fd_sc_hs__buf_1_158/A w_wr_en VSS VDD sky130_fd_sc_hs__buf_1
Xsky130_fd_sc_hs__buf_1_169 VDD VSS sky130_fd_sc_hs__buf_1_74/X sky130_fd_sc_hs__buf_8_30/A
+ VSS VDD sky130_fd_sc_hs__buf_1
Xsky130_fd_sc_hs__mux2i_1_5 VDD VSS sky130_fd_sc_hs__nand4_1_7/Y sky130_fd_sc_hs__mux2i_1_5/A1
+ sky130_fd_sc_hs__or2_1_22/B sky130_fd_sc_hs__mux2i_1_5/Y VSS VDD sky130_fd_sc_hs__mux2i_1
Xsky130_fd_sc_hs__a2111oi_1_4 VDD VSS sky130_fd_sc_hs__nand2_1_235/Y sky130_fd_sc_hs__nand2_1_34/Y
+ sky130_fd_sc_hs__nand2_1_231/Y sky130_fd_sc_hs__a222o_1_2/A2 sky130_fd_sc_hs__mux2_1_476/A0
+ sky130_fd_sc_hs__nand2_1_195/B VSS VDD sky130_fd_sc_hs__a2111oi_1
Xsky130_fd_sc_hs__a21oi_1_206 VDD VSS sky130_fd_sc_hs__buf_8_37/X sky130_fd_sc_hs__a21oi_1_206/Y
+ sky130_fd_sc_hs__xor2_1_89/X sky130_fd_sc_hs__maj3_1_62/C VSS VDD sky130_fd_sc_hs__a21oi_1
Xsky130_fd_sc_hs__o211ai_1_7 VDD VSS sky130_fd_sc_hs__nor3_1_26/B sky130_fd_sc_hs__buf_1_87/A
+ sky130_fd_sc_hs__nor2_4_0/A sky130_fd_sc_hs__nor2_1_98/A sky130_fd_sc_hs__nor3_1_26/A
+ VSS VDD sky130_fd_sc_hs__o211ai_1
Xsky130_fd_sc_hs__a31oi_1_5 VDD VSS sky130_fd_sc_hs__nor2_1_54/B sky130_fd_sc_hs__nand3_1_17/Y
+ sky130_fd_sc_hs__buf_1_62/A sky130_fd_sc_hs__nor2_1_40/B sky130_fd_sc_hs__nor3_1_17/A
+ VSS VDD sky130_fd_sc_hs__a31oi_1
Xsky130_fd_sc_hs__a211o_1_1 VDD VSS sky130_fd_sc_hs__a31o_1_8/A3 sky130_fd_sc_hs__nor2_1_68/Y
+ sky130_fd_sc_hs__or2_1_13/B sky130_fd_sc_hs__nand2_1_79/Y sky130_fd_sc_hs__nand2_1_85/A
+ VSS VDD sky130_fd_sc_hs__a211o_1
Xsky130_fd_sc_hs__clkbuf_2_200 VDD VSS sky130_fd_sc_hs__clkbuf_2_200/X sky130_fd_sc_hs__clkinv_2_11/A
+ VSS VDD sky130_fd_sc_hs__clkbuf_2
Xsky130_fd_sc_hs__clkbuf_2_211 VDD VSS sky130_fd_sc_hs__clkinv_1_158/A sky130_fd_sc_hs__clkinv_2_11/A
+ VSS VDD sky130_fd_sc_hs__clkbuf_2
Xsky130_fd_sc_hs__clkbuf_2_222 VDD VSS sky130_fd_sc_hs__clkbuf_2_222/X sky130_fd_sc_hs__clkinv_2_11/A
+ VSS VDD sky130_fd_sc_hs__clkbuf_2
Xsky130_fd_sc_hs__clkbuf_2_233 VDD VSS sky130_fd_sc_hs__clkbuf_2_233/X sky130_fd_sc_hs__clkbuf_8_17/A
+ VSS VDD sky130_fd_sc_hs__clkbuf_2
Xsky130_fd_sc_hs__nand2_1_200 VDD VSS sky130_fd_sc_hs__nand2_1_200/B sky130_fd_sc_hs__o2111a_1_0/C1
+ sky130_fd_sc_hs__nand2_1_200/A VSS VDD sky130_fd_sc_hs__nand2_1
Xsky130_fd_sc_hs__nand2_1_211 VDD VSS sky130_fd_sc_hs__or3b_1_0/A sky130_fd_sc_hs__nor3_4_8/B
+ sky130_fd_sc_hs__or2_1_29/A VSS VDD sky130_fd_sc_hs__nand2_1
Xsky130_fd_sc_hs__nand2_1_222 VDD VSS sky130_fd_sc_hs__nand2_1_222/B sky130_fd_sc_hs__nand2_1_222/Y
+ sky130_fd_sc_hs__nand2_1_222/A VSS VDD sky130_fd_sc_hs__nand2_1
Xsky130_fd_sc_hs__nand2_1_233 VDD VSS sky130_fd_sc_hs__or2_1_12/B sky130_fd_sc_hs__nand2_1_233/Y
+ sky130_fd_sc_hs__xor2_1_45/A VSS VDD sky130_fd_sc_hs__nand2_1
Xsky130_fd_sc_hs__and2_1_40 VDD VSS sky130_fd_sc_hs__and2_1_40/A sky130_fd_sc_hs__and2_1_40/B
+ sky130_fd_sc_hs__or2_1_28/B VSS VDD sky130_fd_sc_hs__and2_1
Xsky130_fd_sc_hs__a22o_1_6 VDD VSS sky130_fd_sc_hs__a22o_1_6/X sky130_fd_sc_hs__a22o_1_6/B2
+ sky130_fd_sc_hs__a22o_1_6/B1 sky130_fd_sc_hs__nand2_1_9/B sky130_fd_sc_hs__buf_1_18/A
+ VSS VDD sky130_fd_sc_hs__a22o_1
Xsky130_fd_sc_hs__o2bb2ai_1_14 VDD VSS sky130_fd_sc_hs__dfrtp_1_393/D sky130_fd_sc_hs__nand2_1_60/Y
+ sky130_fd_sc_hs__or2_1_9/A sky130_fd_sc_hs__and2_1_16/X sky130_fd_sc_hs__nor2_1_48/Y
+ VSS VDD sky130_fd_sc_hs__o2bb2ai_1
Xsky130_fd_sc_hs__o2bb2ai_1_25 VDD VSS sky130_fd_sc_hs__dfrtp_1_369/D sky130_fd_sc_hs__a31o_1_9/X
+ sky130_fd_sc_hs__nor2_1_68/A sky130_fd_sc_hs__a21oi_1_84/Y sky130_fd_sc_hs__a32o_1_7/B1
+ VSS VDD sky130_fd_sc_hs__o2bb2ai_1
Xsky130_fd_sc_hs__o2bb2ai_1_36 VDD VSS sky130_fd_sc_hs__dfrtp_1_500/D sky130_fd_sc_hs__a31oi_1_12/Y
+ sky130_fd_sc_hs__dfrtp_1_500/Q sky130_fd_sc_hs__nand2b_1_51/Y sky130_fd_sc_hs__or2_1_23/X
+ VSS VDD sky130_fd_sc_hs__o2bb2ai_1
Xsky130_fd_sc_hs__o2bb2ai_1_47 VDD VSS sky130_fd_sc_hs__dfrtp_1_491/D sky130_fd_sc_hs__mux2i_1_9/Y
+ sky130_fd_sc_hs__mux2i_1_9/A1 sky130_fd_sc_hs__nand2b_1_51/Y sky130_fd_sc_hs__or2_1_23/X
+ VSS VDD sky130_fd_sc_hs__o2bb2ai_1
Xsky130_fd_sc_hs__o2bb2ai_1_58 VDD VSS sky130_fd_sc_hs__buf_1_111/A sky130_fd_sc_hs__nand4_1_5/C
+ sky130_fd_sc_hs__nor3_1_32/A sky130_fd_sc_hs__nand2_1_165/Y sky130_fd_sc_hs__nand2_1_125/Y
+ VSS VDD sky130_fd_sc_hs__o2bb2ai_1
Xsky130_fd_sc_hs__o2bb2ai_1_69 VDD VSS sky130_fd_sc_hs__dfrtp_2_4/D sky130_fd_sc_hs__nand4b_1_2/B
+ sky130_fd_sc_hs__or3_1_3/C sky130_fd_sc_hs__nor2_1_175/Y sky130_fd_sc_hs__a22o_1_8/A2
+ VSS VDD sky130_fd_sc_hs__o2bb2ai_1
Xsky130_fd_sc_hs__nand3_1_20 VDD VSS sky130_fd_sc_hs__buf_1_67/A sky130_fd_sc_hs__nand3_1_20/Y
+ sky130_fd_sc_hs__and2_1_15/A sky130_fd_sc_hs__and3_1_7/A VSS VDD sky130_fd_sc_hs__nand3_1
Xsky130_fd_sc_hs__nand3_1_31 VDD VSS sky130_fd_sc_hs__nor2_1_159/Y sky130_fd_sc_hs__buf_4_1/A
+ sky130_fd_sc_hs__nor3_1_46/Y sky130_fd_sc_hs__xor2_1_79/X VSS VDD sky130_fd_sc_hs__nand3_1
Xsky130_fd_sc_hs__nand3_1_42 VDD VSS sky130_fd_sc_hs__nor3b_1_2/Y sky130_fd_sc_hs__nand4_1_13/A
+ sky130_fd_sc_hs__a32o_1_9/A3 sky130_fd_sc_hs__nand3_1_42/A VSS VDD sky130_fd_sc_hs__nand3_1
Xsky130_fd_sc_hs__o2bb2ai_1_1 VDD VSS sky130_fd_sc_hs__o2bb2ai_1_1/Y sky130_fd_sc_hs__a21oi_1_5/Y
+ sky130_fd_sc_hs__buf_1_15/A sky130_fd_sc_hs__or2_1_0/X sky130_fd_sc_hs__nand2_1_9/B
+ VSS VDD sky130_fd_sc_hs__o2bb2ai_1
Xsky130_fd_sc_hs__dfrtp_1_706 sky130_fd_sc_hs__clkbuf_4_51/X VDD VSS sky130_fd_sc_hs__nand2_1_220/A
+ sky130_fd_sc_hs__clkbuf_2_217/X sky130_fd_sc_hs__mux2_1_411/X VSS VDD sky130_fd_sc_hs__dfrtp_1
Xsky130_fd_sc_hs__dfrtp_1_717 sky130_fd_sc_hs__clkbuf_4_50/X VDD VSS sky130_fd_sc_hs__mux2_1_423/A0
+ sky130_fd_sc_hs__clkbuf_2_223/X sky130_fd_sc_hs__mux2_1_423/X VSS VDD sky130_fd_sc_hs__dfrtp_1
Xsky130_fd_sc_hs__dfrtp_1_728 sky130_fd_sc_hs__clkbuf_4_50/X VDD VSS sky130_fd_sc_hs__mux2_1_425/A0
+ sky130_fd_sc_hs__clkbuf_2_224/X sky130_fd_sc_hs__mux2_1_425/X VSS VDD sky130_fd_sc_hs__dfrtp_1
Xsky130_fd_sc_hs__dfrtp_1_739 sky130_fd_sc_hs__buf_8_35/X VDD VSS sky130_fd_sc_hs__mux2_1_447/A0
+ sky130_fd_sc_hs__clkbuf_2_231/X sky130_fd_sc_hs__mux2_1_447/X VSS VDD sky130_fd_sc_hs__dfrtp_1
Xsky130_fd_sc_hs__buf_1_50 VDD VSS sky130_fd_sc_hs__buf_1_50/A raw_code_o[1] VSS VDD
+ sky130_fd_sc_hs__buf_1
Xsky130_fd_sc_hs__buf_1_61 VDD VSS sky130_fd_sc_hs__buf_1_61/A srm_total_count[1]
+ VSS VDD sky130_fd_sc_hs__buf_1
Xsky130_fd_sc_hs__buf_1_72 VDD VSS sky130_fd_sc_hs__buf_1_72/A sky130_fd_sc_hs__buf_1_72/X
+ VSS VDD sky130_fd_sc_hs__buf_1
Xsky130_fd_sc_hs__buf_1_83 VDD VSS sky130_fd_sc_hs__buf_8_36/A sky130_fd_sc_hs__buf_8_10/A
+ VSS VDD sky130_fd_sc_hs__buf_1
Xsky130_fd_sc_hs__buf_1_94 VDD VSS start_calib sky130_fd_sc_hs__buf_1_94/X VSS VDD
+ sky130_fd_sc_hs__buf_1
Xsky130_fd_sc_hs__nor2b_1_4 VDD VSS sky130_fd_sc_hs__a31o_1_1/A1 sky130_fd_sc_hs__nor2b_1_4/Y
+ sky130_fd_sc_hs__nor2b_1_4/A VSS VDD sky130_fd_sc_hs__nor2b_1
Xsky130_fd_sc_hs__nand2_1_6 VDD VSS sky130_fd_sc_hs__and2_1_0/B sky130_fd_sc_hs__o31a_1_0/B1
+ sky130_fd_sc_hs__and2_1_0/A VSS VDD sky130_fd_sc_hs__nand2_1
Xsky130_fd_sc_hs__a311oi_1_13 VDD VSS sky130_fd_sc_hs__nand4_1_4/Y sky130_fd_sc_hs__buf_8_27/X
+ sky130_fd_sc_hs__a32o_1_10/A2 sky130_fd_sc_hs__buf_8_3/A sky130_fd_sc_hs__nor2b_1_45/A
+ sky130_fd_sc_hs__a311oi_1_13/Y VSS VDD sky130_fd_sc_hs__a311oi_1
Xsky130_fd_sc_hs__clkbuf_16_15 VDD VSS sky130_fd_sc_hs__clkinv_4_5/A sky130_fd_sc_hs__clkbuf_8_19/X
+ VSS VDD sky130_fd_sc_hs__clkbuf_16
Xsky130_fd_sc_hs__clkbuf_16_26 VDD VSS sky130_fd_sc_hs__a32o_1_2/B1 sky130_fd_sc_hs__nor2_4_3/B
+ VSS VDD sky130_fd_sc_hs__clkbuf_16
Xsky130_fd_sc_hs__nor2_1_2 VDD VSS sky130_fd_sc_hs__nor2_1_2/B sky130_fd_sc_hs__nor3_1_1/B
+ sky130_fd_sc_hs__nor2_1_2/A VSS VDD sky130_fd_sc_hs__nor2_1
Xsky130_fd_sc_hs__dfrtp_1_503 sky130_fd_sc_hs__clkbuf_4_23/X VDD VSS sky130_fd_sc_hs__o22a_1_0/A1
+ sky130_fd_sc_hs__clkbuf_2_149/X sky130_fd_sc_hs__o22a_1_0/X VSS VDD sky130_fd_sc_hs__dfrtp_1
Xsky130_fd_sc_hs__dfrtp_1_514 sky130_fd_sc_hs__clkbuf_4_22/A VDD VSS sky130_fd_sc_hs__mux2i_1_14/A0
+ sky130_fd_sc_hs__clkbuf_2_144/X sky130_fd_sc_hs__dfrtp_1_514/D VSS VDD sky130_fd_sc_hs__dfrtp_1
Xsky130_fd_sc_hs__dfrtp_1_525 sky130_fd_sc_hs__clkbuf_4_19/X VDD VSS sky130_fd_sc_hs__nor2_1_94/A
+ sky130_fd_sc_hs__clkinv_1_102/A sky130_fd_sc_hs__nand4b_1_0/Y VSS VDD sky130_fd_sc_hs__dfrtp_1
Xsky130_fd_sc_hs__dfrtp_1_536 sky130_fd_sc_hs__clkbuf_4_24/X VDD VSS sky130_fd_sc_hs__buf_1_136/A
+ sky130_fd_sc_hs__clkinv_1_109/A sky130_fd_sc_hs__o21ai_1_79/Y VSS VDD sky130_fd_sc_hs__dfrtp_1
Xsky130_fd_sc_hs__dfrtp_1_547 sky130_fd_sc_hs__clkbuf_4_28/X VDD VSS sky130_fd_sc_hs__mux2_1_265/A0
+ sky130_fd_sc_hs__clkinv_1_114/A sky130_fd_sc_hs__mux2_1_265/X VSS VDD sky130_fd_sc_hs__dfrtp_1
Xsky130_fd_sc_hs__dfrtp_1_558 sky130_fd_sc_hs__buf_8_25/X VDD VSS sky130_fd_sc_hs__mux2_1_278/A0
+ sky130_fd_sc_hs__clkinv_1_123/A sky130_fd_sc_hs__mux2_1_278/X VSS VDD sky130_fd_sc_hs__dfrtp_1
Xsky130_fd_sc_hs__dfrtp_1_569 sky130_fd_sc_hs__clkbuf_4_24/X VDD VSS sky130_fd_sc_hs__buf_1_150/A
+ sky130_fd_sc_hs__clkbuf_2_171/X sky130_fd_sc_hs__mux2_1_280/X VSS VDD sky130_fd_sc_hs__dfrtp_1
Xsky130_fd_sc_hs__a21oi_1_10 VDD VSS sky130_fd_sc_hs__nand2_1_14/Y sky130_fd_sc_hs__nand3_1_8/C
+ sky130_fd_sc_hs__a22o_1_8/B1 sky130_fd_sc_hs__xor2_1_1/A VSS VDD sky130_fd_sc_hs__a21oi_1
Xsky130_fd_sc_hs__a21oi_1_21 VDD VSS sky130_fd_sc_hs__buf_8_2/A sky130_fd_sc_hs__o21ai_1_4/B1
+ sky130_fd_sc_hs__a31oi_1_0/Y sky130_fd_sc_hs__xor2_1_19/X VSS VDD sky130_fd_sc_hs__a21oi_1
Xsky130_fd_sc_hs__a21oi_1_32 VDD VSS sky130_fd_sc_hs__o21ai_1_11/Y sky130_fd_sc_hs__a21oi_1_32/Y
+ sky130_fd_sc_hs__and2_1_10/X sky130_fd_sc_hs__o21a_1_3/X VSS VDD sky130_fd_sc_hs__a21oi_1
Xsky130_fd_sc_hs__a21oi_1_43 VDD VSS sky130_fd_sc_hs__buf_8_19/X sky130_fd_sc_hs__a21oi_1_43/Y
+ sky130_fd_sc_hs__o21ai_1_23/Y sky130_fd_sc_hs__a211o_1_0/X VSS VDD sky130_fd_sc_hs__a21oi_1
Xsky130_fd_sc_hs__a21oi_1_54 VDD VSS sky130_fd_sc_hs__nor2_1_44/Y sky130_fd_sc_hs__nor3_1_13/B
+ sky130_fd_sc_hs__nor2_1_44/A sky130_fd_sc_hs__and3_1_5/A VSS VDD sky130_fd_sc_hs__a21oi_1
Xsky130_fd_sc_hs__a21oi_1_65 VDD VSS sky130_fd_sc_hs__and3_1_10/B sky130_fd_sc_hs__nor3_1_18/C
+ sky130_fd_sc_hs__or2_1_8/A sky130_fd_sc_hs__nor2_1_55/A VSS VDD sky130_fd_sc_hs__a21oi_1
Xsky130_fd_sc_hs__a21oi_1_76 VDD VSS sky130_fd_sc_hs__buf_8_12/X sky130_fd_sc_hs__a22o_1_36/B2
+ sky130_fd_sc_hs__o21ai_1_37/Y sky130_fd_sc_hs__xor2_1_31/X VSS VDD sky130_fd_sc_hs__a21oi_1
Xsky130_fd_sc_hs__a21oi_1_87 VDD VSS sky130_fd_sc_hs__nor2b_1_17/Y sky130_fd_sc_hs__a21oi_1_87/Y
+ sky130_fd_sc_hs__and2_1_19/X sky130_fd_sc_hs__xnor2_1_75/A VSS VDD sky130_fd_sc_hs__a21oi_1
Xsky130_fd_sc_hs__a21oi_1_98 VDD VSS sky130_fd_sc_hs__a21oi_1_99/Y sky130_fd_sc_hs__nor2_1_80/B
+ sky130_fd_sc_hs__xnor2_1_83/Y sky130_fd_sc_hs__o21ai_1_7/B1 VSS VDD sky130_fd_sc_hs__a21oi_1
Xsky130_fd_sc_hs__dfrtp_1_30 sky130_fd_sc_hs__clkbuf_4_3/X VDD VSS sky130_fd_sc_hs__mux2_1_31/A0
+ sky130_fd_sc_hs__clkbuf_2_9/X sky130_fd_sc_hs__mux2_1_31/X VSS VDD sky130_fd_sc_hs__dfrtp_1
Xsky130_fd_sc_hs__dfrtp_1_41 sky130_fd_sc_hs__clkbuf_4_4/X VDD VSS sky130_fd_sc_hs__mux2_1_4/A1
+ sky130_fd_sc_hs__clkinv_1_4/A sky130_fd_sc_hs__mux2_1_4/X VSS VDD sky130_fd_sc_hs__dfrtp_1
Xsky130_fd_sc_hs__dfrtp_1_52 sky130_fd_sc_hs__clkbuf_4_12/A VDD VSS sky130_fd_sc_hs__buf_1_13/A
+ sky130_fd_sc_hs__clkinv_1_5/A sky130_fd_sc_hs__a32o_1_0/X VSS VDD sky130_fd_sc_hs__dfrtp_1
Xsky130_fd_sc_hs__dfrtp_1_63 sky130_fd_sc_hs__clkbuf_4_1/X VDD VSS sky130_fd_sc_hs__dfrtp_1_63/Q
+ sky130_fd_sc_hs__clkinv_1_9/A sky130_fd_sc_hs__mux2_1_182/X VSS VDD sky130_fd_sc_hs__dfrtp_1
Xsky130_fd_sc_hs__dfrtp_1_74 sky130_fd_sc_hs__clkbuf_4_0/X VDD VSS sky130_fd_sc_hs__mux2_1_67/A0
+ sky130_fd_sc_hs__clkbuf_2_28/X sky130_fd_sc_hs__mux2_1_67/X VSS VDD sky130_fd_sc_hs__dfrtp_1
Xsky130_fd_sc_hs__dfrtp_1_85 sky130_fd_sc_hs__clkbuf_4_12/A VDD VSS sky130_fd_sc_hs__buf_1_3/A
+ sky130_fd_sc_hs__clkbuf_2_15/X sky130_fd_sc_hs__a22o_1_3/X VSS VDD sky130_fd_sc_hs__dfrtp_1
Xsky130_fd_sc_hs__dfrtp_1_96 sky130_fd_sc_hs__buf_8_0/A VDD VSS sky130_fd_sc_hs__maj3_1_2/C
+ sky130_fd_sc_hs__clkbuf_2_32/X sky130_fd_sc_hs__mux2_1_92/X VSS VDD sky130_fd_sc_hs__dfrtp_1
Xsky130_fd_sc_hs__a222oi_1_7 VDD VSS sky130_fd_sc_hs__a22oi_1_6/A2 sky130_fd_sc_hs__mux2_1_151/A1
+ sky130_fd_sc_hs__a222o_1_3/C2 sky130_fd_sc_hs__nand2_1_33/B sky130_fd_sc_hs__mux2_1_157/A0
+ sky130_fd_sc_hs__nand4_1_1/C sky130_fd_sc_hs__mux2_1_150/A1 VSS VDD sky130_fd_sc_hs__a222oi_1
Xsky130_fd_sc_hs__o221ai_1_1 VDD VSS sky130_fd_sc_hs__o221ai_1_1/Y sky130_fd_sc_hs__o221ai_1_1/B1
+ sky130_fd_sc_hs__or2_1_18/A sky130_fd_sc_hs__buf_8_37/A sky130_fd_sc_hs__a31o_1_14/X
+ sky130_fd_sc_hs__buf_8_36/A VSS VDD sky130_fd_sc_hs__o221ai_1
Xsky130_fd_sc_hs__a22o_1_120 VDD VSS sky130_fd_sc_hs__a22o_1_120/X sky130_fd_sc_hs__a22o_1_120/B2
+ sky130_fd_sc_hs__or2_1_28/X sky130_fd_sc_hs__a32o_1_2/B1 sky130_fd_sc_hs__xor2_1_53/A
+ VSS VDD sky130_fd_sc_hs__a22o_1
Xsky130_fd_sc_hs__a22o_1_131 VDD VSS sky130_fd_sc_hs__buf_1_171/A sky130_fd_sc_hs__nor3b_1_3/Y
+ sky130_fd_sc_hs__nand2_1_125/Y sky130_fd_sc_hs__buf_8_20/X sky130_fd_sc_hs__o32ai_1_0/B2
+ VSS VDD sky130_fd_sc_hs__a22o_1
Xsky130_fd_sc_hs__o31a_1_4 VDD VSS sky130_fd_sc_hs__o31a_1_5/B1 sky130_fd_sc_hs__or3_1_1/X
+ sky130_fd_sc_hs__nor3_4_2/A sky130_fd_sc_hs__nor3_4_1/C sky130_fd_sc_hs__o31a_1_4/X
+ VSS VDD sky130_fd_sc_hs__o31a_1
Xsky130_fd_sc_hs__a22o_1_142 VDD VSS sky130_fd_sc_hs__a22o_1_142/X sky130_fd_sc_hs__mux2_1_473/A1
+ sky130_fd_sc_hs__a22o_1_75/B1 sky130_fd_sc_hs__nor2_1_92/Y sky130_fd_sc_hs__a22o_1_56/B2
+ VSS VDD sky130_fd_sc_hs__a22o_1
Xsky130_fd_sc_hs__nor3_4_0 VDD VSS sky130_fd_sc_hs__or3_1_6/A sky130_fd_sc_hs__nor3_4_0/B
+ sky130_fd_sc_hs__nor3_4_0/C sky130_fd_sc_hs__nor3_4_0/Y VSS VDD sky130_fd_sc_hs__nor3_4
Xsky130_fd_sc_hs__dfrtp_1_300 sky130_fd_sc_hs__buf_8_7/X VDD VSS sky130_fd_sc_hs__xor2_1_24/B
+ sky130_fd_sc_hs__clkinv_1_54/A sky130_fd_sc_hs__mux2_1_196/X VSS VDD sky130_fd_sc_hs__dfrtp_1
Xsky130_fd_sc_hs__dfrtp_1_311 sky130_fd_sc_hs__clkbuf_4_13/X VDD VSS sky130_fd_sc_hs__buf_1_184/A
+ sky130_fd_sc_hs__clkinv_1_55/A sky130_fd_sc_hs__buf_1_72/X VSS VDD sky130_fd_sc_hs__dfrtp_1
Xsky130_fd_sc_hs__dfrtp_1_322 sky130_fd_sc_hs__buf_8_7/X VDD VSS sky130_fd_sc_hs__xor2_1_26/B
+ sky130_fd_sc_hs__clkinv_1_57/A sky130_fd_sc_hs__mux2_1_200/X VSS VDD sky130_fd_sc_hs__dfrtp_1
Xsky130_fd_sc_hs__dfrtp_1_333 sky130_fd_sc_hs__clkbuf_4_15/X VDD VSS sky130_fd_sc_hs__xor2_1_46/A
+ sky130_fd_sc_hs__clkbuf_2_94/X sky130_fd_sc_hs__mux2_1_211/X VSS VDD sky130_fd_sc_hs__dfrtp_1
Xsky130_fd_sc_hs__dfrtp_1_344 sky130_fd_sc_hs__clkbuf_4_56/X VDD VSS sky130_fd_sc_hs__xor2_1_41/A
+ sky130_fd_sc_hs__clkinv_1_65/A sky130_fd_sc_hs__mux2_1_222/X VSS VDD sky130_fd_sc_hs__dfrtp_1
Xsky130_fd_sc_hs__dfrtp_1_355 sky130_fd_sc_hs__clkbuf_4_56/X VDD VSS sky130_fd_sc_hs__a22o_1_64/A1
+ sky130_fd_sc_hs__clkinv_1_71/A sky130_fd_sc_hs__a22o_1_54/X VSS VDD sky130_fd_sc_hs__dfrtp_1
Xsky130_fd_sc_hs__dfrtp_1_366 sky130_fd_sc_hs__clkbuf_4_15/X VDD VSS sky130_fd_sc_hs__a22o_1_62/B2
+ sky130_fd_sc_hs__clkbuf_2_104/X sky130_fd_sc_hs__a22o_1_62/X VSS VDD sky130_fd_sc_hs__dfrtp_1
Xsky130_fd_sc_hs__dfrtp_1_377 sky130_fd_sc_hs__clkbuf_4_14/X VDD VSS sky130_fd_sc_hs__maj3_1_21/C
+ sky130_fd_sc_hs__clkinv_2_6/A sky130_fd_sc_hs__a22o_1_43/X VSS VDD sky130_fd_sc_hs__dfrtp_1
Xsky130_fd_sc_hs__dfrtp_1_388 sky130_fd_sc_hs__clkbuf_4_14/X VDD VSS sky130_fd_sc_hs__a22o_1_69/A1
+ sky130_fd_sc_hs__clkinv_1_63/A sky130_fd_sc_hs__a22o_1_30/X VSS VDD sky130_fd_sc_hs__dfrtp_1
Xsky130_fd_sc_hs__dfrtp_1_399 sky130_fd_sc_hs__buf_8_9/X VDD VSS sky130_fd_sc_hs__or2_1_15/B
+ sky130_fd_sc_hs__dfrtp_2_1/CLK sky130_fd_sc_hs__mux2_1_232/X VSS VDD sky130_fd_sc_hs__dfrtp_1
Xsky130_fd_sc_hs__dlygate4sd3_1_7 VSS VDD raw_bits_i[13] sky130_fd_sc_hs__buf_1_79/A
+ VSS VDD sky130_fd_sc_hs__dlygate4sd3_1
Xsky130_fd_sc_hs__buf_16_13 sky130_fd_sc_hs__mux2_1_94/S VDD VSS sky130_fd_sc_hs__buf_16_13/A
+ VSS VDD sky130_fd_sc_hs__buf_16
Xsky130_fd_sc_hs__and2_1_1 VDD VSS sky130_fd_sc_hs__and2_1_1/A sky130_fd_sc_hs__and2_1_1/B
+ sky130_fd_sc_hs__and2_1_1/X VSS VDD sky130_fd_sc_hs__and2_1
Xsky130_fd_sc_hs__clkbuf_4_10 VDD VSS sky130_fd_sc_hs__buf_8_38/A sky130_fd_sc_hs__clkbuf_4_10/X
+ VSS VDD sky130_fd_sc_hs__clkbuf_4
Xsky130_fd_sc_hs__clkbuf_4_21 VDD VSS sky130_fd_sc_hs__clkbuf_4_21/A sky130_fd_sc_hs__clkbuf_4_22/A
+ VSS VDD sky130_fd_sc_hs__clkbuf_4
Xsky130_fd_sc_hs__clkbuf_4_32 VDD VSS sky130_fd_sc_hs__buf_4_7/X sky130_fd_sc_hs__a222o_1_2/A2
+ VSS VDD sky130_fd_sc_hs__clkbuf_4
Xsky130_fd_sc_hs__clkbuf_4_43 VDD VSS sky130_fd_sc_hs__nor3_4_4/Y sky130_fd_sc_hs__buf_16_9/A
+ VSS VDD sky130_fd_sc_hs__clkbuf_4
Xsky130_fd_sc_hs__clkbuf_4_54 VDD VSS sky130_fd_sc_hs__nor2_1_93/B sky130_fd_sc_hs__buf_16_5/A
+ VSS VDD sky130_fd_sc_hs__clkbuf_4
Xsky130_fd_sc_hs__mux2_1_304 VDD VSS sky130_fd_sc_hs__mux2_1_304/X sky130_fd_sc_hs__buf_8_23/X
+ sky130_fd_sc_hs__mux2_1_304/A0 sky130_fd_sc_hs__mux2_1_477/A1 VSS VDD sky130_fd_sc_hs__mux2_1
Xsky130_fd_sc_hs__mux2_1_315 VDD VSS sky130_fd_sc_hs__mux2_1_315/X sky130_fd_sc_hs__mux2_1_7/S
+ sky130_fd_sc_hs__mux2_1_315/A0 sky130_fd_sc_hs__mux2_1_355/A1 VSS VDD sky130_fd_sc_hs__mux2_1
Xsky130_fd_sc_hs__mux2_1_326 VDD VSS sky130_fd_sc_hs__mux2_1_326/X sky130_fd_sc_hs__buf_4_1/X
+ sky130_fd_sc_hs__dfrtp_2_1/Q sky130_fd_sc_hs__mux2_1_326/A1 VSS VDD sky130_fd_sc_hs__mux2_1
Xsky130_fd_sc_hs__mux2_1_337 VDD VSS sky130_fd_sc_hs__mux2_1_337/X sky130_fd_sc_hs__buf_8_22/X
+ sky130_fd_sc_hs__mux2_1_337/A0 sky130_fd_sc_hs__mux2_1_355/A1 VSS VDD sky130_fd_sc_hs__mux2_1
Xsky130_fd_sc_hs__mux2_1_348 VDD VSS sky130_fd_sc_hs__mux2_1_348/X sky130_fd_sc_hs__buf_16_1/X
+ sky130_fd_sc_hs__mux2_1_348/A0 sky130_fd_sc_hs__a22o_1_95/B2 VSS VDD sky130_fd_sc_hs__mux2_1
Xsky130_fd_sc_hs__mux2_1_359 VDD VSS sky130_fd_sc_hs__mux2_1_359/X sky130_fd_sc_hs__mux2_1_1/S
+ sky130_fd_sc_hs__dfrtp_2_3/Q sky130_fd_sc_hs__mux2_1_359/A1 VSS VDD sky130_fd_sc_hs__mux2_1
Xsky130_fd_sc_hs__xor2_1_15 VDD VSS sky130_fd_sc_hs__maj3_1_9/B sky130_fd_sc_hs__maj3_1_9/C
+ sky130_fd_sc_hs__xor2_1_15/X VSS VDD sky130_fd_sc_hs__xor2_1
Xsky130_fd_sc_hs__xor2_1_26 VDD VSS sky130_fd_sc_hs__xor2_1_26/A sky130_fd_sc_hs__xor2_1_26/B
+ sky130_fd_sc_hs__xor2_1_26/X VSS VDD sky130_fd_sc_hs__xor2_1
Xsky130_fd_sc_hs__xor2_1_37 VDD VSS sky130_fd_sc_hs__xor2_1_37/A sky130_fd_sc_hs__xor2_1_37/B
+ sky130_fd_sc_hs__xor2_1_37/X VSS VDD sky130_fd_sc_hs__xor2_1
Xsky130_fd_sc_hs__xor2_1_48 VDD VSS sky130_fd_sc_hs__xor2_1_48/A sky130_fd_sc_hs__xor2_1_48/B
+ sky130_fd_sc_hs__xor2_1_92/A VSS VDD sky130_fd_sc_hs__xor2_1
Xsky130_fd_sc_hs__xor2_1_59 VDD VSS sky130_fd_sc_hs__xor2_1_59/A sky130_fd_sc_hs__xor2_1_59/B
+ sky130_fd_sc_hs__xor2_1_59/X VSS VDD sky130_fd_sc_hs__xor2_1
Xsky130_fd_sc_hs__nor3_1_50 VDD VSS sky130_fd_sc_hs__nor3_1_50/Y sky130_fd_sc_hs__or3b_1_0/X
+ sky130_fd_sc_hs__or3b_1_1/B sky130_fd_sc_hs__or3b_1_1/A VSS VDD sky130_fd_sc_hs__nor3_1
Xsky130_fd_sc_hs__nand2b_1_17 VDD VSS sky130_fd_sc_hs__xnor2_1_53/Y sky130_fd_sc_hs__o31ai_1_7/Y
+ sky130_fd_sc_hs__a32o_1_5/A2 VSS VDD sky130_fd_sc_hs__nand2b_1
Xsky130_fd_sc_hs__nand2b_1_28 VDD VSS sky130_fd_sc_hs__maj3_1_26/X sky130_fd_sc_hs__xnor2_1_70/Y
+ sky130_fd_sc_hs__and2_1_19/A VSS VDD sky130_fd_sc_hs__nand2b_1
Xsky130_fd_sc_hs__nand2b_1_39 VDD VSS sky130_fd_sc_hs__xor2_1_64/B sky130_fd_sc_hs__xor2_1_64/A
+ sky130_fd_sc_hs__o21a_1_19/B1 VSS VDD sky130_fd_sc_hs__nand2b_1
Xsky130_fd_sc_hs__nand2b_1_8 VDD VSS sky130_fd_sc_hs__xor2_1_6/B sky130_fd_sc_hs__xor2_1_6/A
+ sky130_fd_sc_hs__o21a_1_3/B1 VSS VDD sky130_fd_sc_hs__nand2b_1
Xsky130_fd_sc_hs__a221oi_1_6 VDD VSS sky130_fd_sc_hs__a221o_1_1/X sky130_fd_sc_hs__nand3_1_36/C
+ sky130_fd_sc_hs__mux2_1_318/A1 sky130_fd_sc_hs__clkbuf_8_14/X sky130_fd_sc_hs__mux2_1_321/A0
+ sky130_fd_sc_hs__buf_4_7/X VSS VDD sky130_fd_sc_hs__a221oi_1
Xsky130_fd_sc_hs__dfrtp_1_130 sky130_fd_sc_hs__buf_8_0/A VDD VSS sky130_fd_sc_hs__maj3_1_1/C
+ sky130_fd_sc_hs__clkbuf_2_31/X sky130_fd_sc_hs__mux2_1_119/X VSS VDD sky130_fd_sc_hs__dfrtp_1
Xsky130_fd_sc_hs__dfrtp_1_141 sky130_fd_sc_hs__clkbuf_4_10/X VDD VSS sky130_fd_sc_hs__buf_1_27/A
+ sky130_fd_sc_hs__clkinv_1_36/A sky130_fd_sc_hs__mux2_1_130/X VSS VDD sky130_fd_sc_hs__dfrtp_1
Xsky130_fd_sc_hs__dfrtp_1_152 sky130_fd_sc_hs__clkbuf_4_3/A VDD VSS sky130_fd_sc_hs__maj3_1_9/A
+ sky130_fd_sc_hs__dfrtp_1_8/CLK sky130_fd_sc_hs__o2bb2ai_1_7/Y VSS VDD sky130_fd_sc_hs__dfrtp_1
Xsky130_fd_sc_hs__dfrtp_1_163 sky130_fd_sc_hs__clkbuf_4_5/X VDD VSS sky130_fd_sc_hs__mux2_1_156/A1
+ sky130_fd_sc_hs__clkinv_1_40/A sky130_fd_sc_hs__mux2_1_156/X VSS VDD sky130_fd_sc_hs__dfrtp_1
Xsky130_fd_sc_hs__dfrtp_1_174 sky130_fd_sc_hs__clkbuf_4_10/X VDD VSS sky130_fd_sc_hs__mux2_1_164/A1
+ sky130_fd_sc_hs__clkinv_2_2/A sky130_fd_sc_hs__mux2_1_164/X VSS VDD sky130_fd_sc_hs__dfrtp_1
Xsky130_fd_sc_hs__dfrtp_1_185 sky130_fd_sc_hs__clkbuf_4_10/X VDD VSS sky130_fd_sc_hs__mux2_1_165/A0
+ sky130_fd_sc_hs__clkinv_1_41/A sky130_fd_sc_hs__mux2_1_165/X VSS VDD sky130_fd_sc_hs__dfrtp_1
Xsky130_fd_sc_hs__dfrtp_1_196 sky130_fd_sc_hs__clkbuf_16_5/X VDD VSS sky130_fd_sc_hs__mux2_1_153/A1
+ sky130_fd_sc_hs__clkinv_2_2/A sky130_fd_sc_hs__mux2_1_153/X VSS VDD sky130_fd_sc_hs__dfrtp_1
Xsky130_fd_sc_hs__o21a_1_3 VDD VSS sky130_fd_sc_hs__o21a_1_3/X sky130_fd_sc_hs__or2_1_2/X
+ sky130_fd_sc_hs__o21a_1_3/B1 sky130_fd_sc_hs__xor2_1_6/X VSS VDD sky130_fd_sc_hs__o21a_1
Xsky130_fd_sc_hs__o311ai_1_10 VDD VSS sky130_fd_sc_hs__a311oi_1_5/Y sky130_fd_sc_hs__clkinv_1_66/Y
+ sky130_fd_sc_hs__xnor2_1_64/Y sky130_fd_sc_hs__o21ai_1_39/B1 sky130_fd_sc_hs__a32o_1_6/A3
+ sky130_fd_sc_hs__nor2b_1_18/Y VSS VDD sky130_fd_sc_hs__o311ai_1
Xsky130_fd_sc_hs__o311ai_1_21 VDD VSS sky130_fd_sc_hs__nor2_2_3/A sky130_fd_sc_hs__or3_1_1/X
+ sky130_fd_sc_hs__buf_1_51/A sky130_fd_sc_hs__o31a_1_5/B1 sky130_fd_sc_hs__o31ai_1_17/B1
+ sky130_fd_sc_hs__or3_1_6/C VSS VDD sky130_fd_sc_hs__o311ai_1
Xsky130_fd_sc_hs__a32o_1_8 VDD VSS sky130_fd_sc_hs__a32o_1_8/X sky130_fd_sc_hs__maj3_1_39/C
+ sky130_fd_sc_hs__buf_8_13/X sky130_fd_sc_hs__a32o_1_8/A2 sky130_fd_sc_hs__buf_8_14/X
+ sky130_fd_sc_hs__or3_1_2/X VSS VDD sky130_fd_sc_hs__a32o_1
Xsky130_fd_sc_hs__nor2_1_150 VDD VSS sky130_fd_sc_hs__nor2_1_150/B sky130_fd_sc_hs__nor2_1_150/Y
+ sky130_fd_sc_hs__nor2_1_150/A VSS VDD sky130_fd_sc_hs__nor2_1
Xsky130_fd_sc_hs__clkinv_1_4 VDD VSS sky130_fd_sc_hs__clkinv_1_4/A sky130_fd_sc_hs__clkinv_1_4/Y
+ VSS VDD sky130_fd_sc_hs__clkinv_1
Xsky130_fd_sc_hs__nor2_1_161 VDD VSS sky130_fd_sc_hs__o31ai_2_0/A1 sky130_fd_sc_hs__nor2_1_161/Y
+ sky130_fd_sc_hs__or3_1_6/A VSS VDD sky130_fd_sc_hs__nor2_1
Xsky130_fd_sc_hs__nor2_1_172 VDD VSS sky130_fd_sc_hs__nor2_1_172/B sky130_fd_sc_hs__and2_1_46/B
+ sky130_fd_sc_hs__and2_1_45/X VSS VDD sky130_fd_sc_hs__nor2_1
Xsky130_fd_sc_hs__nor2_1_183 VDD VSS sky130_fd_sc_hs__nor2_1_183/B sky130_fd_sc_hs__nor3_1_53/A
+ sky130_fd_sc_hs__nor2_1_183/A VSS VDD sky130_fd_sc_hs__nor2_1
Xsky130_fd_sc_hs__a22oi_1_70 VDD VSS sky130_fd_sc_hs__mux2_1_464/A1 sky130_fd_sc_hs__nand3_1_32/C
+ sky130_fd_sc_hs__buf_16_9/X sky130_fd_sc_hs__a22o_1_8/A2 sky130_fd_sc_hs__mux2_1_267/A0
+ VSS VDD sky130_fd_sc_hs__a22oi_1
Xsky130_fd_sc_hs__a22oi_1_81 VDD VSS sky130_fd_sc_hs__mux2_1_300/A0 sky130_fd_sc_hs__and4_1_7/D
+ sky130_fd_sc_hs__nor2_2_9/Y sky130_fd_sc_hs__clkbuf_8_15/X sky130_fd_sc_hs__mux2_1_296/A0
+ VSS VDD sky130_fd_sc_hs__a22oi_1
Xsky130_fd_sc_hs__a22oi_1_92 VDD VSS sky130_fd_sc_hs__mux2_1_317/A0 sky130_fd_sc_hs__nand4_1_10/B
+ sky130_fd_sc_hs__nor2_2_9/Y sky130_fd_sc_hs__a222o_1_7/A2 sky130_fd_sc_hs__mux2_1_299/A1
+ VSS VDD sky130_fd_sc_hs__a22oi_1
Xsky130_fd_sc_hs__mux2_1_101 VDD VSS sky130_fd_sc_hs__mux2_1_101/X sky130_fd_sc_hs__mux2_1_99/S
+ sky130_fd_sc_hs__mux2_1_98/A1 sky130_fd_sc_hs__mux2_1_101/A1 VSS VDD sky130_fd_sc_hs__mux2_1
Xsky130_fd_sc_hs__mux2_1_112 VDD VSS sky130_fd_sc_hs__mux2_1_112/X sky130_fd_sc_hs__mux2_1_8/S
+ sky130_fd_sc_hs__mux2_1_112/A0 sky130_fd_sc_hs__a22o_1_64/B2 VSS VDD sky130_fd_sc_hs__mux2_1
Xsky130_fd_sc_hs__mux2_1_123 VDD VSS sky130_fd_sc_hs__mux2_1_123/X sky130_fd_sc_hs__buf_8_3/X
+ sky130_fd_sc_hs__buf_1_24/A sky130_fd_sc_hs__mux2_1_61/A0 VSS VDD sky130_fd_sc_hs__mux2_1
Xsky130_fd_sc_hs__mux2_1_134 VDD VSS sky130_fd_sc_hs__mux2_1_134/X sky130_fd_sc_hs__buf_16_2/X
+ sky130_fd_sc_hs__a22o_1_60/B2 sky130_fd_sc_hs__mux2_1_134/A1 VSS VDD sky130_fd_sc_hs__mux2_1
Xsky130_fd_sc_hs__mux2_1_145 VDD VSS sky130_fd_sc_hs__mux2_1_145/X sky130_fd_sc_hs__mux2_1_7/S
+ sky130_fd_sc_hs__mux2_1_145/A0 sky130_fd_sc_hs__a22o_1_40/B2 VSS VDD sky130_fd_sc_hs__mux2_1
Xsky130_fd_sc_hs__mux2_1_156 VDD VSS sky130_fd_sc_hs__mux2_1_156/X sky130_fd_sc_hs__mux2_1_6/S
+ sky130_fd_sc_hs__a22o_1_75/B2 sky130_fd_sc_hs__mux2_1_156/A1 VSS VDD sky130_fd_sc_hs__mux2_1
Xsky130_fd_sc_hs__mux2_1_167 VDD VSS sky130_fd_sc_hs__mux2_1_167/X sky130_fd_sc_hs__buf_8_3/A
+ sky130_fd_sc_hs__buf_1_183/A sky130_fd_sc_hs__mux2_1_7/A1 VSS VDD sky130_fd_sc_hs__mux2_1
Xsky130_fd_sc_hs__mux2_1_178 VDD VSS sky130_fd_sc_hs__mux2_1_178/X sky130_fd_sc_hs__mux2_1_4/S
+ sky130_fd_sc_hs__a22o_1_60/B2 sky130_fd_sc_hs__mux2_1_178/A1 VSS VDD sky130_fd_sc_hs__mux2_1
Xsky130_fd_sc_hs__mux2_1_189 VDD VSS sky130_fd_sc_hs__mux2_1_189/X sky130_fd_sc_hs__mux2_1_94/S
+ sky130_fd_sc_hs__xor2_1_50/A sky130_fd_sc_hs__mux2_1_61/A0 VSS VDD sky130_fd_sc_hs__mux2_1
Xsky130_fd_sc_hs__buf_1_6 VDD VSS sky130_fd_sc_hs__buf_1_6/A srm_residue_o[3] VSS
+ VDD sky130_fd_sc_hs__buf_1
Xsky130_fd_sc_hs__or3_1_2 VDD VSS sky130_fd_sc_hs__or3_1_2/A sky130_fd_sc_hs__or3_1_2/B
+ sky130_fd_sc_hs__or3_1_2/C sky130_fd_sc_hs__or3_1_2/X VSS VDD sky130_fd_sc_hs__or3_1
Xsky130_fd_sc_hs__buf_1_104 VDD VSS sky130_fd_sc_hs__buf_1_104/A dac_n_force[0] VSS
+ VDD sky130_fd_sc_hs__buf_1
Xsky130_fd_sc_hs__buf_1_115 VDD VSS sky130_fd_sc_hs__o22ai_1_4/Y dac_n_force[18] VSS
+ VDD sky130_fd_sc_hs__buf_1
Xsky130_fd_sc_hs__buf_1_126 VDD VSS sky130_fd_sc_hs__buf_1_126/A dac_n_force[7] VSS
+ VDD sky130_fd_sc_hs__buf_1
Xsky130_fd_sc_hs__buf_1_137 VDD VSS sky130_fd_sc_hs__buf_1_137/A calib_overrange_bits[2]
+ VSS VDD sky130_fd_sc_hs__buf_1
Xsky130_fd_sc_hs__buf_1_148 VDD VSS sky130_fd_sc_hs__buf_1_74/X sky130_fd_sc_hs__buf_8_34/A
+ VSS VDD sky130_fd_sc_hs__buf_1
Xsky130_fd_sc_hs__buf_1_159 VDD VSS sky130_fd_sc_hs__buf_1_159/A calib_overrange_bits[0]
+ VSS VDD sky130_fd_sc_hs__buf_1
Xsky130_fd_sc_hs__mux2i_1_6 VDD VSS sky130_fd_sc_hs__mux2i_1_6/S sky130_fd_sc_hs__or2_1_22/B
+ sky130_fd_sc_hs__o22ai_1_2/B2 sky130_fd_sc_hs__mux2i_1_6/Y VSS VDD sky130_fd_sc_hs__mux2i_1
Xsky130_fd_sc_hs__a21oi_1_207 VDD VSS sky130_fd_sc_hs__buf_8_37/X sky130_fd_sc_hs__o21a_1_30/B1
+ sky130_fd_sc_hs__o21a_1_30/A2 sky130_fd_sc_hs__a21o_1_7/X VSS VDD sky130_fd_sc_hs__a21oi_1
Xsky130_fd_sc_hs__o211ai_1_8 VDD VSS sky130_fd_sc_hs__nor3_1_26/B sky130_fd_sc_hs__o211ai_1_8/Y
+ sky130_fd_sc_hs__nor2_4_0/A sky130_fd_sc_hs__nor2_1_98/B sky130_fd_sc_hs__nor3_1_26/A
+ VSS VDD sky130_fd_sc_hs__o211ai_1
Xsky130_fd_sc_hs__a31oi_1_6 VDD VSS sky130_fd_sc_hs__a31oi_1_6/Y sky130_fd_sc_hs__nand2_1_77/Y
+ sky130_fd_sc_hs__buf_8_12/X sky130_fd_sc_hs__xnor2_1_67/Y sky130_fd_sc_hs__a31o_1_7/A2
+ VSS VDD sky130_fd_sc_hs__a31oi_1
Xsky130_fd_sc_hs__a211o_1_2 VDD VSS sky130_fd_sc_hs__a211o_1_2/X sky130_fd_sc_hs__nand3_1_44/Y
+ sky130_fd_sc_hs__nand4_1_14/Y sky130_fd_sc_hs__a22oi_1_7/B1 sky130_fd_sc_hs__a211o_1_2/A1
+ VSS VDD sky130_fd_sc_hs__a211o_1
Xsky130_fd_sc_hs__clkbuf_2_201 VDD VSS sky130_fd_sc_hs__clkbuf_2_201/X sky130_fd_sc_hs__clkinv_2_11/A
+ VSS VDD sky130_fd_sc_hs__clkbuf_2
Xsky130_fd_sc_hs__clkbuf_2_212 VDD VSS sky130_fd_sc_hs__nor2_4_3/B sky130_fd_sc_hs__o31ai_4_0/Y
+ VSS VDD sky130_fd_sc_hs__clkbuf_2
Xsky130_fd_sc_hs__clkbuf_2_223 VDD VSS sky130_fd_sc_hs__clkbuf_2_223/X sky130_fd_sc_hs__clkinv_2_11/A
+ VSS VDD sky130_fd_sc_hs__clkbuf_2
Xsky130_fd_sc_hs__clkbuf_2_234 VDD VSS sky130_fd_sc_hs__clkbuf_2_234/X sky130_fd_sc_hs__clkbuf_8_17/A
+ VSS VDD sky130_fd_sc_hs__clkbuf_2
Xsky130_fd_sc_hs__nand2_1_201 VDD VSS sky130_fd_sc_hs__xor2_1_80/B sky130_fd_sc_hs__and2_1_43/A
+ sky130_fd_sc_hs__xor2_1_80/A VSS VDD sky130_fd_sc_hs__nand2_1
Xsky130_fd_sc_hs__nand2_1_212 VDD VSS sky130_fd_sc_hs__xor2_1_84/B sky130_fd_sc_hs__nand2_1_212/Y
+ sky130_fd_sc_hs__xor2_1_85/A VSS VDD sky130_fd_sc_hs__nand2_1
Xsky130_fd_sc_hs__nand2_1_223 VDD VSS sky130_fd_sc_hs__nor2_1_183/A sky130_fd_sc_hs__nand2_1_223/Y
+ sky130_fd_sc_hs__nor2_1_180/A VSS VDD sky130_fd_sc_hs__nand2_1
Xsky130_fd_sc_hs__nand2_1_234 VDD VSS sky130_fd_sc_hs__a32o_1_2/B1 sky130_fd_sc_hs__nand2_1_234/Y
+ sky130_fd_sc_hs__or2_1_15/A VSS VDD sky130_fd_sc_hs__nand2_1
Xsky130_fd_sc_hs__and2_1_30 VDD VSS sky130_fd_sc_hs__and2_1_30/A sky130_fd_sc_hs__and2_1_30/B
+ sky130_fd_sc_hs__o31a_1_3/A1 VSS VDD sky130_fd_sc_hs__and2_1
Xsky130_fd_sc_hs__and2_1_41 VDD VSS sky130_fd_sc_hs__nor2_1_77/A sky130_fd_sc_hs__and2_1_41/B
+ sky130_fd_sc_hs__o31a_1_6/A2 VSS VDD sky130_fd_sc_hs__and2_1
Xsky130_fd_sc_hs__a22o_1_7 VDD VSS sky130_fd_sc_hs__a22o_1_7/X sky130_fd_sc_hs__a22o_1_7/B2
+ sky130_fd_sc_hs__o21ai_1_0/Y sky130_fd_sc_hs__nand2_1_9/B sky130_fd_sc_hs__buf_1_4/A
+ VSS VDD sky130_fd_sc_hs__a22o_1
Xsky130_fd_sc_hs__o2bb2ai_1_15 VDD VSS sky130_fd_sc_hs__dfrtp_1_257/D sky130_fd_sc_hs__xnor2_1_47/Y
+ sky130_fd_sc_hs__and3_1_8/B sky130_fd_sc_hs__o31ai_1_6/A1 sky130_fd_sc_hs__a32o_1_4/B1
+ VSS VDD sky130_fd_sc_hs__o2bb2ai_1
Xsky130_fd_sc_hs__o2bb2ai_1_26 VDD VSS sky130_fd_sc_hs__dfrtp_1_403/D sky130_fd_sc_hs__a31o_1_11/X
+ sky130_fd_sc_hs__xnor2_1_84/A sky130_fd_sc_hs__a21oi_1_101/Y sky130_fd_sc_hs__a32o_1_7/B1
+ VSS VDD sky130_fd_sc_hs__o2bb2ai_1
Xsky130_fd_sc_hs__o2bb2ai_1_37 VDD VSS sky130_fd_sc_hs__dfrtp_1_496/D sky130_fd_sc_hs__a31oi_1_13/Y
+ sky130_fd_sc_hs__nor2_1_152/A sky130_fd_sc_hs__nand2b_1_51/Y sky130_fd_sc_hs__or2_1_23/X
+ VSS VDD sky130_fd_sc_hs__o2bb2ai_1
Xsky130_fd_sc_hs__o2bb2ai_1_48 VDD VSS sky130_fd_sc_hs__dfrtp_1_497/D sky130_fd_sc_hs__mux2i_1_10/Y
+ sky130_fd_sc_hs__nand2_1_156/A sky130_fd_sc_hs__nand2b_1_51/Y sky130_fd_sc_hs__or2_1_23/X
+ VSS VDD sky130_fd_sc_hs__o2bb2ai_1
Xsky130_fd_sc_hs__o2bb2ai_1_59 VDD VSS sky130_fd_sc_hs__buf_1_112/A sky130_fd_sc_hs__nand4_1_5/C
+ sky130_fd_sc_hs__o22ai_1_2/A1 sky130_fd_sc_hs__nand2_1_166/Y sky130_fd_sc_hs__nand2_1_125/Y
+ VSS VDD sky130_fd_sc_hs__o2bb2ai_1
Xsky130_fd_sc_hs__nand3_1_10 VDD VSS sky130_fd_sc_hs__nor3_1_8/Y sky130_fd_sc_hs__nand3_1_11/A
+ sky130_fd_sc_hs__nand3_1_10/B sky130_fd_sc_hs__xnor2_1_11/A VSS VDD sky130_fd_sc_hs__nand3_1
Xsky130_fd_sc_hs__nand3_1_21 VDD VSS sky130_fd_sc_hs__nor2_2_2/A sky130_fd_sc_hs__nor2_1_95/B
+ sky130_fd_sc_hs__nor3_1_26/B sky130_fd_sc_hs__nor3_1_26/A VSS VDD sky130_fd_sc_hs__nand3_1
Xsky130_fd_sc_hs__nand3_1_32 VDD VSS sky130_fd_sc_hs__nand3_1_32/C sky130_fd_sc_hs__nand3_1_32/Y
+ sky130_fd_sc_hs__nand3_1_32/B sky130_fd_sc_hs__nand3_1_32/A VSS VDD sky130_fd_sc_hs__nand3_1
Xsky130_fd_sc_hs__nand3_1_43 VDD VSS sky130_fd_sc_hs__nand3_1_43/C sky130_fd_sc_hs__nand3_1_43/Y
+ sky130_fd_sc_hs__nand3_1_43/B sky130_fd_sc_hs__nand3_1_43/A VSS VDD sky130_fd_sc_hs__nand3_1
Xsky130_fd_sc_hs__o2bb2ai_1_2 VDD VSS sky130_fd_sc_hs__dfrtp_1_44/D sky130_fd_sc_hs__a311o_1_0/X
+ sky130_fd_sc_hs__buf_1_5/A sky130_fd_sc_hs__a211oi_1_1/Y sky130_fd_sc_hs__nand2_1_9/B
+ VSS VDD sky130_fd_sc_hs__o2bb2ai_1
Xsky130_fd_sc_hs__dfrtp_1_707 sky130_fd_sc_hs__clkbuf_4_51/X VDD VSS sky130_fd_sc_hs__mux2_1_410/A0
+ sky130_fd_sc_hs__clkbuf_2_217/X sky130_fd_sc_hs__mux2_1_410/X VSS VDD sky130_fd_sc_hs__dfrtp_1
Xsky130_fd_sc_hs__dfrtp_1_718 sky130_fd_sc_hs__clkbuf_4_50/X VDD VSS sky130_fd_sc_hs__mux2_1_472/A1
+ sky130_fd_sc_hs__clkbuf_2_223/X sky130_fd_sc_hs__mux2_1_472/X VSS VDD sky130_fd_sc_hs__dfrtp_1
Xsky130_fd_sc_hs__dfrtp_1_729 sky130_fd_sc_hs__buf_8_34/X VDD VSS sky130_fd_sc_hs__mux2_1_444/A0
+ sky130_fd_sc_hs__clkinv_1_161/A sky130_fd_sc_hs__mux2_1_444/X VSS VDD sky130_fd_sc_hs__dfrtp_1
Xsky130_fd_sc_hs__buf_1_40 VDD VSS sky130_fd_sc_hs__buf_1_40/A raw_code_o[12] VSS
+ VDD sky130_fd_sc_hs__buf_1
Xsky130_fd_sc_hs__buf_1_51 VDD VSS sky130_fd_sc_hs__buf_1_51/A calib_overrange_bits[13]
+ VSS VDD sky130_fd_sc_hs__buf_1
Xsky130_fd_sc_hs__buf_1_62 VDD VSS sky130_fd_sc_hs__buf_1_62/A srm_stalled VSS VDD
+ sky130_fd_sc_hs__buf_1
Xsky130_fd_sc_hs__buf_1_73 VDD VSS sky130_fd_sc_hs__buf_1_73/A sky130_fd_sc_hs__buf_1_73/X
+ VSS VDD sky130_fd_sc_hs__buf_1
Xsky130_fd_sc_hs__buf_1_84 VDD VSS sky130_fd_sc_hs__buf_1_84/A sky130_fd_sc_hs__buf_8_11/A
+ VSS VDD sky130_fd_sc_hs__buf_1
Xsky130_fd_sc_hs__buf_1_95 VDD VSS sky130_fd_sc_hs__buf_1_95/A dac_p_force[16] VSS
+ VDD sky130_fd_sc_hs__buf_1
Xsky130_fd_sc_hs__maj3_1_60 VDD VSS sky130_fd_sc_hs__xor2_1_88/A sky130_fd_sc_hs__xor2_1_88/B
+ sky130_fd_sc_hs__maj3_1_64/B sky130_fd_sc_hs__xor2_1_87/B VSS VDD sky130_fd_sc_hs__maj3_1
Xsky130_fd_sc_hs__nor2b_1_5 VDD VSS sky130_fd_sc_hs__and3_1_3/A sky130_fd_sc_hs__nor2b_1_5/Y
+ sky130_fd_sc_hs__nor2b_1_5/A VSS VDD sky130_fd_sc_hs__nor2b_1
Xsky130_fd_sc_hs__nand2_1_7 VDD VSS sky130_fd_sc_hs__o21ai_1_1/Y sky130_fd_sc_hs__nand2_1_7/Y
+ sky130_fd_sc_hs__nand2_1_7/A VSS VDD sky130_fd_sc_hs__nand2_1
Xsky130_fd_sc_hs__a311oi_1_14 VDD VSS sky130_fd_sc_hs__and2_1_38/X sky130_fd_sc_hs__or2_1_27/A
+ sky130_fd_sc_hs__and2_1_40/B sky130_fd_sc_hs__or2_1_28/A sky130_fd_sc_hs__and2_1_40/A
+ sky130_fd_sc_hs__or3_1_0/C VSS VDD sky130_fd_sc_hs__a311oi_1
Xsky130_fd_sc_hs__o31ai_1_20 VDD VSS sky130_fd_sc_hs__xor2_1_84/X sky130_fd_sc_hs__and3_1_14/X
+ sky130_fd_sc_hs__buf_8_26/X sky130_fd_sc_hs__and2_1_47/X sky130_fd_sc_hs__o31ai_1_20/Y
+ VSS VDD sky130_fd_sc_hs__o31ai_1
Xsky130_fd_sc_hs__clkbuf_16_16 VDD VSS sky130_fd_sc_hs__o21ai_1_7/B1 sky130_fd_sc_hs__nor2_4_2/Y
+ VSS VDD sky130_fd_sc_hs__clkbuf_16
Xsky130_fd_sc_hs__clkbuf_16_27 VDD VSS sky130_fd_sc_hs__clkbuf_16_27/X sky130_fd_sc_hs__clkbuf_2_18/X
+ VSS VDD sky130_fd_sc_hs__clkbuf_16
Xsky130_fd_sc_hs__nor2_1_3 VDD VSS sky130_fd_sc_hs__nor3_1_3/Y sky130_fd_sc_hs__nor2_1_3/Y
+ sky130_fd_sc_hs__nor3_1_5/A VSS VDD sky130_fd_sc_hs__nor2_1
Xsky130_fd_sc_hs__clkbuf_16_0 VDD VSS sky130_fd_sc_hs__clkinv_4_0/A sky130_fd_sc_hs__clkbuf_8_19/X
+ VSS VDD sky130_fd_sc_hs__clkbuf_16
Xsky130_fd_sc_hs__dfrtp_1_504 sky130_fd_sc_hs__clkbuf_4_23/X VDD VSS sky130_fd_sc_hs__mux2i_1_3/A0
+ sky130_fd_sc_hs__clkinv_1_106/A sky130_fd_sc_hs__dfrtp_1_504/D VSS VDD sky130_fd_sc_hs__dfrtp_1
Xsky130_fd_sc_hs__dfrtp_1_515 sky130_fd_sc_hs__clkbuf_4_22/X VDD VSS sky130_fd_sc_hs__xor2_1_62/B
+ sky130_fd_sc_hs__clkinv_1_82/A sky130_fd_sc_hs__dfrtp_1_515/D VSS VDD sky130_fd_sc_hs__dfrtp_1
Xsky130_fd_sc_hs__dfrtp_1_526 sky130_fd_sc_hs__clkbuf_4_23/A VDD VSS sky130_fd_sc_hs__maj3_1_41/C
+ sky130_fd_sc_hs__clkinv_1_97/A sky130_fd_sc_hs__o21ai_1_54/Y VSS VDD sky130_fd_sc_hs__dfrtp_1
Xsky130_fd_sc_hs__dfrtp_1_537 sky130_fd_sc_hs__clkbuf_4_24/X VDD VSS sky130_fd_sc_hs__buf_1_137/A
+ sky130_fd_sc_hs__clkinv_1_111/A sky130_fd_sc_hs__o21ai_1_76/Y VSS VDD sky130_fd_sc_hs__dfrtp_1
Xsky130_fd_sc_hs__dfrtp_1_548 sky130_fd_sc_hs__clkbuf_4_28/X VDD VSS sky130_fd_sc_hs__buf_1_153/A
+ sky130_fd_sc_hs__clkinv_1_116/A sky130_fd_sc_hs__mux2_1_266/X VSS VDD sky130_fd_sc_hs__dfrtp_1
Xsky130_fd_sc_hs__dfrtp_1_559 sky130_fd_sc_hs__buf_8_25/X VDD VSS sky130_fd_sc_hs__or2_1_21/A
+ sky130_fd_sc_hs__clkinv_1_123/A sky130_fd_sc_hs__dfrtp_1_559/D VSS VDD sky130_fd_sc_hs__dfrtp_1
Xsky130_fd_sc_hs__a21oi_1_11 VDD VSS sky130_fd_sc_hs__xor2_1_0/X sky130_fd_sc_hs__o21a_1_0/A1
+ sky130_fd_sc_hs__xnor2_1_5/A sky130_fd_sc_hs__nor3_1_2/A VSS VDD sky130_fd_sc_hs__a21oi_1
Xsky130_fd_sc_hs__a21oi_1_22 VDD VSS sky130_fd_sc_hs__xnor2_1_11/A sky130_fd_sc_hs__o21a_1_2/A1
+ sky130_fd_sc_hs__nor3_1_8/Y sky130_fd_sc_hs__nand3_1_10/B VSS VDD sky130_fd_sc_hs__a21oi_1
Xsky130_fd_sc_hs__a21oi_1_33 VDD VSS sky130_fd_sc_hs__a211oi_1_3/Y sky130_fd_sc_hs__nor2_1_64/B
+ sky130_fd_sc_hs__xnor2_1_17/Y sky130_fd_sc_hs__o21ai_1_7/B1 VSS VDD sky130_fd_sc_hs__a21oi_1
Xsky130_fd_sc_hs__a21oi_1_44 VDD VSS sky130_fd_sc_hs__a21oi_1_46/Y sky130_fd_sc_hs__nor2_1_62/B
+ sky130_fd_sc_hs__xnor2_1_36/Y sky130_fd_sc_hs__o21ai_1_7/B1 VSS VDD sky130_fd_sc_hs__a21oi_1
Xsky130_fd_sc_hs__a21oi_1_55 VDD VSS sky130_fd_sc_hs__and3_1_6/C sky130_fd_sc_hs__nor3_1_15/C
+ sky130_fd_sc_hs__and3_1_6/B sky130_fd_sc_hs__and3_1_6/A VSS VDD sky130_fd_sc_hs__a21oi_1
Xsky130_fd_sc_hs__a21oi_1_66 VDD VSS sky130_fd_sc_hs__and3_1_9/B sky130_fd_sc_hs__nor3_1_19/C
+ sky130_fd_sc_hs__and3_1_9/C sky130_fd_sc_hs__and3_1_9/A VSS VDD sky130_fd_sc_hs__a21oi_1
Xsky130_fd_sc_hs__a21oi_1_77 VDD VSS sky130_fd_sc_hs__a31o_1_3/A1 sky130_fd_sc_hs__a21oi_1_77/Y
+ sky130_fd_sc_hs__a31o_1_3/A3 sky130_fd_sc_hs__a31o_1_3/A2 VSS VDD sky130_fd_sc_hs__a21oi_1
Xsky130_fd_sc_hs__a21oi_1_88 VDD VSS sky130_fd_sc_hs__nor2_1_71/A sky130_fd_sc_hs__xnor2_1_72/A
+ sky130_fd_sc_hs__and2_1_20/X sky130_fd_sc_hs__nor2_1_71/Y VSS VDD sky130_fd_sc_hs__a21oi_1
Xsky130_fd_sc_hs__a21oi_1_99 VDD VSS sky130_fd_sc_hs__o21ai_1_45/Y sky130_fd_sc_hs__a21oi_1_99/Y
+ sky130_fd_sc_hs__xor2_1_55/X sky130_fd_sc_hs__buf_8_10/A VSS VDD sky130_fd_sc_hs__a21oi_1
Xsky130_fd_sc_hs__dfrtp_1_20 sky130_fd_sc_hs__clkbuf_4_3/X VDD VSS sky130_fd_sc_hs__mux2_1_23/A0
+ sky130_fd_sc_hs__clkbuf_2_10/X sky130_fd_sc_hs__mux2_1_23/X VSS VDD sky130_fd_sc_hs__dfrtp_1
Xsky130_fd_sc_hs__dfrtp_1_31 sky130_fd_sc_hs__clkbuf_4_3/X VDD VSS sky130_fd_sc_hs__mux2_1_32/A1
+ sky130_fd_sc_hs__clkbuf_2_10/X sky130_fd_sc_hs__mux2_1_32/X VSS VDD sky130_fd_sc_hs__dfrtp_1
Xsky130_fd_sc_hs__dfrtp_1_42 sky130_fd_sc_hs__clkbuf_4_4/X VDD VSS sky130_fd_sc_hs__mux2_1_16/A1
+ sky130_fd_sc_hs__clkbuf_2_4/X sky130_fd_sc_hs__mux2_1_16/X VSS VDD sky130_fd_sc_hs__dfrtp_1
Xsky130_fd_sc_hs__dfrtp_1_53 sky130_fd_sc_hs__clkbuf_4_12/A VDD VSS sky130_fd_sc_hs__buf_1_11/A
+ sky130_fd_sc_hs__clkinv_1_6/A sky130_fd_sc_hs__a32o_1_1/X VSS VDD sky130_fd_sc_hs__dfrtp_1
Xsky130_fd_sc_hs__dfrtp_1_64 sky130_fd_sc_hs__clkbuf_4_1/X VDD VSS sky130_fd_sc_hs__mux2_1_49/A1
+ sky130_fd_sc_hs__clkinv_1_7/A sky130_fd_sc_hs__mux2_1_49/X VSS VDD sky130_fd_sc_hs__dfrtp_1
Xsky130_fd_sc_hs__dfrtp_1_75 sky130_fd_sc_hs__clkbuf_4_0/X VDD VSS sky130_fd_sc_hs__mux2_1_80/A0
+ sky130_fd_sc_hs__clkbuf_2_28/X sky130_fd_sc_hs__mux2_1_80/X VSS VDD sky130_fd_sc_hs__dfrtp_1
Xsky130_fd_sc_hs__dfrtp_1_86 sky130_fd_sc_hs__clkbuf_4_12/A VDD VSS sky130_fd_sc_hs__buf_1_2/A
+ sky130_fd_sc_hs__clkbuf_2_13/X sky130_fd_sc_hs__a22o_1_1/X VSS VDD sky130_fd_sc_hs__dfrtp_1
Xsky130_fd_sc_hs__dfrtp_1_97 sky130_fd_sc_hs__buf_8_0/A VDD VSS sky130_fd_sc_hs__mux2_1_89/A1
+ sky130_fd_sc_hs__clkbuf_2_32/X sky130_fd_sc_hs__mux2_1_89/X VSS VDD sky130_fd_sc_hs__dfrtp_1
Xsky130_fd_sc_hs__a222oi_1_8 VDD VSS sky130_fd_sc_hs__mux2_1_164/A1 sky130_fd_sc_hs__buf_16_9/X
+ sky130_fd_sc_hs__buf_16_7/X sky130_fd_sc_hs__a22o_1_9/A2 sky130_fd_sc_hs__mux2_1_163/A1
+ sky130_fd_sc_hs__nand4_1_0/D sky130_fd_sc_hs__mux2_1_165/A0 VSS VDD sky130_fd_sc_hs__a222oi_1
Xsky130_fd_sc_hs__o221ai_1_2 VDD VSS sky130_fd_sc_hs__o221ai_1_2/Y sky130_fd_sc_hs__a22oi_1_58/Y
+ sky130_fd_sc_hs__or2_1_22/A sky130_fd_sc_hs__o21a_1_26/A2 sky130_fd_sc_hs__nor2_1_129/Y
+ sky130_fd_sc_hs__nor3b_1_1/B VSS VDD sky130_fd_sc_hs__o221ai_1
Xsky130_fd_sc_hs__a41oi_1_0 VDD VSS sky130_fd_sc_hs__nand4_1_3/D sky130_fd_sc_hs__nor2_2_2/A
+ sky130_fd_sc_hs__buf_1_94/X sky130_fd_sc_hs__and2_1_29/X sky130_fd_sc_hs__nor2_2_2/B
+ sky130_fd_sc_hs__nor2_4_0/B VSS VDD sky130_fd_sc_hs__a41oi_1
Xsky130_fd_sc_hs__a22o_1_110 VDD VSS sky130_fd_sc_hs__buf_1_104/A sky130_fd_sc_hs__nor2_2_2/Y
+ sky130_fd_sc_hs__nor2b_1_33/A sky130_fd_sc_hs__nand2_1_125/Y sky130_fd_sc_hs__o21ai_1_63/B1
+ VSS VDD sky130_fd_sc_hs__a22o_1
Xsky130_fd_sc_hs__a22o_1_121 VDD VSS sky130_fd_sc_hs__a22o_1_121/X sky130_fd_sc_hs__mux2_1_328/A0
+ sky130_fd_sc_hs__nor2_2_9/Y sky130_fd_sc_hs__a222o_1_7/A2 sky130_fd_sc_hs__mux2_1_326/A1
+ VSS VDD sky130_fd_sc_hs__a22o_1
Xsky130_fd_sc_hs__a22o_1_132 VDD VSS sky130_fd_sc_hs__nor3_1_51/B sky130_fd_sc_hs__mux2_1_382/A1
+ sky130_fd_sc_hs__buf_16_8/A sky130_fd_sc_hs__a22oi_1_5/A2 sky130_fd_sc_hs__mux2_1_378/A0
+ VSS VDD sky130_fd_sc_hs__a22o_1
Xsky130_fd_sc_hs__o31a_1_5 VDD VSS sky130_fd_sc_hs__o31a_1_5/B1 sky130_fd_sc_hs__or3_1_1/X
+ sky130_fd_sc_hs__nor3_4_2/A sky130_fd_sc_hs__or3_1_5/B sky130_fd_sc_hs__o31a_1_5/X
+ VSS VDD sky130_fd_sc_hs__o31a_1
Xsky130_fd_sc_hs__a22o_1_143 VDD VSS sky130_fd_sc_hs__a22o_1_143/X sky130_fd_sc_hs__mux2_1_355/A1
+ sky130_fd_sc_hs__a22o_1_75/B1 sky130_fd_sc_hs__nor2_1_92/Y sky130_fd_sc_hs__a22o_1_71/B2
+ VSS VDD sky130_fd_sc_hs__a22o_1
Xsky130_fd_sc_hs__nor3_4_1 VDD VSS sky130_fd_sc_hs__nor3_4_2/A sky130_fd_sc_hs__nor3_4_2/B
+ sky130_fd_sc_hs__nor3_4_1/C sky130_fd_sc_hs__nor3_4_1/Y VSS VDD sky130_fd_sc_hs__nor3_4
Xsky130_fd_sc_hs__dfrtp_1_301 sky130_fd_sc_hs__clkbuf_4_13/X VDD VSS sky130_fd_sc_hs__xor2_1_24/A
+ sky130_fd_sc_hs__clkinv_1_54/A sky130_fd_sc_hs__mux2_1_198/X VSS VDD sky130_fd_sc_hs__dfrtp_1
Xsky130_fd_sc_hs__dfrtp_1_312 sky130_fd_sc_hs__clkbuf_4_13/X VDD VSS sky130_fd_sc_hs__buf_1_50/A
+ sky130_fd_sc_hs__clkinv_1_56/A sky130_fd_sc_hs__buf_1_75/X VSS VDD sky130_fd_sc_hs__dfrtp_1
Xsky130_fd_sc_hs__dfrtp_1_323 sky130_fd_sc_hs__clkbuf_4_13/X VDD VSS sky130_fd_sc_hs__buf_1_37/A
+ sky130_fd_sc_hs__clkinv_2_5/A sky130_fd_sc_hs__buf_1_88/X VSS VDD sky130_fd_sc_hs__dfrtp_1
Xsky130_fd_sc_hs__dfrtp_1_334 sky130_fd_sc_hs__clkbuf_4_15/X VDD VSS sky130_fd_sc_hs__a22o_1_40/B2
+ sky130_fd_sc_hs__clkbuf_2_93/X sky130_fd_sc_hs__a22o_1_40/X VSS VDD sky130_fd_sc_hs__dfrtp_1
Xsky130_fd_sc_hs__dfrtp_1_345 sky130_fd_sc_hs__clkbuf_4_56/X VDD VSS sky130_fd_sc_hs__xor2_1_39/A
+ sky130_fd_sc_hs__clkinv_1_69/A sky130_fd_sc_hs__mux2_1_219/X VSS VDD sky130_fd_sc_hs__dfrtp_1
Xsky130_fd_sc_hs__dfrtp_1_356 sky130_fd_sc_hs__buf_8_9/A VDD VSS sky130_fd_sc_hs__xor2_1_44/A
+ sky130_fd_sc_hs__clkinv_1_71/A sky130_fd_sc_hs__a32o_1_7/X VSS VDD sky130_fd_sc_hs__dfrtp_1
Xsky130_fd_sc_hs__dfrtp_1_367 sky130_fd_sc_hs__clkbuf_4_15/X VDD VSS sky130_fd_sc_hs__a22o_1_60/B2
+ sky130_fd_sc_hs__clkinv_1_73/A sky130_fd_sc_hs__a22o_1_60/X VSS VDD sky130_fd_sc_hs__dfrtp_1
Xsky130_fd_sc_hs__dfrtp_1_378 sky130_fd_sc_hs__buf_8_5/A VDD VSS sky130_fd_sc_hs__and2_1_15/A
+ sky130_fd_sc_hs__clkbuf_8_4/X sky130_fd_sc_hs__buf_1_67/X VSS VDD sky130_fd_sc_hs__dfrtp_1
Xsky130_fd_sc_hs__dfrtp_1_389 sky130_fd_sc_hs__clkbuf_4_14/X VDD VSS sky130_fd_sc_hs__mux2_1_95/A1
+ sky130_fd_sc_hs__clkbuf_2_95/X sky130_fd_sc_hs__a22o_1_45/X VSS VDD sky130_fd_sc_hs__dfrtp_1
Xsky130_fd_sc_hs__dlygate4sd3_1_8 VSS VDD raw_bits_i[14] sky130_fd_sc_hs__buf_1_72/A
+ VSS VDD sky130_fd_sc_hs__dlygate4sd3_1
Xsky130_fd_sc_hs__buf_16_14 sky130_fd_sc_hs__mux2_1_9/S VDD VSS sky130_fd_sc_hs__buf_16_14/A
+ VSS VDD sky130_fd_sc_hs__buf_16
Xsky130_fd_sc_hs__and2_1_2 VDD VSS sky130_fd_sc_hs__maj3_1_4/A sky130_fd_sc_hs__and2_1_2/B
+ sky130_fd_sc_hs__and2_1_2/X VSS VDD sky130_fd_sc_hs__and2_1
Xsky130_fd_sc_hs__clkbuf_4_11 VDD VSS sky130_fd_sc_hs__dfrtp_1_259/Q sky130_fd_sc_hs__clkbuf_4_12/A
+ VSS VDD sky130_fd_sc_hs__clkbuf_4
Xsky130_fd_sc_hs__clkbuf_4_22 VDD VSS sky130_fd_sc_hs__clkbuf_4_22/A sky130_fd_sc_hs__clkbuf_4_22/X
+ VSS VDD sky130_fd_sc_hs__clkbuf_4
Xsky130_fd_sc_hs__clkbuf_4_33 VDD VSS sky130_fd_sc_hs__clkbuf_4_35/X sky130_fd_sc_hs__clkbuf_4_33/X
+ VSS VDD sky130_fd_sc_hs__clkbuf_4
Xsky130_fd_sc_hs__clkbuf_4_44 VDD VSS sky130_fd_sc_hs__buf_8_31/A sky130_fd_sc_hs__a22oi_1_5/A2
+ VSS VDD sky130_fd_sc_hs__clkbuf_4
Xsky130_fd_sc_hs__clkbuf_4_55 VDD VSS sky130_fd_sc_hs__or3_1_5/X sky130_fd_sc_hs__buf_16_15/A
+ VSS VDD sky130_fd_sc_hs__clkbuf_4
Xsky130_fd_sc_hs__mux2_1_305 VDD VSS sky130_fd_sc_hs__mux2_1_305/X sky130_fd_sc_hs__buf_8_24/X
+ sky130_fd_sc_hs__mux2_1_473/A1 sky130_fd_sc_hs__mux2_1_305/A1 VSS VDD sky130_fd_sc_hs__mux2_1
Xsky130_fd_sc_hs__mux2_1_316 VDD VSS sky130_fd_sc_hs__mux2_1_316/X sky130_fd_sc_hs__nor2_1_93/B
+ sky130_fd_sc_hs__mux2_1_316/A0 sky130_fd_sc_hs__mux2_1_355/A1 VSS VDD sky130_fd_sc_hs__mux2_1
Xsky130_fd_sc_hs__mux2_1_327 VDD VSS sky130_fd_sc_hs__mux2_1_327/X sky130_fd_sc_hs__mux2_1_464/S
+ sky130_fd_sc_hs__mux2_1_355/A1 sky130_fd_sc_hs__mux2_1_327/A1 VSS VDD sky130_fd_sc_hs__mux2_1
Xsky130_fd_sc_hs__mux2_1_338 VDD VSS sky130_fd_sc_hs__mux2_1_338/X sky130_fd_sc_hs__buf_8_22/X
+ sky130_fd_sc_hs__mux2_1_338/A0 sky130_fd_sc_hs__mux2_1_477/A1 VSS VDD sky130_fd_sc_hs__mux2_1
Xsky130_fd_sc_hs__mux2_1_349 VDD VSS sky130_fd_sc_hs__mux2_1_349/X sky130_fd_sc_hs__mux2_1_99/S
+ sky130_fd_sc_hs__a22o_1_95/B2 sky130_fd_sc_hs__mux2_1_349/A1 VSS VDD sky130_fd_sc_hs__mux2_1
Xsky130_fd_sc_hs__xor2_1_16 VDD VSS sky130_fd_sc_hs__maj3_1_9/A sky130_fd_sc_hs__maj3_1_9/B
+ sky130_fd_sc_hs__xor2_1_16/X VSS VDD sky130_fd_sc_hs__xor2_1
Xsky130_fd_sc_hs__xor2_1_27 VDD VSS sky130_fd_sc_hs__xor2_1_27/A sky130_fd_sc_hs__xor2_1_27/B
+ sky130_fd_sc_hs__xor2_1_27/X VSS VDD sky130_fd_sc_hs__xor2_1
Xsky130_fd_sc_hs__xor2_1_38 VDD VSS sky130_fd_sc_hs__xor2_1_38/A sky130_fd_sc_hs__xor2_1_38/B
+ sky130_fd_sc_hs__xor2_1_38/X VSS VDD sky130_fd_sc_hs__xor2_1
Xsky130_fd_sc_hs__xor2_1_49 VDD VSS sky130_fd_sc_hs__xor2_1_49/A sky130_fd_sc_hs__xor2_1_49/B
+ sky130_fd_sc_hs__xor2_1_49/X VSS VDD sky130_fd_sc_hs__xor2_1
Xsky130_fd_sc_hs__nor3_1_40 VDD VSS sky130_fd_sc_hs__nor3_1_40/Y sky130_fd_sc_hs__or2_1_30/B
+ sky130_fd_sc_hs__or2_1_30/A sky130_fd_sc_hs__nor3_1_44/B VSS VDD sky130_fd_sc_hs__nor3_1
Xsky130_fd_sc_hs__nor3_1_51 VDD VSS sky130_fd_sc_hs__nor3_1_51/Y sky130_fd_sc_hs__nor3_1_51/C
+ sky130_fd_sc_hs__nor3_1_51/B sky130_fd_sc_hs__nor3_1_51/A VSS VDD sky130_fd_sc_hs__nor3_1
Xsky130_fd_sc_hs__nand2b_1_18 VDD VSS sky130_fd_sc_hs__xnor2_1_54/Y sky130_fd_sc_hs__maj3_1_14/X
+ sky130_fd_sc_hs__a31o_1_6/A1 VSS VDD sky130_fd_sc_hs__nand2b_1
Xsky130_fd_sc_hs__nand2b_1_29 VDD VSS sky130_fd_sc_hs__xnor2_1_70/Y sky130_fd_sc_hs__maj3_1_26/X
+ sky130_fd_sc_hs__nand2_1_91/A VSS VDD sky130_fd_sc_hs__nand2b_1
Xsky130_fd_sc_hs__nand2b_1_9 VDD VSS sky130_fd_sc_hs__xor2_1_8/B sky130_fd_sc_hs__xor2_1_8/A
+ sky130_fd_sc_hs__o21a_1_11/B1 VSS VDD sky130_fd_sc_hs__nand2b_1
Xsky130_fd_sc_hs__a221oi_1_7 VDD VSS sky130_fd_sc_hs__nand2_1_203/Y sky130_fd_sc_hs__and3_1_13/B
+ sky130_fd_sc_hs__mux2_1_340/A1 sky130_fd_sc_hs__a222o_1_3/C2 sky130_fd_sc_hs__mux2_1_341/A1
+ sky130_fd_sc_hs__a22o_1_9/A2 VSS VDD sky130_fd_sc_hs__a221oi_1
Xsky130_fd_sc_hs__dfrtp_1_120 sky130_fd_sc_hs__clkbuf_4_2/X VDD VSS sky130_fd_sc_hs__mux2_1_114/A1
+ sky130_fd_sc_hs__clkbuf_2_40/X sky130_fd_sc_hs__mux2_1_114/X VSS VDD sky130_fd_sc_hs__dfrtp_1
Xsky130_fd_sc_hs__dfrtp_1_131 sky130_fd_sc_hs__clkbuf_4_1/X VDD VSS sky130_fd_sc_hs__mux2_1_96/A1
+ sky130_fd_sc_hs__clkbuf_2_35/X sky130_fd_sc_hs__mux2_1_96/X VSS VDD sky130_fd_sc_hs__dfrtp_1
Xsky130_fd_sc_hs__dfrtp_1_142 sky130_fd_sc_hs__clkbuf_4_10/X VDD VSS sky130_fd_sc_hs__buf_1_30/A
+ sky130_fd_sc_hs__clkinv_1_36/A sky130_fd_sc_hs__mux2_1_172/X VSS VDD sky130_fd_sc_hs__dfrtp_1
Xsky130_fd_sc_hs__dfrtp_1_153 sky130_fd_sc_hs__clkbuf_4_4/X VDD VSS sky130_fd_sc_hs__maj3_1_7/A
+ sky130_fd_sc_hs__dfrtp_1_8/CLK sky130_fd_sc_hs__o2bb2ai_1_8/Y VSS VDD sky130_fd_sc_hs__dfrtp_1
Xsky130_fd_sc_hs__dfrtp_1_164 sky130_fd_sc_hs__clkbuf_4_5/X VDD VSS sky130_fd_sc_hs__mux2_1_155/A0
+ sky130_fd_sc_hs__clkinv_1_40/A sky130_fd_sc_hs__mux2_1_155/X VSS VDD sky130_fd_sc_hs__dfrtp_1
Xsky130_fd_sc_hs__dfrtp_1_175 sky130_fd_sc_hs__clkbuf_16_5/X VDD VSS sky130_fd_sc_hs__buf_1_56/A
+ sky130_fd_sc_hs__clkinv_1_42/A sky130_fd_sc_hs__o41ai_1_3/Y VSS VDD sky130_fd_sc_hs__dfrtp_1
Xsky130_fd_sc_hs__dfrtp_1_186 sky130_fd_sc_hs__clkbuf_16_5/X VDD VSS sky130_fd_sc_hs__buf_1_49/A
+ sky130_fd_sc_hs__clkbuf_2_62/X sky130_fd_sc_hs__mux2_1_166/X VSS VDD sky130_fd_sc_hs__dfrtp_1
Xsky130_fd_sc_hs__dfrtp_1_197 sky130_fd_sc_hs__clkbuf_4_3/A VDD VSS sky130_fd_sc_hs__xor2_1_9/B
+ sky130_fd_sc_hs__clkinv_1_33/A sky130_fd_sc_hs__mux2_1_176/X VSS VDD sky130_fd_sc_hs__dfrtp_1
Xsky130_fd_sc_hs__buf_8_0 VDD VSS sky130_fd_sc_hs__buf_8_0/X sky130_fd_sc_hs__buf_8_0/A
+ VSS VDD sky130_fd_sc_hs__buf_8
Xsky130_fd_sc_hs__o21a_1_4 VDD VSS sky130_fd_sc_hs__o21a_1_4/X sky130_fd_sc_hs__o21a_1_4/A2
+ sky130_fd_sc_hs__o21a_1_4/B1 sky130_fd_sc_hs__o21a_1_4/A1 VSS VDD sky130_fd_sc_hs__o21a_1
Xsky130_fd_sc_hs__o311ai_1_11 VDD VSS sky130_fd_sc_hs__nor3_1_20/B sky130_fd_sc_hs__nor3_1_20/A
+ sky130_fd_sc_hs__nand2_1_88/Y sky130_fd_sc_hs__and2_1_50/A sky130_fd_sc_hs__and2_1_5/B
+ sky130_fd_sc_hs__nor3_1_20/C VSS VDD sky130_fd_sc_hs__o311ai_1
Xsky130_fd_sc_hs__o311ai_1_22 VDD VSS sky130_fd_sc_hs__or3_1_6/B sky130_fd_sc_hs__or3_1_1/X
+ sky130_fd_sc_hs__buf_1_178/A sky130_fd_sc_hs__o31a_1_5/B1 sky130_fd_sc_hs__o311ai_1_22/Y
+ sky130_fd_sc_hs__or3_1_6/C VSS VDD sky130_fd_sc_hs__o311ai_1
Xsky130_fd_sc_hs__inv_8_0 VDD VSS sky130_fd_sc_hs__inv_8_0/A sky130_fd_sc_hs__inv_8_0/Y
+ VSS VDD sky130_fd_sc_hs__inv_8
Xsky130_fd_sc_hs__a32o_1_9 VDD VSS sky130_fd_sc_hs__a32o_1_9/X sky130_fd_sc_hs__or3b_1_1/B
+ sky130_fd_sc_hs__a32o_1_9/B1 sky130_fd_sc_hs__and2_1_33/X sky130_fd_sc_hs__or3_1_3/C
+ sky130_fd_sc_hs__a32o_1_9/A3 VSS VDD sky130_fd_sc_hs__a32o_1
Xsky130_fd_sc_hs__nor2_1_140 VDD VSS sky130_fd_sc_hs__o21a_1_27/A2 sky130_fd_sc_hs__o22a_1_0/A2
+ sky130_fd_sc_hs__or2_1_23/X VSS VDD sky130_fd_sc_hs__nor2_1
Xsky130_fd_sc_hs__nor2_1_151 VDD VSS sky130_fd_sc_hs__or2_1_30/B sky130_fd_sc_hs__nor3_1_32/B
+ sky130_fd_sc_hs__nor3_1_44/B VSS VDD sky130_fd_sc_hs__nor2_1
Xsky130_fd_sc_hs__clkinv_1_5 VDD VSS sky130_fd_sc_hs__clkinv_1_5/A sky130_fd_sc_hs__clkinv_1_5/Y
+ VSS VDD sky130_fd_sc_hs__clkinv_1
Xsky130_fd_sc_hs__nor2_1_162 VDD VSS sky130_fd_sc_hs__nor2_1_162/B sky130_fd_sc_hs__nor2_1_162/Y
+ sky130_fd_sc_hs__nor2b_1_45/A VSS VDD sky130_fd_sc_hs__nor2_1
Xsky130_fd_sc_hs__nor2_1_173 VDD VSS sky130_fd_sc_hs__nor2_1_174/Y sky130_fd_sc_hs__a21o_1_7/A2
+ sky130_fd_sc_hs__and2_1_48/X VSS VDD sky130_fd_sc_hs__nor2_1
Xsky130_fd_sc_hs__a22oi_1_60 VDD VSS sky130_fd_sc_hs__nor2_1_150/A sky130_fd_sc_hs__a22oi_1_60/Y
+ sky130_fd_sc_hs__nor2_1_176/Y sky130_fd_sc_hs__and2_1_33/X sky130_fd_sc_hs__mux2i_1_4/A1
+ VSS VDD sky130_fd_sc_hs__a22oi_1
Xsky130_fd_sc_hs__nor2_1_184 VDD VSS sky130_fd_sc_hs__and2_1_46/X sky130_fd_sc_hs__nor2_1_184/Y
+ sky130_fd_sc_hs__and2_1_45/X VSS VDD sky130_fd_sc_hs__nor2_1
Xsky130_fd_sc_hs__a22oi_1_71 VDD VSS sky130_fd_sc_hs__mux2_1_474/A0 sky130_fd_sc_hs__nand3_1_32/A
+ sky130_fd_sc_hs__buf_16_7/X sky130_fd_sc_hs__a22o_1_8/B1 sky130_fd_sc_hs__xor2_1_18/B
+ VSS VDD sky130_fd_sc_hs__a22oi_1
Xsky130_fd_sc_hs__a22oi_1_82 VDD VSS sky130_fd_sc_hs__mux2_1_303/A0 sky130_fd_sc_hs__and4_1_6/D
+ sky130_fd_sc_hs__nor2_2_9/Y sky130_fd_sc_hs__buf_4_5/X sky130_fd_sc_hs__mux2_1_301/A0
+ VSS VDD sky130_fd_sc_hs__a22oi_1
Xsky130_fd_sc_hs__a22oi_1_93 VDD VSS sky130_fd_sc_hs__mux2_1_364/A0 sky130_fd_sc_hs__nand3_1_37/C
+ sky130_fd_sc_hs__buf_16_7/X sky130_fd_sc_hs__buf_4_4/X sky130_fd_sc_hs__xor2_1_83/B
+ VSS VDD sky130_fd_sc_hs__a22oi_1
Xsky130_fd_sc_hs__mux2_1_102 VDD VSS sky130_fd_sc_hs__mux2_1_102/X sky130_fd_sc_hs__buf_16_3/A
+ sky130_fd_sc_hs__mux2_1_98/A1 sky130_fd_sc_hs__mux2_1_102/A1 VSS VDD sky130_fd_sc_hs__mux2_1
Xsky130_fd_sc_hs__mux2_1_113 VDD VSS sky130_fd_sc_hs__mux2_1_113/X sky130_fd_sc_hs__mux2_1_6/S
+ sky130_fd_sc_hs__a22o_1_64/B2 sky130_fd_sc_hs__mux2_1_113/A1 VSS VDD sky130_fd_sc_hs__mux2_1
Xsky130_fd_sc_hs__mux2_1_124 VDD VSS sky130_fd_sc_hs__mux2_1_124/X sky130_fd_sc_hs__buf_8_3/X
+ sky130_fd_sc_hs__buf_1_23/A sky130_fd_sc_hs__mux2_1_85/A0 VSS VDD sky130_fd_sc_hs__mux2_1
Xsky130_fd_sc_hs__mux2_1_135 VDD VSS sky130_fd_sc_hs__mux2_1_135/X sky130_fd_sc_hs__buf_16_1/A
+ sky130_fd_sc_hs__mux2_1_135/A0 sky130_fd_sc_hs__a22o_1_60/B2 VSS VDD sky130_fd_sc_hs__mux2_1
Xsky130_fd_sc_hs__mux2_1_146 VDD VSS sky130_fd_sc_hs__mux2_1_146/X sky130_fd_sc_hs__mux2_1_5/S
+ sky130_fd_sc_hs__mux2_1_146/A0 sky130_fd_sc_hs__a22o_1_40/B2 VSS VDD sky130_fd_sc_hs__mux2_1
Xsky130_fd_sc_hs__mux2_1_157 VDD VSS sky130_fd_sc_hs__mux2_1_157/X sky130_fd_sc_hs__mux2_1_9/S
+ sky130_fd_sc_hs__mux2_1_157/A0 sky130_fd_sc_hs__a22o_1_40/B2 VSS VDD sky130_fd_sc_hs__mux2_1
Xsky130_fd_sc_hs__mux2_1_168 VDD VSS sky130_fd_sc_hs__mux2_1_168/X sky130_fd_sc_hs__buf_8_3/A
+ sky130_fd_sc_hs__buf_1_44/A sky130_fd_sc_hs__mux2_1_355/A1 VSS VDD sky130_fd_sc_hs__mux2_1
Xsky130_fd_sc_hs__a21oi_4_0 VDD VSS sky130_fd_sc_hs__nand4_1_5/D sky130_fd_sc_hs__or3_1_3/B
+ sky130_fd_sc_hs__nor2_1_157/Y sky130_fd_sc_hs__nor2_1_94/A VSS VDD sky130_fd_sc_hs__a21oi_4
Xsky130_fd_sc_hs__mux2_1_179 VDD VSS sky130_fd_sc_hs__mux2_1_179/X sky130_fd_sc_hs__buf_16_1/A
+ sky130_fd_sc_hs__a22oi_1_4/B2 sky130_fd_sc_hs__mux2_1_9/A1 VSS VDD sky130_fd_sc_hs__mux2_1
Xsky130_fd_sc_hs__buf_1_7 VDD VSS sky130_fd_sc_hs__buf_1_7/A srm_residue_o[7] VSS
+ VDD sky130_fd_sc_hs__buf_1
Xsky130_fd_sc_hs__or3_1_3 VDD VSS sky130_fd_sc_hs__or3_1_3/A sky130_fd_sc_hs__or3_1_3/B
+ sky130_fd_sc_hs__or3_1_3/C sky130_fd_sc_hs__or3_1_3/X VSS VDD sky130_fd_sc_hs__or3_1
Xsky130_fd_sc_hs__buf_1_105 VDD VSS sky130_fd_sc_hs__buf_1_105/A dac_p_force[0] VSS
+ VDD sky130_fd_sc_hs__buf_1
Xsky130_fd_sc_hs__buf_1_116 VDD VSS sky130_fd_sc_hs__buf_1_116/A dac_n_force[1] VSS
+ VDD sky130_fd_sc_hs__buf_1
Xsky130_fd_sc_hs__buf_1_127 VDD VSS sky130_fd_sc_hs__o22ai_1_5/Y dac_p_force[18] VSS
+ VDD sky130_fd_sc_hs__buf_1
Xsky130_fd_sc_hs__buf_1_138 VDD VSS sky130_fd_sc_hs__buf_1_138/A calib_overrange_bits[7]
+ VSS VDD sky130_fd_sc_hs__buf_1
Xsky130_fd_sc_hs__buf_1_149 VDD VSS sky130_fd_sc_hs__buf_8_34/A sky130_fd_sc_hs__buf_8_29/A
+ VSS VDD sky130_fd_sc_hs__buf_1
Xsky130_fd_sc_hs__mux2i_1_7 VDD VSS sky130_fd_sc_hs__mux2i_1_7/S sky130_fd_sc_hs__or2_1_22/B
+ sky130_fd_sc_hs__nor3_1_32/A sky130_fd_sc_hs__mux2i_1_7/Y VSS VDD sky130_fd_sc_hs__mux2i_1
Xsky130_fd_sc_hs__a21oi_1_208 VDD VSS sky130_fd_sc_hs__mux2i_1_3/A0 sky130_fd_sc_hs__o22ai_1_14/A2
+ sky130_fd_sc_hs__nor3_1_34/Y sky130_fd_sc_hs__or2_1_21/B VSS VDD sky130_fd_sc_hs__a21oi_1
Xsky130_fd_sc_hs__o31ai_2_0 VDD VSS sky130_fd_sc_hs__xor2_1_79/X sky130_fd_sc_hs__o31ai_2_0/B1
+ sky130_fd_sc_hs__or2_1_26/A sky130_fd_sc_hs__o31ai_2_0/A1 sky130_fd_sc_hs__buf_4_2/A
+ VSS VDD sky130_fd_sc_hs__o31ai_2
Xsky130_fd_sc_hs__o211ai_1_9 VDD VSS sky130_fd_sc_hs__o211ai_1_9/B1 sky130_fd_sc_hs__buf_1_128/A
+ sky130_fd_sc_hs__nor2_2_2/B sky130_fd_sc_hs__nor2_4_0/Y sky130_fd_sc_hs__or3_1_1/C
+ VSS VDD sky130_fd_sc_hs__o211ai_1
Xsky130_fd_sc_hs__a31oi_1_7 VDD VSS sky130_fd_sc_hs__a31oi_1_7/Y sky130_fd_sc_hs__a21o_1_4/B1
+ sky130_fd_sc_hs__buf_8_12/X sky130_fd_sc_hs__a32o_1_7/A3 sky130_fd_sc_hs__a21o_1_4/A1
+ VSS VDD sky130_fd_sc_hs__a31oi_1
Xsky130_fd_sc_hs__clkbuf_2_202 VDD VSS sky130_fd_sc_hs__clkbuf_2_202/X sky130_fd_sc_hs__clkinv_2_11/A
+ VSS VDD sky130_fd_sc_hs__clkbuf_2
Xsky130_fd_sc_hs__clkbuf_2_213 VDD VSS sky130_fd_sc_hs__clkbuf_2_213/X sky130_fd_sc_hs__clkinv_2_11/A
+ VSS VDD sky130_fd_sc_hs__clkbuf_2
Xsky130_fd_sc_hs__o21a_1_30 VDD VSS sky130_fd_sc_hs__o21a_1_30/X sky130_fd_sc_hs__o21a_1_30/A2
+ sky130_fd_sc_hs__o21a_1_30/B1 sky130_fd_sc_hs__a21o_1_7/X VSS VDD sky130_fd_sc_hs__o21a_1
Xsky130_fd_sc_hs__clkbuf_2_224 VDD VSS sky130_fd_sc_hs__clkbuf_2_224/X sky130_fd_sc_hs__clkinv_2_11/A
+ VSS VDD sky130_fd_sc_hs__clkbuf_2
Xsky130_fd_sc_hs__clkbuf_2_235 VDD VSS sky130_fd_sc_hs__clkbuf_2_235/X sky130_fd_sc_hs__clkbuf_8_17/A
+ VSS VDD sky130_fd_sc_hs__clkbuf_2
Xsky130_fd_sc_hs__nand2_1_202 VDD VSS sky130_fd_sc_hs__a22oi_1_88/Y sky130_fd_sc_hs__nand2_1_202/Y
+ sky130_fd_sc_hs__a22oi_1_87/Y VSS VDD sky130_fd_sc_hs__nand2_1
Xsky130_fd_sc_hs__nand2_1_213 VDD VSS sky130_fd_sc_hs__nand2_1_213/B sky130_fd_sc_hs__nand2_1_213/Y
+ sky130_fd_sc_hs__a221oi_1_8/Y VSS VDD sky130_fd_sc_hs__nand2_1
Xsky130_fd_sc_hs__nand2_1_224 VDD VSS sky130_fd_sc_hs__xnor3_1_1/B sky130_fd_sc_hs__nand2_1_224/Y
+ sky130_fd_sc_hs__xnor3_1_1/A VSS VDD sky130_fd_sc_hs__nand2_1
Xsky130_fd_sc_hs__nand2_1_235 VDD VSS sky130_fd_sc_hs__a22oi_1_85/Y sky130_fd_sc_hs__nand2_1_235/Y
+ sky130_fd_sc_hs__a222oi_1_2/Y VSS VDD sky130_fd_sc_hs__nand2_1
Xsky130_fd_sc_hs__and2_1_20 VDD VSS sky130_fd_sc_hs__or2_1_15/X sky130_fd_sc_hs__and2_1_20/B
+ sky130_fd_sc_hs__and2_1_20/X VSS VDD sky130_fd_sc_hs__and2_1
Xsky130_fd_sc_hs__and2_1_31 VDD VSS sky130_fd_sc_hs__maj3_1_48/X sky130_fd_sc_hs__xor3_1_0/X
+ sky130_fd_sc_hs__and2_1_31/X VSS VDD sky130_fd_sc_hs__and2_1
Xsky130_fd_sc_hs__and2_1_42 VDD VSS sky130_fd_sc_hs__and2_1_42/A sky130_fd_sc_hs__or3_1_7/X
+ sky130_fd_sc_hs__o31a_1_6/A1 VSS VDD sky130_fd_sc_hs__and2_1
Xsky130_fd_sc_hs__a22o_1_8 VDD VSS sky130_fd_sc_hs__nor3_1_6/B sky130_fd_sc_hs__maj3_1_1/B
+ sky130_fd_sc_hs__a22o_1_8/B1 sky130_fd_sc_hs__a22o_1_8/A2 sky130_fd_sc_hs__a22o_1_8/A1
+ VSS VDD sky130_fd_sc_hs__a22o_1
Xsky130_fd_sc_hs__o2bb2ai_1_16 VDD VSS sky130_fd_sc_hs__dfrtp_1_258/D sky130_fd_sc_hs__and3_1_8/B
+ sky130_fd_sc_hs__dfrtp_1_258/Q sky130_fd_sc_hs__o31ai_1_6/A1 sky130_fd_sc_hs__a32o_1_4/B1
+ VSS VDD sky130_fd_sc_hs__o2bb2ai_1
Xsky130_fd_sc_hs__o2bb2ai_1_27 VDD VSS sky130_fd_sc_hs__dfrtp_1_417/D sky130_fd_sc_hs__a31o_1_12/X
+ sky130_fd_sc_hs__maj3_1_33/C sky130_fd_sc_hs__a21oi_1_103/Y sky130_fd_sc_hs__buf_8_13/X
+ VSS VDD sky130_fd_sc_hs__o2bb2ai_1
Xsky130_fd_sc_hs__o2bb2ai_1_38 VDD VSS sky130_fd_sc_hs__dfrtp_1_504/D sky130_fd_sc_hs__mux2i_1_3/Y
+ sky130_fd_sc_hs__mux2i_1_3/A0 sky130_fd_sc_hs__nand2b_1_51/Y sky130_fd_sc_hs__or2_1_23/X
+ VSS VDD sky130_fd_sc_hs__o2bb2ai_1
Xsky130_fd_sc_hs__o2bb2ai_1_49 VDD VSS sky130_fd_sc_hs__dfrtp_1_492/D sky130_fd_sc_hs__mux2i_1_15/Y
+ sky130_fd_sc_hs__o32ai_1_0/B2 sky130_fd_sc_hs__nand2b_1_51/Y sky130_fd_sc_hs__or2_1_23/X
+ VSS VDD sky130_fd_sc_hs__o2bb2ai_1
Xsky130_fd_sc_hs__nand3_1_11 VDD VSS sky130_fd_sc_hs__a311o_1_3/X sky130_fd_sc_hs__nand3_1_11/Y
+ sky130_fd_sc_hs__nor2_1_13/Y sky130_fd_sc_hs__nand3_1_11/A VSS VDD sky130_fd_sc_hs__nand3_1
Xsky130_fd_sc_hs__nand3_1_22 VDD VSS sky130_fd_sc_hs__nand3_1_22/C sky130_fd_sc_hs__and2_1_30/B
+ sky130_fd_sc_hs__xnor2_1_97/Y sky130_fd_sc_hs__nand3_1_22/A VSS VDD sky130_fd_sc_hs__nand3_1
Xsky130_fd_sc_hs__nand3_1_33 VDD VSS sky130_fd_sc_hs__nand3_1_33/C sky130_fd_sc_hs__xor2_1_80/B
+ sky130_fd_sc_hs__nand3_1_33/B sky130_fd_sc_hs__nand3_1_33/A VSS VDD sky130_fd_sc_hs__nand3_1
Xsky130_fd_sc_hs__nand3_1_44 VDD VSS sky130_fd_sc_hs__nand3_1_44/C sky130_fd_sc_hs__nand3_1_44/Y
+ sky130_fd_sc_hs__nand3_1_44/B sky130_fd_sc_hs__nand3_1_44/A VSS VDD sky130_fd_sc_hs__nand3_1
Xsky130_fd_sc_hs__o2bb2ai_1_3 VDD VSS sky130_fd_sc_hs__dfrtp_1_43/D sky130_fd_sc_hs__a21oi_1_12/Y
+ sky130_fd_sc_hs__buf_1_7/A sky130_fd_sc_hs__or2_1_0/X sky130_fd_sc_hs__nand2_1_9/B
+ VSS VDD sky130_fd_sc_hs__o2bb2ai_1
Xsky130_fd_sc_hs__dfrtp_1_708 sky130_fd_sc_hs__clkbuf_4_51/X VDD VSS sky130_fd_sc_hs__mux2_1_412/A1
+ sky130_fd_sc_hs__clkbuf_2_216/X sky130_fd_sc_hs__mux2_1_412/X VSS VDD sky130_fd_sc_hs__dfrtp_1
Xsky130_fd_sc_hs__dfrtp_1_719 sky130_fd_sc_hs__clkbuf_4_50/X VDD VSS sky130_fd_sc_hs__xor2_1_86/A
+ sky130_fd_sc_hs__clkbuf_2_224/X sky130_fd_sc_hs__a22o_1_127/X VSS VDD sky130_fd_sc_hs__dfrtp_1
Xsky130_fd_sc_hs__buf_1_30 VDD VSS sky130_fd_sc_hs__buf_1_30/A w_wr_data[24] VSS VDD
+ sky130_fd_sc_hs__buf_1
Xsky130_fd_sc_hs__buf_1_41 VDD VSS sky130_fd_sc_hs__buf_1_41/A raw_code_o[2] VSS VDD
+ sky130_fd_sc_hs__buf_1
Xsky130_fd_sc_hs__buf_1_52 VDD VSS sky130_fd_sc_hs__buf_1_52/A calib_overrange_bits[12]
+ VSS VDD sky130_fd_sc_hs__buf_1
Xsky130_fd_sc_hs__buf_1_63 VDD VSS sky130_fd_sc_hs__buf_1_63/A sky130_fd_sc_hs__buf_1_63/X
+ VSS VDD sky130_fd_sc_hs__buf_1
Xsky130_fd_sc_hs__buf_1_74 VDD VSS rst_n sky130_fd_sc_hs__buf_1_74/X VSS VDD sky130_fd_sc_hs__buf_1
Xsky130_fd_sc_hs__buf_1_85 VDD VSS sky130_fd_sc_hs__buf_1_85/A sky130_fd_sc_hs__buf_8_21/A
+ VSS VDD sky130_fd_sc_hs__buf_1
Xsky130_fd_sc_hs__buf_1_96 VDD VSS sky130_fd_sc_hs__buf_1_96/A sky130_fd_sc_hs__buf_8_37/A
+ VSS VDD sky130_fd_sc_hs__buf_1
Xsky130_fd_sc_hs__maj3_1_50 VDD VSS sky130_fd_sc_hs__xor2_1_62/A sky130_fd_sc_hs__xor2_1_62/B
+ sky130_fd_sc_hs__maj3_1_50/X sky130_fd_sc_hs__maj3_1_50/C VSS VDD sky130_fd_sc_hs__maj3_1
Xsky130_fd_sc_hs__maj3_1_61 VDD VSS sky130_fd_sc_hs__xor2_1_86/A sky130_fd_sc_hs__xor2_1_86/B
+ sky130_fd_sc_hs__maj3_1_63/C sky130_fd_sc_hs__maj3_1_62/X VSS VDD sky130_fd_sc_hs__maj3_1
Xsky130_fd_sc_hs__o21bai_1_0 VDD VSS sky130_fd_sc_hs__o32a_1_0/A2 sky130_fd_sc_hs__o21bai_1_0/Y
+ sky130_fd_sc_hs__nor3_1_16/B sky130_fd_sc_hs__o21bai_1_0/A1 VSS VDD sky130_fd_sc_hs__o21bai_1
Xsky130_fd_sc_hs__nor2b_1_6 VDD VSS sky130_fd_sc_hs__nor2b_1_7/A sky130_fd_sc_hs__or2_1_2/A
+ sky130_fd_sc_hs__maj3_1_2/X VSS VDD sky130_fd_sc_hs__nor2b_1
Xsky130_fd_sc_hs__nand2_1_8 VDD VSS sky130_fd_sc_hs__o31a_1_0/X sky130_fd_sc_hs__xnor2_1_4/B
+ sky130_fd_sc_hs__nand2_1_8/A VSS VDD sky130_fd_sc_hs__nand2_1
Xsky130_fd_sc_hs__o31ai_1_10 VDD VSS sky130_fd_sc_hs__nor3_1_25/C sky130_fd_sc_hs__nor3_1_25/B
+ sky130_fd_sc_hs__o31ai_1_10/B1 sky130_fd_sc_hs__nor3_1_25/A sky130_fd_sc_hs__o31ai_1_10/Y
+ VSS VDD sky130_fd_sc_hs__o31ai_1
Xsky130_fd_sc_hs__o31ai_1_21 VDD VSS sky130_fd_sc_hs__nor3_1_52/C sky130_fd_sc_hs__nor3_1_52/B
+ sky130_fd_sc_hs__nor2_1_180/A sky130_fd_sc_hs__nor3_1_52/A sky130_fd_sc_hs__o31ai_1_21/Y
+ VSS VDD sky130_fd_sc_hs__o31ai_1
Xsky130_fd_sc_hs__clkbuf_16_17 VDD VSS sky130_fd_sc_hs__inv_8_1/A sky130_fd_sc_hs__clkbuf_8_19/X
+ VSS VDD sky130_fd_sc_hs__clkbuf_16
Xsky130_fd_sc_hs__nor2_1_4 VDD VSS sky130_fd_sc_hs__nor3_1_2/C sky130_fd_sc_hs__nor3_1_3/B
+ sky130_fd_sc_hs__nor3_1_2/A VSS VDD sky130_fd_sc_hs__nor2_1
Xsky130_fd_sc_hs__clkbuf_16_1 VDD VSS sky130_fd_sc_hs__clkbuf_2_3/A sky130_fd_sc_hs__clkbuf_8_19/X
+ VSS VDD sky130_fd_sc_hs__clkbuf_16
Xsky130_fd_sc_hs__dfrtp_1_505 sky130_fd_sc_hs__clkbuf_4_23/X VDD VSS sky130_fd_sc_hs__o22ai_1_3/B2
+ sky130_fd_sc_hs__clkbuf_2_149/X sky130_fd_sc_hs__dfrtp_1_505/D VSS VDD sky130_fd_sc_hs__dfrtp_1
Xsky130_fd_sc_hs__dfrtp_1_516 sky130_fd_sc_hs__clkbuf_4_13/X VDD VSS sky130_fd_sc_hs__xor2_1_76/B
+ sky130_fd_sc_hs__clkinv_1_89/A sky130_fd_sc_hs__dfrtp_1_516/D VSS VDD sky130_fd_sc_hs__dfrtp_1
Xsky130_fd_sc_hs__dfrtp_1_527 sky130_fd_sc_hs__clkbuf_4_24/X VDD VSS sky130_fd_sc_hs__buf_1_133/A
+ sky130_fd_sc_hs__clkinv_1_109/A sky130_fd_sc_hs__mux2_1_254/X VSS VDD sky130_fd_sc_hs__dfrtp_1
Xsky130_fd_sc_hs__dfrtp_1_538 sky130_fd_sc_hs__clkbuf_4_24/X VDD VSS sky130_fd_sc_hs__buf_1_140/A
+ sky130_fd_sc_hs__clkinv_1_111/A sky130_fd_sc_hs__o21ai_1_74/Y VSS VDD sky130_fd_sc_hs__dfrtp_1
Xsky130_fd_sc_hs__dfrtp_1_549 sky130_fd_sc_hs__clkbuf_4_28/X VDD VSS sky130_fd_sc_hs__buf_1_166/A
+ sky130_fd_sc_hs__clkinv_1_116/A sky130_fd_sc_hs__mux2_1_264/X VSS VDD sky130_fd_sc_hs__dfrtp_1
Xsky130_fd_sc_hs__a21oi_1_12 VDD VSS sky130_fd_sc_hs__nor3_1_4/Y sky130_fd_sc_hs__a21oi_1_12/Y
+ sky130_fd_sc_hs__nor3_1_4/C sky130_fd_sc_hs__nor3_1_4/A VSS VDD sky130_fd_sc_hs__a21oi_1
Xsky130_fd_sc_hs__a21oi_1_23 VDD VSS sky130_fd_sc_hs__o31ai_1_4/A1 sky130_fd_sc_hs__a21oi_1_23/Y
+ sky130_fd_sc_hs__nor2_1_14/Y sky130_fd_sc_hs__nand2b_1_6/Y VSS VDD sky130_fd_sc_hs__a21oi_1
Xsky130_fd_sc_hs__a21oi_1_34 VDD VSS sky130_fd_sc_hs__o21ai_1_14/Y sky130_fd_sc_hs__a21oi_1_34/Y
+ sky130_fd_sc_hs__xnor2_1_19/Y sky130_fd_sc_hs__buf_8_10/X VSS VDD sky130_fd_sc_hs__a21oi_1
Xsky130_fd_sc_hs__a21oi_1_45 VDD VSS sky130_fd_sc_hs__buf_8_2/A sky130_fd_sc_hs__a21oi_1_45/Y
+ sky130_fd_sc_hs__or2_1_7/B sky130_fd_sc_hs__or2_1_7/A VSS VDD sky130_fd_sc_hs__a21oi_1
Xsky130_fd_sc_hs__a21oi_1_56 VDD VSS sky130_fd_sc_hs__a21oi_1_57/Y sky130_fd_sc_hs__a21o_1_1/B1
+ sky130_fd_sc_hs__xor2_1_23/X sky130_fd_sc_hs__and3_1_6/C VSS VDD sky130_fd_sc_hs__a21oi_1
Xsky130_fd_sc_hs__a21oi_1_67 VDD VSS sky130_fd_sc_hs__o21bai_1_2/Y sky130_fd_sc_hs__a21oi_1_67/Y
+ sky130_fd_sc_hs__and3_1_9/C sky130_fd_sc_hs__and3_1_9/A VSS VDD sky130_fd_sc_hs__a21oi_1
Xsky130_fd_sc_hs__a21oi_1_78 VDD VSS sky130_fd_sc_hs__buf_8_12/X sky130_fd_sc_hs__a22o_1_43/B2
+ sky130_fd_sc_hs__or2_1_11/B sky130_fd_sc_hs__or2_1_11/A VSS VDD sky130_fd_sc_hs__a21oi_1
Xsky130_fd_sc_hs__a21oi_1_89 VDD VSS sky130_fd_sc_hs__o21ai_1_43/Y sky130_fd_sc_hs__a21oi_1_89/Y
+ sky130_fd_sc_hs__xor2_1_49/X sky130_fd_sc_hs__buf_8_10/X VSS VDD sky130_fd_sc_hs__a21oi_1
Xsky130_fd_sc_hs__dfrtp_1_10 sky130_fd_sc_hs__clkbuf_4_4/A VDD VSS sky130_fd_sc_hs__maj3_1_7/C
+ sky130_fd_sc_hs__clkinv_1_2/A sky130_fd_sc_hs__mux2_1_12/X VSS VDD sky130_fd_sc_hs__dfrtp_1
Xsky130_fd_sc_hs__dfrtp_1_21 sky130_fd_sc_hs__clkbuf_4_3/X VDD VSS sky130_fd_sc_hs__mux2_1_21/A0
+ sky130_fd_sc_hs__clkinv_1_3/A sky130_fd_sc_hs__mux2_1_21/X VSS VDD sky130_fd_sc_hs__dfrtp_1
Xsky130_fd_sc_hs__dfrtp_1_32 sky130_fd_sc_hs__clkbuf_4_3/X VDD VSS sky130_fd_sc_hs__mux2_1_35/A0
+ sky130_fd_sc_hs__clkinv_1_3/A sky130_fd_sc_hs__mux2_1_35/X VSS VDD sky130_fd_sc_hs__dfrtp_1
Xsky130_fd_sc_hs__dfrtp_1_43 sky130_fd_sc_hs__clkbuf_4_12/A VDD VSS sky130_fd_sc_hs__buf_1_7/A
+ sky130_fd_sc_hs__clkbuf_2_13/X sky130_fd_sc_hs__dfrtp_1_43/D VSS VDD sky130_fd_sc_hs__dfrtp_1
Xsky130_fd_sc_hs__a22oi_1_120 VDD VSS sky130_fd_sc_hs__mux2_1_193/A0 sky130_fd_sc_hs__nand3_1_6/C
+ sky130_fd_sc_hs__buf_16_7/X sky130_fd_sc_hs__a22o_1_8/B1 sky130_fd_sc_hs__xor2_1_35/A
+ VSS VDD sky130_fd_sc_hs__a22oi_1
Xsky130_fd_sc_hs__dfrtp_1_54 sky130_fd_sc_hs__clkbuf_4_12/A VDD VSS sky130_fd_sc_hs__buf_1_18/A
+ sky130_fd_sc_hs__clkinv_1_6/A sky130_fd_sc_hs__a22o_1_6/X VSS VDD sky130_fd_sc_hs__dfrtp_1
Xsky130_fd_sc_hs__dfrtp_1_65 sky130_fd_sc_hs__clkbuf_4_1/X VDD VSS sky130_fd_sc_hs__mux2_1_55/A0
+ sky130_fd_sc_hs__clkinv_1_9/A sky130_fd_sc_hs__mux2_1_55/X VSS VDD sky130_fd_sc_hs__dfrtp_1
Xsky130_fd_sc_hs__dfrtp_1_76 sky130_fd_sc_hs__clkbuf_4_0/X VDD VSS sky130_fd_sc_hs__mux2_1_77/A0
+ sky130_fd_sc_hs__clkbuf_2_28/X sky130_fd_sc_hs__mux2_1_77/X VSS VDD sky130_fd_sc_hs__dfrtp_1
Xsky130_fd_sc_hs__dfrtp_1_87 sky130_fd_sc_hs__buf_8_0/X VDD VSS sky130_fd_sc_hs__maj3_1_1/B
+ sky130_fd_sc_hs__clkbuf_2_25/X sky130_fd_sc_hs__mux2_1_57/X VSS VDD sky130_fd_sc_hs__dfrtp_1
Xsky130_fd_sc_hs__dfrtp_1_98 sky130_fd_sc_hs__buf_8_1/X VDD VSS sky130_fd_sc_hs__or2_1_3/A
+ sky130_fd_sc_hs__clkinv_1_17/A sky130_fd_sc_hs__nand2_1_19/Y VSS VDD sky130_fd_sc_hs__dfrtp_1
Xsky130_fd_sc_hs__a222oi_1_9 VDD VSS sky130_fd_sc_hs__mux2_1_188/A0 sky130_fd_sc_hs__nand2_1_51/B
+ sky130_fd_sc_hs__buf_16_7/X sky130_fd_sc_hs__a22o_1_9/A2 sky130_fd_sc_hs__mux2_1_187/A1
+ sky130_fd_sc_hs__nand3_1_5/C sky130_fd_sc_hs__mux2_1_192/A0 VSS VDD sky130_fd_sc_hs__a222oi_1
Xsky130_fd_sc_hs__o221ai_1_3 VDD VSS sky130_fd_sc_hs__o221ai_1_3/Y sky130_fd_sc_hs__o21bai_1_4/Y
+ sky130_fd_sc_hs__nor3_1_37/A sky130_fd_sc_hs__o21a_1_26/A2 sky130_fd_sc_hs__or2_1_21/A
+ sky130_fd_sc_hs__or2_1_22/A VSS VDD sky130_fd_sc_hs__o221ai_1
Xsky130_fd_sc_hs__a41oi_1_1 VDD VSS sky130_fd_sc_hs__a41oi_1_1/Y sky130_fd_sc_hs__o21a_1_29/B1
+ sky130_fd_sc_hs__nand4_1_9/D sky130_fd_sc_hs__buf_1_151/A sky130_fd_sc_hs__nor2b_1_45/Y
+ sky130_fd_sc_hs__xor2_1_79/B VSS VDD sky130_fd_sc_hs__a41oi_1
Xsky130_fd_sc_hs__a22o_1_100 VDD VSS sky130_fd_sc_hs__a22o_1_100/X sky130_fd_sc_hs__buf_8_14/X
+ sky130_fd_sc_hs__xnor2_1_102/Y sky130_fd_sc_hs__buf_8_13/X sky130_fd_sc_hs__maj3_1_50/C
+ VSS VDD sky130_fd_sc_hs__a22o_1
Xsky130_fd_sc_hs__a22o_1_111 VDD VSS sky130_fd_sc_hs__buf_1_106/A sky130_fd_sc_hs__mux2i_1_14/A0
+ sky130_fd_sc_hs__nand2_1_125/Y sky130_fd_sc_hs__buf_8_36/A sky130_fd_sc_hs__nor2_2_2/Y
+ VSS VDD sky130_fd_sc_hs__a22o_1
Xsky130_fd_sc_hs__a22o_1_122 VDD VSS sky130_fd_sc_hs__a22o_1_122/X sky130_fd_sc_hs__o31a_1_7/X
+ sky130_fd_sc_hs__o21ai_1_89/Y sky130_fd_sc_hs__o31ai_4_0/Y sky130_fd_sc_hs__or2_1_18/A
+ VSS VDD sky130_fd_sc_hs__a22o_1
Xsky130_fd_sc_hs__a22o_1_133 VDD VSS sky130_fd_sc_hs__a22o_1_133/X sky130_fd_sc_hs__mux2_1_419/A0
+ sky130_fd_sc_hs__a22oi_1_7/B1 sky130_fd_sc_hs__nor3_4_6/Y sky130_fd_sc_hs__mux2_1_417/A1
+ VSS VDD sky130_fd_sc_hs__a22o_1
Xsky130_fd_sc_hs__o31a_1_6 VDD VSS sky130_fd_sc_hs__buf_8_26/X sky130_fd_sc_hs__o31a_1_6/A2
+ sky130_fd_sc_hs__o31a_1_6/A1 sky130_fd_sc_hs__o31a_1_6/A3 sky130_fd_sc_hs__o31a_1_6/X
+ VSS VDD sky130_fd_sc_hs__o31a_1
Xsky130_fd_sc_hs__nor3_4_2 VDD VSS sky130_fd_sc_hs__nor3_4_2/A sky130_fd_sc_hs__nor3_4_2/B
+ sky130_fd_sc_hs__or3_1_5/B sky130_fd_sc_hs__nor3_4_2/Y VSS VDD sky130_fd_sc_hs__nor3_4
Xsky130_fd_sc_hs__dfrtp_1_302 sky130_fd_sc_hs__clkbuf_4_13/X VDD VSS sky130_fd_sc_hs__xor2_1_32/A
+ sky130_fd_sc_hs__clkinv_1_57/A sky130_fd_sc_hs__mux2_1_203/X VSS VDD sky130_fd_sc_hs__dfrtp_1
Xsky130_fd_sc_hs__dfrtp_1_313 sky130_fd_sc_hs__clkbuf_4_13/X VDD VSS sky130_fd_sc_hs__buf_1_54/A
+ sky130_fd_sc_hs__clkinv_1_56/A sky130_fd_sc_hs__buf_1_76/X VSS VDD sky130_fd_sc_hs__dfrtp_1
Xsky130_fd_sc_hs__dfrtp_1_324 sky130_fd_sc_hs__clkbuf_4_14/X VDD VSS sky130_fd_sc_hs__mux2_1_206/A1
+ sky130_fd_sc_hs__clkbuf_2_94/X sky130_fd_sc_hs__mux2_1_206/X VSS VDD sky130_fd_sc_hs__dfrtp_1
Xsky130_fd_sc_hs__dfrtp_1_335 sky130_fd_sc_hs__clkbuf_4_14/X VDD VSS sky130_fd_sc_hs__mux2_1_94/A1
+ sky130_fd_sc_hs__clkinv_1_61/A sky130_fd_sc_hs__a22o_1_38/X VSS VDD sky130_fd_sc_hs__dfrtp_1
Xsky130_fd_sc_hs__dfrtp_1_346 sky130_fd_sc_hs__clkbuf_4_14/X VDD VSS sky130_fd_sc_hs__a22o_1_50/B2
+ sky130_fd_sc_hs__clkbuf_2_95/X sky130_fd_sc_hs__a22o_1_50/X VSS VDD sky130_fd_sc_hs__dfrtp_1
Xsky130_fd_sc_hs__dfrtp_1_357 sky130_fd_sc_hs__clkbuf_4_56/X VDD VSS sky130_fd_sc_hs__or2_1_12/A
+ sky130_fd_sc_hs__clkinv_1_69/A sky130_fd_sc_hs__dfrtp_1_357/D VSS VDD sky130_fd_sc_hs__dfrtp_1
Xsky130_fd_sc_hs__dfrtp_1_368 sky130_fd_sc_hs__clkbuf_4_15/X VDD VSS sky130_fd_sc_hs__a22o_1_65/B2
+ sky130_fd_sc_hs__clkinv_1_73/A sky130_fd_sc_hs__a22o_1_65/X VSS VDD sky130_fd_sc_hs__dfrtp_1
Xsky130_fd_sc_hs__dfrtp_1_379 sky130_fd_sc_hs__buf_8_5/A VDD VSS sky130_fd_sc_hs__and3_1_7/A
+ sky130_fd_sc_hs__clkbuf_8_2/X sky130_fd_sc_hs__o21bai_1_3/Y VSS VDD sky130_fd_sc_hs__dfrtp_1
Xsky130_fd_sc_hs__dlygate4sd3_1_9 VSS VDD raw_bits_i[12] sky130_fd_sc_hs__buf_1_78/A
+ VSS VDD sky130_fd_sc_hs__dlygate4sd3_1
Xsky130_fd_sc_hs__o2111a_1_0 VDD VSS sky130_fd_sc_hs__nor3_4_8/C sky130_fd_sc_hs__or3b_1_0/X
+ sky130_fd_sc_hs__o2111a_1_0/B1 sky130_fd_sc_hs__o2111a_1_0/C1 sky130_fd_sc_hs__o2111a_1_0/D1
+ sky130_fd_sc_hs__o2111a_1_0/X VSS VDD sky130_fd_sc_hs__o2111a_1
Xsky130_fd_sc_hs__buf_16_15 sky130_fd_sc_hs__mux2_1_6/S VDD VSS sky130_fd_sc_hs__buf_16_15/A
+ VSS VDD sky130_fd_sc_hs__buf_16
Xsky130_fd_sc_hs__and2_1_3 VDD VSS sky130_fd_sc_hs__maj3_1_1/A sky130_fd_sc_hs__maj3_1_1/B
+ sky130_fd_sc_hs__and2_1_3/X VSS VDD sky130_fd_sc_hs__and2_1
Xsky130_fd_sc_hs__clkbuf_4_12 VDD VSS sky130_fd_sc_hs__clkbuf_4_12/A sky130_fd_sc_hs__buf_2_0/A
+ VSS VDD sky130_fd_sc_hs__clkbuf_4
Xsky130_fd_sc_hs__clkbuf_4_23 VDD VSS sky130_fd_sc_hs__clkbuf_4_23/A sky130_fd_sc_hs__clkbuf_4_23/X
+ VSS VDD sky130_fd_sc_hs__clkbuf_4
Xsky130_fd_sc_hs__clkbuf_4_34 VDD VSS sky130_fd_sc_hs__buf_4_3/A sky130_fd_sc_hs__a22oi_1_7/B1
+ VSS VDD sky130_fd_sc_hs__clkbuf_4
Xsky130_fd_sc_hs__clkbuf_4_45 VDD VSS sky130_fd_sc_hs__nor3_4_8/Y sky130_fd_sc_hs__nand2_1_33/B
+ VSS VDD sky130_fd_sc_hs__clkbuf_4
Xsky130_fd_sc_hs__clkbuf_4_56 VDD VSS sky130_fd_sc_hs__buf_8_9/A sky130_fd_sc_hs__clkbuf_4_56/X
+ VSS VDD sky130_fd_sc_hs__clkbuf_4
Xsky130_fd_sc_hs__a41o_1_0 VDD VSS sky130_fd_sc_hs__a41o_1_0/A4 sky130_fd_sc_hs__a41o_1_0/A1
+ sky130_fd_sc_hs__nor3_1_51/Y sky130_fd_sc_hs__a41o_1_0/A3 sky130_fd_sc_hs__a41o_1_0/B1
+ sky130_fd_sc_hs__a41o_1_0/X VSS VDD sky130_fd_sc_hs__a41o_1
Xsky130_fd_sc_hs__mux2_1_306 VDD VSS sky130_fd_sc_hs__mux2_1_306/X sky130_fd_sc_hs__buf_16_2/X
+ sky130_fd_sc_hs__mux2_1_473/A1 sky130_fd_sc_hs__mux2_1_306/A1 VSS VDD sky130_fd_sc_hs__mux2_1
Xsky130_fd_sc_hs__mux2_1_317 VDD VSS sky130_fd_sc_hs__mux2_1_317/X sky130_fd_sc_hs__mux2_1_328/S
+ sky130_fd_sc_hs__mux2_1_317/A0 sky130_fd_sc_hs__mux2_1_355/A1 VSS VDD sky130_fd_sc_hs__mux2_1
Xsky130_fd_sc_hs__mux2_1_328 VDD VSS sky130_fd_sc_hs__mux2_1_328/X sky130_fd_sc_hs__mux2_1_328/S
+ sky130_fd_sc_hs__mux2_1_328/A0 sky130_fd_sc_hs__dfrtp_2_1/Q VSS VDD sky130_fd_sc_hs__mux2_1
Xsky130_fd_sc_hs__mux2_1_339 VDD VSS sky130_fd_sc_hs__mux2_1_339/X sky130_fd_sc_hs__buf_4_0/X
+ sky130_fd_sc_hs__mux2_1_339/A0 sky130_fd_sc_hs__a22o_1_67/B2 VSS VDD sky130_fd_sc_hs__mux2_1
Xsky130_fd_sc_hs__xor2_1_17 VDD VSS sky130_fd_sc_hs__xor2_1_18/B sky130_fd_sc_hs__xor2_1_17/B
+ sky130_fd_sc_hs__xor2_1_17/X VSS VDD sky130_fd_sc_hs__xor2_1
Xsky130_fd_sc_hs__xor2_1_28 VDD VSS sky130_fd_sc_hs__xor2_1_28/A sky130_fd_sc_hs__xor2_1_28/B
+ sky130_fd_sc_hs__xor2_1_28/X VSS VDD sky130_fd_sc_hs__xor2_1
Xsky130_fd_sc_hs__xor2_1_39 VDD VSS sky130_fd_sc_hs__xor2_1_39/A sky130_fd_sc_hs__xor2_1_39/B
+ sky130_fd_sc_hs__xor2_1_39/X VSS VDD sky130_fd_sc_hs__xor2_1
Xsky130_fd_sc_hs__nor3_1_30 VDD VSS sky130_fd_sc_hs__nor3_1_30/Y sky130_fd_sc_hs__or2_1_30/A
+ sky130_fd_sc_hs__nor3_1_44/B sky130_fd_sc_hs__or2_1_21/B VSS VDD sky130_fd_sc_hs__nor3_1
Xsky130_fd_sc_hs__nor3_1_41 VDD VSS sky130_fd_sc_hs__nor4_1_0/B sky130_fd_sc_hs__nor3_1_41/C
+ sky130_fd_sc_hs__nor3_1_41/B sky130_fd_sc_hs__nor3_1_41/A VSS VDD sky130_fd_sc_hs__nor3_1
Xsky130_fd_sc_hs__nor3_1_52 VDD VSS sky130_fd_sc_hs__nor3_1_52/Y sky130_fd_sc_hs__nor3_1_52/C
+ sky130_fd_sc_hs__nor3_1_52/B sky130_fd_sc_hs__nor3_1_52/A VSS VDD sky130_fd_sc_hs__nor3_1
Xsky130_fd_sc_hs__nand2b_1_19 VDD VSS sky130_fd_sc_hs__xor2_1_27/B sky130_fd_sc_hs__xor2_1_27/A
+ sky130_fd_sc_hs__a21o_1_2/A2 VSS VDD sky130_fd_sc_hs__nand2b_1
Xsky130_fd_sc_hs__a221oi_1_8 VDD VSS sky130_fd_sc_hs__nor3_1_50/Y sky130_fd_sc_hs__a221oi_1_8/Y
+ sky130_fd_sc_hs__mux2_1_367/A1 sky130_fd_sc_hs__nand2_1_198/B sky130_fd_sc_hs__mux2_1_366/A1
+ sky130_fd_sc_hs__clkbuf_8_14/X VSS VDD sky130_fd_sc_hs__a221oi_1
Xsky130_fd_sc_hs__dfrtp_1_110 sky130_fd_sc_hs__clkbuf_4_1/X VDD VSS sky130_fd_sc_hs__a22o_1_14/A1
+ sky130_fd_sc_hs__clkinv_1_24/A sky130_fd_sc_hs__mux2_1_103/X VSS VDD sky130_fd_sc_hs__dfrtp_1
Xsky130_fd_sc_hs__dfrtp_1_121 sky130_fd_sc_hs__clkbuf_4_2/X VDD VSS sky130_fd_sc_hs__or2_1_1/A
+ sky130_fd_sc_hs__clkbuf_2_39/X sky130_fd_sc_hs__o2bb2ai_1_5/Y VSS VDD sky130_fd_sc_hs__dfrtp_1
Xsky130_fd_sc_hs__dfrtp_1_132 sky130_fd_sc_hs__clkbuf_4_2/X VDD VSS sky130_fd_sc_hs__mux2_1_113/A1
+ sky130_fd_sc_hs__clkinv_1_28/A sky130_fd_sc_hs__mux2_1_113/X VSS VDD sky130_fd_sc_hs__dfrtp_1
Xsky130_fd_sc_hs__dfrtp_1_143 sky130_fd_sc_hs__clkbuf_4_10/X VDD VSS sky130_fd_sc_hs__buf_1_26/A
+ sky130_fd_sc_hs__clkinv_1_36/A sky130_fd_sc_hs__mux2_1_131/X VSS VDD sky130_fd_sc_hs__dfrtp_1
Xsky130_fd_sc_hs__dfrtp_1_154 sky130_fd_sc_hs__clkbuf_4_5/X VDD VSS sky130_fd_sc_hs__mux2_1_141/A0
+ sky130_fd_sc_hs__clkinv_1_44/A sky130_fd_sc_hs__mux2_1_141/X VSS VDD sky130_fd_sc_hs__dfrtp_1
Xsky130_fd_sc_hs__dfrtp_1_165 sky130_fd_sc_hs__clkbuf_4_5/X VDD VSS sky130_fd_sc_hs__mux2_1_482/A0
+ sky130_fd_sc_hs__clkinv_1_40/A sky130_fd_sc_hs__mux2_1_482/X VSS VDD sky130_fd_sc_hs__dfrtp_1
Xsky130_fd_sc_hs__dfrtp_1_176 sky130_fd_sc_hs__clkbuf_16_5/X VDD VSS sky130_fd_sc_hs__mux2_1_171/A1
+ sky130_fd_sc_hs__clkinv_1_42/A sky130_fd_sc_hs__mux2_1_171/X VSS VDD sky130_fd_sc_hs__dfrtp_1
Xsky130_fd_sc_hs__dfrtp_1_187 sky130_fd_sc_hs__clkbuf_16_5/X VDD VSS sky130_fd_sc_hs__mux2_1_163/A1
+ sky130_fd_sc_hs__clkinv_2_2/A sky130_fd_sc_hs__mux2_1_163/X VSS VDD sky130_fd_sc_hs__dfrtp_1
Xsky130_fd_sc_hs__dfrtp_1_198 sky130_fd_sc_hs__clkbuf_4_10/X VDD VSS sky130_fd_sc_hs__mux2_1_174/A0
+ sky130_fd_sc_hs__clkinv_1_35/A sky130_fd_sc_hs__mux2_1_174/X VSS VDD sky130_fd_sc_hs__dfrtp_1
Xsky130_fd_sc_hs__buf_8_1 VDD VSS sky130_fd_sc_hs__buf_8_1/X sky130_fd_sc_hs__buf_8_1/A
+ VSS VDD sky130_fd_sc_hs__buf_8
Xsky130_fd_sc_hs__o21a_1_5 VDD VSS sky130_fd_sc_hs__o21a_1_5/X sky130_fd_sc_hs__o21a_1_5/A2
+ sky130_fd_sc_hs__o21a_1_5/B1 sky130_fd_sc_hs__o21a_1_5/A1 VSS VDD sky130_fd_sc_hs__o21a_1
Xsky130_fd_sc_hs__clkinv_1_160 VDD VSS sky130_fd_sc_hs__xnor2_1_143/B sky130_fd_sc_hs__maj3_1_64/C
+ VSS VDD sky130_fd_sc_hs__clkinv_1
Xsky130_fd_sc_hs__o311ai_1_12 VDD VSS sky130_fd_sc_hs__xor2_1_92/A sky130_fd_sc_hs__nor2_1_74/B
+ sky130_fd_sc_hs__o31ai_1_8/B1 sky130_fd_sc_hs__nand2_1_91/A sky130_fd_sc_hs__and2_1_19/B
+ sky130_fd_sc_hs__o31ai_1_8/A3 VSS VDD sky130_fd_sc_hs__o311ai_1
Xsky130_fd_sc_hs__o311ai_1_23 VDD VSS sky130_fd_sc_hs__or2_1_24/B sky130_fd_sc_hs__or3_1_1/X
+ sky130_fd_sc_hs__buf_1_56/A sky130_fd_sc_hs__o31a_1_5/B1 sky130_fd_sc_hs__o41ai_1_3/B1
+ sky130_fd_sc_hs__nor2_2_3/A VSS VDD sky130_fd_sc_hs__o311ai_1
Xsky130_fd_sc_hs__inv_8_1 VDD VSS sky130_fd_sc_hs__inv_8_1/A sky130_fd_sc_hs__inv_8_1/Y
+ VSS VDD sky130_fd_sc_hs__inv_8
Xsky130_fd_sc_hs__nor2_1_130 VDD VSS sky130_fd_sc_hs__nor3_1_35/C sky130_fd_sc_hs__nor2_1_130/Y
+ sky130_fd_sc_hs__or2_1_22/A VSS VDD sky130_fd_sc_hs__nor2_1
Xsky130_fd_sc_hs__nor2_1_141 VDD VSS sky130_fd_sc_hs__nor2_1_141/B sky130_fd_sc_hs__nor3_1_35/C
+ sky130_fd_sc_hs__nor3_1_38/B VSS VDD sky130_fd_sc_hs__nor2_1
Xsky130_fd_sc_hs__nor2_1_152 VDD VSS sky130_fd_sc_hs__nor3_1_42/Y sky130_fd_sc_hs__nor4_1_0/C
+ sky130_fd_sc_hs__nor2_1_152/A VSS VDD sky130_fd_sc_hs__nor2_1
Xsky130_fd_sc_hs__nor2_1_163 VDD VSS sky130_fd_sc_hs__nor3_1_46/B sky130_fd_sc_hs__nor3_1_47/C
+ sky130_fd_sc_hs__nor3_1_48/A VSS VDD sky130_fd_sc_hs__nor2_1
Xsky130_fd_sc_hs__clkinv_1_6 VDD VSS sky130_fd_sc_hs__clkinv_1_6/A sky130_fd_sc_hs__clkinv_1_6/Y
+ VSS VDD sky130_fd_sc_hs__clkinv_1
Xsky130_fd_sc_hs__nor2_1_174 VDD VSS sky130_fd_sc_hs__xor2_1_83/A sky130_fd_sc_hs__nor2_1_174/Y
+ sky130_fd_sc_hs__maj3_1_56/A VSS VDD sky130_fd_sc_hs__nor2_1
Xsky130_fd_sc_hs__a22oi_1_50 VDD VSS sky130_fd_sc_hs__xor2_1_4/B sky130_fd_sc_hs__and4_1_4/A
+ sky130_fd_sc_hs__a22oi_1_6/B1 sky130_fd_sc_hs__a22oi_1_5/A2 sky130_fd_sc_hs__mux2_1_149/A0
+ VSS VDD sky130_fd_sc_hs__a22oi_1
Xsky130_fd_sc_hs__a22oi_1_61 VDD VSS sky130_fd_sc_hs__o22ai_1_3/B2 sky130_fd_sc_hs__a22oi_1_61/Y
+ sky130_fd_sc_hs__nor2_1_176/Y sky130_fd_sc_hs__and2_1_33/X sky130_fd_sc_hs__nor3_1_32/A
+ VSS VDD sky130_fd_sc_hs__a22oi_1
Xsky130_fd_sc_hs__nor2_1_185 VDD VSS sky130_fd_sc_hs__nor2_1_185/B sky130_fd_sc_hs__nor2_1_185/Y
+ sky130_fd_sc_hs__buf_8_19/X VSS VDD sky130_fd_sc_hs__nor2_1
Xsky130_fd_sc_hs__a22oi_1_72 VDD VSS sky130_fd_sc_hs__mux2_1_462/A0 sky130_fd_sc_hs__nand3_1_32/B
+ sky130_fd_sc_hs__buf_4_3/X sky130_fd_sc_hs__nor2_2_9/Y sky130_fd_sc_hs__mux2_1_262/A0
+ VSS VDD sky130_fd_sc_hs__a22oi_1
Xsky130_fd_sc_hs__a22oi_1_83 VDD VSS sky130_fd_sc_hs__mux2_1_302/A1 sky130_fd_sc_hs__a22oi_1_83/Y
+ sky130_fd_sc_hs__nand2_1_198/B sky130_fd_sc_hs__nand2_1_200/B sky130_fd_sc_hs__mux2_1_465/A1
+ VSS VDD sky130_fd_sc_hs__a22oi_1
Xsky130_fd_sc_hs__a22oi_1_94 VDD VSS sky130_fd_sc_hs__xor2_1_83/A sky130_fd_sc_hs__a22oi_1_94/Y
+ sky130_fd_sc_hs__a222o_1_7/B1 sky130_fd_sc_hs__a22oi_1_5/A2 sky130_fd_sc_hs__mux2_1_360/A0
+ VSS VDD sky130_fd_sc_hs__a22oi_1
Xsky130_fd_sc_hs__mux2_1_103 VDD VSS sky130_fd_sc_hs__mux2_1_103/X sky130_fd_sc_hs__buf_16_2/X
+ sky130_fd_sc_hs__mux2_1_98/A1 sky130_fd_sc_hs__a22o_1_14/A1 VSS VDD sky130_fd_sc_hs__mux2_1
Xsky130_fd_sc_hs__mux2_1_114 VDD VSS sky130_fd_sc_hs__mux2_1_114/X sky130_fd_sc_hs__mux2_1_99/S
+ sky130_fd_sc_hs__a22o_1_64/B2 sky130_fd_sc_hs__mux2_1_114/A1 VSS VDD sky130_fd_sc_hs__mux2_1
Xsky130_fd_sc_hs__mux2_1_125 VDD VSS sky130_fd_sc_hs__mux2_1_125/X sky130_fd_sc_hs__buf_8_3/X
+ sky130_fd_sc_hs__buf_1_25/A sky130_fd_sc_hs__mux2_1_95/A1 VSS VDD sky130_fd_sc_hs__mux2_1
Xsky130_fd_sc_hs__mux2_1_136 VDD VSS sky130_fd_sc_hs__mux2_1_136/X sky130_fd_sc_hs__buf_8_3/X
+ sky130_fd_sc_hs__buf_1_28/A sky130_fd_sc_hs__mux2_1_94/A1 VSS VDD sky130_fd_sc_hs__mux2_1
Xsky130_fd_sc_hs__mux2_1_147 VDD VSS sky130_fd_sc_hs__mux2_1_147/X sky130_fd_sc_hs__buf_16_3/A
+ sky130_fd_sc_hs__a22o_1_40/B2 sky130_fd_sc_hs__mux2_1_147/A1 VSS VDD sky130_fd_sc_hs__mux2_1
Xsky130_fd_sc_hs__mux2_1_158 VDD VSS sky130_fd_sc_hs__mux2_1_158/X sky130_fd_sc_hs__buf_16_1/X
+ sky130_fd_sc_hs__mux2_1_158/A0 sky130_fd_sc_hs__a22o_1_40/B2 VSS VDD sky130_fd_sc_hs__mux2_1
Xsky130_fd_sc_hs__mux2_1_169 VDD VSS sky130_fd_sc_hs__mux2_1_169/X sky130_fd_sc_hs__buf_8_3/A
+ sky130_fd_sc_hs__buf_1_43/A sky130_fd_sc_hs__dfrtp_2_1/Q VSS VDD sky130_fd_sc_hs__mux2_1
Xsky130_fd_sc_hs__buf_1_8 VDD VSS sky130_fd_sc_hs__buf_1_8/A srm_done VSS VDD sky130_fd_sc_hs__buf_1
Xsky130_fd_sc_hs__or3_1_4 VDD VSS sky130_fd_sc_hs__or3_1_4/A sky130_fd_sc_hs__or3_1_4/B
+ sky130_fd_sc_hs__or3_1_4/C sky130_fd_sc_hs__or3_1_4/X VSS VDD sky130_fd_sc_hs__or3_1
Xsky130_fd_sc_hs__buf_1_106 VDD VSS sky130_fd_sc_hs__buf_1_106/A dac_n_force[19] VSS
+ VDD sky130_fd_sc_hs__buf_1
Xsky130_fd_sc_hs__buf_1_117 VDD VSS sky130_fd_sc_hs__buf_1_117/A dac_n_force[14] VSS
+ VDD sky130_fd_sc_hs__buf_1
Xsky130_fd_sc_hs__buf_1_128 VDD VSS sky130_fd_sc_hs__buf_1_128/A sky130_fd_sc_hs__buf_8_13/A
+ VSS VDD sky130_fd_sc_hs__buf_1
Xsky130_fd_sc_hs__buf_1_139 VDD VSS sky130_fd_sc_hs__buf_1_139/A w_wr_data[21] VSS
+ VDD sky130_fd_sc_hs__buf_1
Xsky130_fd_sc_hs__mux2i_1_8 VDD VSS sky130_fd_sc_hs__mux2i_1_8/S sky130_fd_sc_hs__o22ai_1_2/A1
+ sky130_fd_sc_hs__or2_1_22/B sky130_fd_sc_hs__mux2i_1_8/Y VSS VDD sky130_fd_sc_hs__mux2i_1
Xsky130_fd_sc_hs__a21oi_1_209 VDD VSS sky130_fd_sc_hs__xnor2_1_16/A sky130_fd_sc_hs__nor2b_1_5/A
+ sky130_fd_sc_hs__and4_1_6/X sky130_fd_sc_hs__nand3_1_46/B VSS VDD sky130_fd_sc_hs__a21oi_1
Xsky130_fd_sc_hs__a31oi_1_8 VDD VSS sky130_fd_sc_hs__a31oi_1_8/Y sky130_fd_sc_hs__xor2_1_57/X
+ sky130_fd_sc_hs__buf_8_12/X sky130_fd_sc_hs__a21o_1_4/X sky130_fd_sc_hs__a21o_1_8/A1
+ VSS VDD sky130_fd_sc_hs__a31oi_1
Xsky130_fd_sc_hs__clkbuf_2_203 VDD VSS sky130_fd_sc_hs__clkinv_1_150/A sky130_fd_sc_hs__clkinv_2_11/A
+ VSS VDD sky130_fd_sc_hs__clkbuf_2
Xsky130_fd_sc_hs__o21a_1_20 VDD VSS sky130_fd_sc_hs__o21a_1_20/X sky130_fd_sc_hs__and2_1_27/X
+ sky130_fd_sc_hs__o21ai_1_7/B1 sky130_fd_sc_hs__o21a_1_20/A1 VSS VDD sky130_fd_sc_hs__o21a_1
Xsky130_fd_sc_hs__clkbuf_2_214 VDD VSS sky130_fd_sc_hs__clkbuf_2_214/X sky130_fd_sc_hs__clkinv_2_11/A
+ VSS VDD sky130_fd_sc_hs__clkbuf_2
Xsky130_fd_sc_hs__o21a_1_31 VDD VSS sky130_fd_sc_hs__o21a_1_31/X sky130_fd_sc_hs__or2_1_31/B
+ sky130_fd_sc_hs__a41o_1_0/X sky130_fd_sc_hs__o31ai_1_21/Y VSS VDD sky130_fd_sc_hs__o21a_1
Xsky130_fd_sc_hs__clkbuf_2_225 VDD VSS sky130_fd_sc_hs__clkbuf_2_225/X sky130_fd_sc_hs__clkbuf_8_17/A
+ VSS VDD sky130_fd_sc_hs__clkbuf_2
Xsky130_fd_sc_hs__nand2_1_203 VDD VSS sky130_fd_sc_hs__a22oi_1_90/Y sky130_fd_sc_hs__nand2_1_203/Y
+ sky130_fd_sc_hs__a22oi_1_89/Y VSS VDD sky130_fd_sc_hs__nand2_1
Xsky130_fd_sc_hs__clkbuf_2_236 VDD VSS sky130_fd_sc_hs__clkinv_2_10/A sky130_fd_sc_hs__clkbuf_2_236/A
+ VSS VDD sky130_fd_sc_hs__clkbuf_2
Xsky130_fd_sc_hs__nand2_1_214 VDD VSS sky130_fd_sc_hs__a211oi_1_9/Y sky130_fd_sc_hs__xor2_1_84/B
+ sky130_fd_sc_hs__nand2_1_214/A VSS VDD sky130_fd_sc_hs__nand2_1
Xsky130_fd_sc_hs__nand2_1_225 VDD VSS sky130_fd_sc_hs__nand2_1_225/B sky130_fd_sc_hs__nor3_1_54/A
+ sky130_fd_sc_hs__nand2_1_225/A VSS VDD sky130_fd_sc_hs__nand2_1
Xsky130_fd_sc_hs__nand2_1_236 VDD VSS sky130_fd_sc_hs__a32o_1_2/B1 sky130_fd_sc_hs__nand2_1_237/A
+ sky130_fd_sc_hs__and2_1_7/A VSS VDD sky130_fd_sc_hs__nand2_1
Xsky130_fd_sc_hs__and2_1_10 VDD VSS sky130_fd_sc_hs__and2_1_10/A sky130_fd_sc_hs__and2_1_10/B
+ sky130_fd_sc_hs__and2_1_10/X VSS VDD sky130_fd_sc_hs__and2_1
Xsky130_fd_sc_hs__and2_1_21 VDD VSS sky130_fd_sc_hs__xor2_1_3/A sky130_fd_sc_hs__xor2_1_50/A
+ sky130_fd_sc_hs__nor2_1_71/A VSS VDD sky130_fd_sc_hs__and2_1
Xsky130_fd_sc_hs__and2_1_32 VDD VSS sky130_fd_sc_hs__o21a_1_4/B1 sky130_fd_sc_hs__and2_1_32/B
+ sky130_fd_sc_hs__or3_1_3/C VSS VDD sky130_fd_sc_hs__and2_1
Xsky130_fd_sc_hs__and2_1_43 VDD VSS sky130_fd_sc_hs__and2_1_43/A sky130_fd_sc_hs__or3_1_8/X
+ sky130_fd_sc_hs__o31a_1_7/A1 VSS VDD sky130_fd_sc_hs__and2_1
Xsky130_fd_sc_hs__a22o_1_9 VDD VSS sky130_fd_sc_hs__nor3_1_6/A sky130_fd_sc_hs__a22o_1_9/B2
+ sky130_fd_sc_hs__buf_16_9/X sky130_fd_sc_hs__a22o_1_9/A2 sky130_fd_sc_hs__a22o_1_9/A1
+ VSS VDD sky130_fd_sc_hs__a22o_1
Xsky130_fd_sc_hs__o2bb2ai_1_17 VDD VSS sky130_fd_sc_hs__dfrtp_1_276/D sky130_fd_sc_hs__xnor2_1_50/B
+ sky130_fd_sc_hs__xnor2_1_5/A sky130_fd_sc_hs__nand3_1_18/Y sky130_fd_sc_hs__nor2_1_45/B
+ VSS VDD sky130_fd_sc_hs__o2bb2ai_1
Xsky130_fd_sc_hs__o2bb2ai_1_28 VDD VSS sky130_fd_sc_hs__dfrtp_1_426/D sky130_fd_sc_hs__nor2_1_88/Y
+ sky130_fd_sc_hs__nor2_1_88/A sky130_fd_sc_hs__nand4b_1_0/C sky130_fd_sc_hs__buf_8_13/A
+ VSS VDD sky130_fd_sc_hs__o2bb2ai_1
Xsky130_fd_sc_hs__o2bb2ai_1_39 VDD VSS sky130_fd_sc_hs__dfrtp_1_513/D sky130_fd_sc_hs__mux2i_1_5/Y
+ sky130_fd_sc_hs__mux2i_1_5/A1 sky130_fd_sc_hs__nand2b_1_51/Y sky130_fd_sc_hs__or2_1_23/X
+ VSS VDD sky130_fd_sc_hs__o2bb2ai_1
Xsky130_fd_sc_hs__nand3_1_12 VDD VSS sky130_fd_sc_hs__nand3_1_12/C sky130_fd_sc_hs__xnor2_1_21/B
+ sky130_fd_sc_hs__nand3_1_12/B sky130_fd_sc_hs__and4_1_7/X VSS VDD sky130_fd_sc_hs__nand3_1
Xsky130_fd_sc_hs__nand3_1_23 VDD VSS sky130_fd_sc_hs__a32o_1_9/A3 sky130_fd_sc_hs__and2_1_29/B
+ sky130_fd_sc_hs__nor2_1_176/Y sky130_fd_sc_hs__or3b_1_0/B VSS VDD sky130_fd_sc_hs__nand3_1
Xsky130_fd_sc_hs__nand3_1_34 VDD VSS sky130_fd_sc_hs__nor2b_1_45/Y sky130_fd_sc_hs__buf_8_28/A
+ sky130_fd_sc_hs__xor2_1_79/B sky130_fd_sc_hs__o21a_1_29/B1 VSS VDD sky130_fd_sc_hs__nand3_1
Xsky130_fd_sc_hs__nand3_1_45 VDD VSS sky130_fd_sc_hs__nand3_1_45/C sky130_fd_sc_hs__nor3_1_52/C
+ sky130_fd_sc_hs__nand3_1_45/B sky130_fd_sc_hs__nand3_1_45/A VSS VDD sky130_fd_sc_hs__nand3_1
Xsky130_fd_sc_hs__o2bb2ai_1_4 VDD VSS sky130_fd_sc_hs__o2bb2ai_1_4/Y sky130_fd_sc_hs__o31ai_1_2/Y
+ sky130_fd_sc_hs__and2_1_6/A sky130_fd_sc_hs__and3_1_1/X sky130_fd_sc_hs__a32o_1_2/B1
+ VSS VDD sky130_fd_sc_hs__o2bb2ai_1
Xsky130_fd_sc_hs__dfrtp_1_709 sky130_fd_sc_hs__clkbuf_4_51/X VDD VSS sky130_fd_sc_hs__mux2_1_415/A1
+ sky130_fd_sc_hs__clkbuf_2_215/X sky130_fd_sc_hs__mux2_1_415/X VSS VDD sky130_fd_sc_hs__dfrtp_1
Xsky130_fd_sc_hs__buf_1_20 VDD VSS sky130_fd_sc_hs__buf_1_20/A srm_residue_valid VSS
+ VDD sky130_fd_sc_hs__buf_1
Xsky130_fd_sc_hs__buf_1_31 VDD VSS sky130_fd_sc_hs__buf_1_31/A w_wr_data[6] VSS VDD
+ sky130_fd_sc_hs__buf_1
Xsky130_fd_sc_hs__buf_1_42 VDD VSS sky130_fd_sc_hs__buf_1_42/A raw_code_valid_o VSS
+ VDD sky130_fd_sc_hs__buf_1
Xsky130_fd_sc_hs__buf_1_53 VDD VSS sky130_fd_sc_hs__buf_1_53/A w_wr_addr[2] VSS VDD
+ sky130_fd_sc_hs__buf_1
Xsky130_fd_sc_hs__buf_1_64 VDD VSS sky130_fd_sc_hs__buf_1_64/A srm_ones_count[3] VSS
+ VDD sky130_fd_sc_hs__buf_1
Xsky130_fd_sc_hs__buf_1_75 VDD VSS sky130_fd_sc_hs__buf_1_75/A sky130_fd_sc_hs__buf_1_75/X
+ VSS VDD sky130_fd_sc_hs__buf_1
Xsky130_fd_sc_hs__buf_1_86 VDD VSS sky130_fd_sc_hs__buf_1_86/A sky130_fd_sc_hs__buf_8_18/A
+ VSS VDD sky130_fd_sc_hs__buf_1
Xsky130_fd_sc_hs__buf_1_97 VDD VSS sky130_fd_sc_hs__buf_1_97/A dac_n_force[16] VSS
+ VDD sky130_fd_sc_hs__buf_1
Xsky130_fd_sc_hs__maj3_1_40 VDD VSS sky130_fd_sc_hs__xor2_1_69/A sky130_fd_sc_hs__xor2_1_69/B
+ sky130_fd_sc_hs__maj3_1_40/X sky130_fd_sc_hs__maj3_1_40/C VSS VDD sky130_fd_sc_hs__maj3_1
Xsky130_fd_sc_hs__maj3_1_51 VDD VSS sky130_fd_sc_hs__xor2_1_80/A sky130_fd_sc_hs__xor2_1_91/A
+ sky130_fd_sc_hs__maj3_1_51/X sky130_fd_sc_hs__xor2_1_91/B VSS VDD sky130_fd_sc_hs__maj3_1
Xsky130_fd_sc_hs__maj3_1_62 VDD VSS sky130_fd_sc_hs__xor2_1_89/A sky130_fd_sc_hs__xor2_1_89/B
+ sky130_fd_sc_hs__maj3_1_62/X sky130_fd_sc_hs__maj3_1_62/C VSS VDD sky130_fd_sc_hs__maj3_1
Xsky130_fd_sc_hs__o21bai_1_1 VDD VSS sky130_fd_sc_hs__o32a_1_0/A2 sky130_fd_sc_hs__or2_1_8/A
+ sky130_fd_sc_hs__nor3_1_17/C sky130_fd_sc_hs__nor3_1_17/A VSS VDD sky130_fd_sc_hs__o21bai_1
Xsky130_fd_sc_hs__nor2b_1_7 VDD VSS sky130_fd_sc_hs__maj3_1_2/X sky130_fd_sc_hs__nor2_1_9/A
+ sky130_fd_sc_hs__nor2b_1_7/A VSS VDD sky130_fd_sc_hs__nor2b_1
Xsky130_fd_sc_hs__nand2_1_9 VDD VSS sky130_fd_sc_hs__nand2_1_9/B sky130_fd_sc_hs__nand2_1_9/Y
+ sky130_fd_sc_hs__buf_1_6/A VSS VDD sky130_fd_sc_hs__nand2_1
Xsky130_fd_sc_hs__o31ai_1_11 VDD VSS sky130_fd_sc_hs__o31ai_1_9/A2 sky130_fd_sc_hs__nand2_1_96/B
+ sky130_fd_sc_hs__nand2_1_96/Y sky130_fd_sc_hs__buf_8_19/X sky130_fd_sc_hs__o31ai_1_11/Y
+ VSS VDD sky130_fd_sc_hs__o31ai_1
Xsky130_fd_sc_hs__o31ai_1_22 VDD VSS sky130_fd_sc_hs__and2_1_33/X sky130_fd_sc_hs__or3b_1_0/B
+ sky130_fd_sc_hs__and2_1_32/B sky130_fd_sc_hs__or3b_1_1/B sky130_fd_sc_hs__o31ai_1_22/Y
+ VSS VDD sky130_fd_sc_hs__o31ai_1
Xsky130_fd_sc_hs__clkbuf_16_18 VDD VSS sky130_fd_sc_hs__a32o_1_7/B1 sky130_fd_sc_hs__clkbuf_2_140/X
+ VSS VDD sky130_fd_sc_hs__clkbuf_16
Xsky130_fd_sc_hs__nor2_1_5 VDD VSS sky130_fd_sc_hs__nor3_1_4/A sky130_fd_sc_hs__nor2_1_5/Y
+ sky130_fd_sc_hs__nor3_1_2/A VSS VDD sky130_fd_sc_hs__nor2_1
Xsky130_fd_sc_hs__clkbuf_16_2 VDD VSS sky130_fd_sc_hs__clkinv_4_1/A sky130_fd_sc_hs__clkbuf_8_19/X
+ VSS VDD sky130_fd_sc_hs__clkbuf_16
Xsky130_fd_sc_hs__dfrtp_1_506 sky130_fd_sc_hs__clkbuf_4_22/A VDD VSS sky130_fd_sc_hs__or3_1_4/B
+ sky130_fd_sc_hs__clkinv_1_97/A sky130_fd_sc_hs__o41ai_1_1/Y VSS VDD sky130_fd_sc_hs__dfrtp_1
Xsky130_fd_sc_hs__dfrtp_1_517 sky130_fd_sc_hs__clkbuf_4_22/A VDD VSS sky130_fd_sc_hs__xor2_1_78/A
+ sky130_fd_sc_hs__clkbuf_2_143/X sky130_fd_sc_hs__dfrtp_1_517/D VSS VDD sky130_fd_sc_hs__dfrtp_1
Xsky130_fd_sc_hs__dfrtp_1_528 sky130_fd_sc_hs__clkbuf_16_5/X VDD VSS sky130_fd_sc_hs__buf_1_181/A
+ sky130_fd_sc_hs__clkinv_1_108/A sky130_fd_sc_hs__o21ai_1_67/Y VSS VDD sky130_fd_sc_hs__dfrtp_1
Xsky130_fd_sc_hs__dfrtp_1_539 sky130_fd_sc_hs__clkbuf_4_24/X VDD VSS sky130_fd_sc_hs__buf_1_48/A
+ sky130_fd_sc_hs__clkinv_1_109/A sky130_fd_sc_hs__o31ai_1_16/Y VSS VDD sky130_fd_sc_hs__dfrtp_1
Xsky130_fd_sc_hs__a21oi_1_13 VDD VSS sky130_fd_sc_hs__nor3_1_4/A sky130_fd_sc_hs__xor2_1_0/B
+ sky130_fd_sc_hs__xnor2_1_5/A sky130_fd_sc_hs__nor3_1_2/A VSS VDD sky130_fd_sc_hs__a21oi_1
Xsky130_fd_sc_hs__a21oi_1_24 VDD VSS sky130_fd_sc_hs__o31ai_1_4/A1 sky130_fd_sc_hs__a22o_1_15/B2
+ sky130_fd_sc_hs__nand2_1_30/Y sky130_fd_sc_hs__clkinv_1_23/Y VSS VDD sky130_fd_sc_hs__a21oi_1
Xsky130_fd_sc_hs__a21oi_1_35 VDD VSS sky130_fd_sc_hs__and3_1_2/B sky130_fd_sc_hs__nor3_1_9/C
+ sky130_fd_sc_hs__and3_1_2/C sky130_fd_sc_hs__or2_1_3/X VSS VDD sky130_fd_sc_hs__a21oi_1
Xsky130_fd_sc_hs__a21oi_1_46 VDD VSS sky130_fd_sc_hs__o21ai_1_24/Y sky130_fd_sc_hs__a21oi_1_46/Y
+ sky130_fd_sc_hs__xnor2_1_28/Y sky130_fd_sc_hs__buf_1_22/X VSS VDD sky130_fd_sc_hs__a21oi_1
Xsky130_fd_sc_hs__a21oi_1_57 VDD VSS sky130_fd_sc_hs__nor3_1_15/Y sky130_fd_sc_hs__a21oi_1_57/Y
+ sky130_fd_sc_hs__xor2_1_23/X sky130_fd_sc_hs__and2_1_15/X VSS VDD sky130_fd_sc_hs__a21oi_1
Xsky130_fd_sc_hs__a21oi_1_68 VDD VSS sky130_fd_sc_hs__nor2_1_55/Y sky130_fd_sc_hs__a21oi_1_68/Y
+ sky130_fd_sc_hs__or2_1_8/A sky130_fd_sc_hs__nor2_1_55/A VSS VDD sky130_fd_sc_hs__a21oi_1
Xsky130_fd_sc_hs__a21oi_1_79 VDD VSS sky130_fd_sc_hs__xor2_1_36/X sky130_fd_sc_hs__a21oi_1_79/Y
+ sky130_fd_sc_hs__a31o_1_5/A2 sky130_fd_sc_hs__a31o_1_5/A1 VSS VDD sky130_fd_sc_hs__a21oi_1
Xsky130_fd_sc_hs__dfrtp_1_11 sky130_fd_sc_hs__clkbuf_4_3/A VDD VSS sky130_fd_sc_hs__maj3_1_0/C
+ sky130_fd_sc_hs__clkinv_1_2/A sky130_fd_sc_hs__mux2_1_15/X VSS VDD sky130_fd_sc_hs__dfrtp_1
Xsky130_fd_sc_hs__dfrtp_1_22 sky130_fd_sc_hs__clkbuf_4_3/X VDD VSS sky130_fd_sc_hs__mux2_1_37/A1
+ sky130_fd_sc_hs__clkbuf_2_7/X sky130_fd_sc_hs__mux2_1_37/X VSS VDD sky130_fd_sc_hs__dfrtp_1
Xsky130_fd_sc_hs__a22oi_1_110 VDD VSS sky130_fd_sc_hs__mux2_1_445/A0 sky130_fd_sc_hs__nand2_1_226/B
+ sky130_fd_sc_hs__buf_16_7/X sky130_fd_sc_hs__a222o_1_2/A2 sky130_fd_sc_hs__mux2_1_461/A0
+ VSS VDD sky130_fd_sc_hs__a22oi_1
Xsky130_fd_sc_hs__dfrtp_1_33 sky130_fd_sc_hs__clkbuf_4_3/X VDD VSS sky130_fd_sc_hs__mux2_1_25/A0
+ sky130_fd_sc_hs__clkbuf_2_7/X sky130_fd_sc_hs__mux2_1_25/X VSS VDD sky130_fd_sc_hs__dfrtp_1
Xsky130_fd_sc_hs__dfrtp_1_44 sky130_fd_sc_hs__clkbuf_4_12/A VDD VSS sky130_fd_sc_hs__buf_1_5/A
+ sky130_fd_sc_hs__clkbuf_2_13/X sky130_fd_sc_hs__dfrtp_1_44/D VSS VDD sky130_fd_sc_hs__dfrtp_1
Xsky130_fd_sc_hs__dfrtp_1_55 sky130_fd_sc_hs__clkbuf_4_1/X VDD VSS sky130_fd_sc_hs__mux2_1_61/A1
+ sky130_fd_sc_hs__clkinv_1_7/A sky130_fd_sc_hs__mux2_1_61/X VSS VDD sky130_fd_sc_hs__dfrtp_1
Xsky130_fd_sc_hs__dfrtp_1_66 sky130_fd_sc_hs__clkbuf_4_0/X VDD VSS sky130_fd_sc_hs__mux2_1_79/A1
+ sky130_fd_sc_hs__clkbuf_2_29/X sky130_fd_sc_hs__mux2_1_79/X VSS VDD sky130_fd_sc_hs__dfrtp_1
Xsky130_fd_sc_hs__dfrtp_1_77 sky130_fd_sc_hs__clkbuf_4_0/X VDD VSS sky130_fd_sc_hs__mux2_1_69/A1
+ sky130_fd_sc_hs__clkinv_1_11/A sky130_fd_sc_hs__mux2_1_69/X VSS VDD sky130_fd_sc_hs__dfrtp_1
Xsky130_fd_sc_hs__dfrtp_1_88 sky130_fd_sc_hs__clkbuf_4_1/X VDD VSS sky130_fd_sc_hs__mux2_1_48/A1
+ sky130_fd_sc_hs__clkbuf_2_19/X sky130_fd_sc_hs__mux2_1_48/X VSS VDD sky130_fd_sc_hs__dfrtp_1
Xsky130_fd_sc_hs__dfrtp_1_99 sky130_fd_sc_hs__buf_8_1/X VDD VSS sky130_fd_sc_hs__maj3_1_2/A
+ sky130_fd_sc_hs__clkinv_1_17/A sky130_fd_sc_hs__a22o_1_12/X VSS VDD sky130_fd_sc_hs__dfrtp_1
Xsky130_fd_sc_hs__a41oi_1_2 VDD VSS sky130_fd_sc_hs__or2_1_31/A sky130_fd_sc_hs__nor3_1_51/Y
+ sky130_fd_sc_hs__a41o_1_0/A1 sky130_fd_sc_hs__a41o_1_0/B1 sky130_fd_sc_hs__a41o_1_0/A4
+ sky130_fd_sc_hs__a41o_1_0/A3 VSS VDD sky130_fd_sc_hs__a41oi_1
Xsky130_fd_sc_hs__a22o_1_101 VDD VSS sky130_fd_sc_hs__a22o_1_101/X sky130_fd_sc_hs__o21a_1_21/X
+ sky130_fd_sc_hs__nand2_1_119/Y sky130_fd_sc_hs__buf_8_13/X sky130_fd_sc_hs__maj3_1_44/C
+ VSS VDD sky130_fd_sc_hs__a22o_1
Xsky130_fd_sc_hs__a22o_1_112 VDD VSS sky130_fd_sc_hs__a22o_1_112/X sky130_fd_sc_hs__a22o_1_88/A1
+ sky130_fd_sc_hs__a22o_1_90/B1 sky130_fd_sc_hs__a22o_1_90/A2 sky130_fd_sc_hs__maj3_1_39/C
+ VSS VDD sky130_fd_sc_hs__a22o_1
Xsky130_fd_sc_hs__a22o_1_123 VDD VSS sky130_fd_sc_hs__a22o_1_123/X sky130_fd_sc_hs__mux2_1_332/A0
+ sky130_fd_sc_hs__buf_8_31/X sky130_fd_sc_hs__a222o_1_2/A2 sky130_fd_sc_hs__mux2_1_330/A0
+ VSS VDD sky130_fd_sc_hs__a22o_1
Xsky130_fd_sc_hs__a22o_1_134 VDD VSS sky130_fd_sc_hs__nor3_1_52/B sky130_fd_sc_hs__mux2_1_435/A0
+ sky130_fd_sc_hs__nand2_1_33/B sky130_fd_sc_hs__a22oi_1_6/B1 sky130_fd_sc_hs__nor2_1_183/B
+ VSS VDD sky130_fd_sc_hs__a22o_1
Xsky130_fd_sc_hs__o31a_1_7 VDD VSS sky130_fd_sc_hs__buf_8_26/X sky130_fd_sc_hs__o31a_1_7/A2
+ sky130_fd_sc_hs__o31a_1_7/A1 sky130_fd_sc_hs__or3_1_7/A sky130_fd_sc_hs__o31a_1_7/X
+ VSS VDD sky130_fd_sc_hs__o31a_1
Xsky130_fd_sc_hs__nor3_4_3 VDD VSS sky130_fd_sc_hs__or3b_1_0/B sky130_fd_sc_hs__nor3_4_8/B
+ sky130_fd_sc_hs__nor3_4_7/C sky130_fd_sc_hs__buf_4_5/A VSS VDD sky130_fd_sc_hs__nor3_4
Xsky130_fd_sc_hs__dfrtp_1_303 sky130_fd_sc_hs__buf_8_6/X VDD VSS sky130_fd_sc_hs__xor2_1_25/B
+ sky130_fd_sc_hs__clkinv_2_4/A sky130_fd_sc_hs__a21oi_1_72/Y VSS VDD sky130_fd_sc_hs__dfrtp_1
Xsky130_fd_sc_hs__o21ai_1_90 VDD VSS sky130_fd_sc_hs__o21ai_1_90/Y sky130_fd_sc_hs__buf_8_37/X
+ sky130_fd_sc_hs__buf_8_36/X sky130_fd_sc_hs__maj3_1_52/A VSS VDD sky130_fd_sc_hs__o21ai_1
Xsky130_fd_sc_hs__dfrtp_1_314 sky130_fd_sc_hs__clkbuf_4_13/X VDD VSS sky130_fd_sc_hs__buf_1_33/A
+ sky130_fd_sc_hs__clkinv_1_55/A sky130_fd_sc_hs__buf_1_79/X VSS VDD sky130_fd_sc_hs__dfrtp_1
Xsky130_fd_sc_hs__dfrtp_1_325 sky130_fd_sc_hs__buf_8_8/X VDD VSS sky130_fd_sc_hs__a22o_1_70/B2
+ sky130_fd_sc_hs__clkinv_1_60/A sky130_fd_sc_hs__mux2_1_205/X VSS VDD sky130_fd_sc_hs__dfrtp_1
Xsky130_fd_sc_hs__dfrtp_1_336 sky130_fd_sc_hs__clkbuf_4_15/X VDD VSS sky130_fd_sc_hs__a22o_1_42/B2
+ sky130_fd_sc_hs__clkbuf_2_93/X sky130_fd_sc_hs__a22o_1_42/X VSS VDD sky130_fd_sc_hs__dfrtp_1
Xsky130_fd_sc_hs__dfrtp_1_347 sky130_fd_sc_hs__clkbuf_4_56/X VDD VSS sky130_fd_sc_hs__xor2_1_42/A
+ sky130_fd_sc_hs__clkinv_1_64/A sky130_fd_sc_hs__mux2_1_220/X VSS VDD sky130_fd_sc_hs__dfrtp_1
Xsky130_fd_sc_hs__dfrtp_1_358 sky130_fd_sc_hs__clkbuf_4_56/X VDD VSS sky130_fd_sc_hs__a22o_1_68/A1
+ sky130_fd_sc_hs__clkinv_1_70/A sky130_fd_sc_hs__a22o_1_52/X VSS VDD sky130_fd_sc_hs__dfrtp_1
Xsky130_fd_sc_hs__dfrtp_1_369 sky130_fd_sc_hs__buf_8_9/X VDD VSS sky130_fd_sc_hs__nor2_1_68/A
+ sky130_fd_sc_hs__clkbuf_2_102/X sky130_fd_sc_hs__dfrtp_1_369/D VSS VDD sky130_fd_sc_hs__dfrtp_1
Xsky130_fd_sc_hs__buf_16_16 sky130_fd_sc_hs__mux2_1_99/S VDD VSS sky130_fd_sc_hs__buf_16_16/A
+ VSS VDD sky130_fd_sc_hs__buf_16
Xsky130_fd_sc_hs__and2_1_4 VDD VSS sky130_fd_sc_hs__maj3_1_4/A sky130_fd_sc_hs__xor2_1_1/A
+ sky130_fd_sc_hs__and2_1_4/X VSS VDD sky130_fd_sc_hs__and2_1
Xsky130_fd_sc_hs__clkbuf_4_13 VDD VSS sky130_fd_sc_hs__buf_8_6/A sky130_fd_sc_hs__clkbuf_4_13/X
+ VSS VDD sky130_fd_sc_hs__clkbuf_4
Xsky130_fd_sc_hs__clkbuf_4_24 VDD VSS sky130_fd_sc_hs__buf_8_29/A sky130_fd_sc_hs__clkbuf_4_24/X
+ VSS VDD sky130_fd_sc_hs__clkbuf_4
Xsky130_fd_sc_hs__clkbuf_4_35 VDD VSS sky130_fd_sc_hs__buf_1_74/X sky130_fd_sc_hs__clkbuf_4_35/X
+ VSS VDD sky130_fd_sc_hs__clkbuf_4
Xsky130_fd_sc_hs__clkbuf_4_46 VDD VSS sky130_fd_sc_hs__nor3_4_9/Y sky130_fd_sc_hs__a222o_1_3/C2
+ VSS VDD sky130_fd_sc_hs__clkbuf_4
Xsky130_fd_sc_hs__clkbuf_8_0 VDD VSS sky130_fd_sc_hs__o32a_1_0/A2 sky130_fd_sc_hs__nor2_2_1/Y
+ VSS VDD sky130_fd_sc_hs__clkbuf_8
Xsky130_fd_sc_hs__mux2_1_307 VDD VSS sky130_fd_sc_hs__mux2_1_307/X sky130_fd_sc_hs__mux2_1_341/S
+ sky130_fd_sc_hs__a22o_1_61/B2 sky130_fd_sc_hs__mux2_1_307/A1 VSS VDD sky130_fd_sc_hs__mux2_1
Xsky130_fd_sc_hs__mux2_1_318 VDD VSS sky130_fd_sc_hs__mux2_1_318/X sky130_fd_sc_hs__buf_8_28/X
+ sky130_fd_sc_hs__a22o_1_67/B2 sky130_fd_sc_hs__mux2_1_318/A1 VSS VDD sky130_fd_sc_hs__mux2_1
Xsky130_fd_sc_hs__mux2_1_329 VDD VSS sky130_fd_sc_hs__mux2_1_329/X sky130_fd_sc_hs__buf_8_27/X
+ sky130_fd_sc_hs__mux2_1_329/A0 sky130_fd_sc_hs__dfrtp_2_1/Q VSS VDD sky130_fd_sc_hs__mux2_1
Xsky130_fd_sc_hs__xor2_1_18 VDD VSS sky130_fd_sc_hs__xor2_1_18/A sky130_fd_sc_hs__xor2_1_18/B
+ sky130_fd_sc_hs__xor2_1_18/X VSS VDD sky130_fd_sc_hs__xor2_1
Xsky130_fd_sc_hs__xor2_1_29 VDD VSS sky130_fd_sc_hs__xor2_1_29/A sky130_fd_sc_hs__xor2_1_29/B
+ sky130_fd_sc_hs__xor2_1_29/X VSS VDD sky130_fd_sc_hs__xor2_1
Xsky130_fd_sc_hs__nor3_1_20 VDD VSS sky130_fd_sc_hs__nor3_1_21/B sky130_fd_sc_hs__nor3_1_20/C
+ sky130_fd_sc_hs__nor3_1_20/B sky130_fd_sc_hs__nor3_1_20/A VSS VDD sky130_fd_sc_hs__nor3_1
Xsky130_fd_sc_hs__nor3_1_31 VDD VSS sky130_fd_sc_hs__nor3_1_31/Y sky130_fd_sc_hs__nor3_1_31/C
+ sky130_fd_sc_hs__o22ai_1_3/Y sky130_fd_sc_hs__nor3_1_33/Y VSS VDD sky130_fd_sc_hs__nor3_1
Xsky130_fd_sc_hs__nor3_1_42 VDD VSS sky130_fd_sc_hs__nor3_1_42/Y sky130_fd_sc_hs__or2_1_30/X
+ sky130_fd_sc_hs__nor3_1_44/B sky130_fd_sc_hs__or2_1_21/B VSS VDD sky130_fd_sc_hs__nor3_1
Xsky130_fd_sc_hs__nor3_2_0 VDD VSS sky130_fd_sc_hs__buf_4_6/A sky130_fd_sc_hs__or3_1_1/A
+ sky130_fd_sc_hs__or3_1_1/B sky130_fd_sc_hs__or3_1_1/C VSS VDD sky130_fd_sc_hs__nor3_2
Xsky130_fd_sc_hs__nor3_1_53 VDD VSS sky130_fd_sc_hs__xnor3_1_2/A sky130_fd_sc_hs__nor3_1_53/C
+ sky130_fd_sc_hs__xnor3_1_1/X sky130_fd_sc_hs__nor3_1_53/A VSS VDD sky130_fd_sc_hs__nor3_1
Xsky130_fd_sc_hs__a221oi_1_9 VDD VSS sky130_fd_sc_hs__nand2_1_222/Y sky130_fd_sc_hs__nand3b_1_6/B
+ sky130_fd_sc_hs__mux2_1_425/A0 sky130_fd_sc_hs__nand2_1_33/B sky130_fd_sc_hs__mux2_1_426/A0
+ sky130_fd_sc_hs__a222o_1_2/A2 VSS VDD sky130_fd_sc_hs__a221oi_1
Xsky130_fd_sc_hs__dfrtp_1_100 sky130_fd_sc_hs__buf_8_0/A VDD VSS sky130_fd_sc_hs__mux2_1_91/A0
+ sky130_fd_sc_hs__clkbuf_2_32/X sky130_fd_sc_hs__mux2_1_91/X VSS VDD sky130_fd_sc_hs__dfrtp_1
Xsky130_fd_sc_hs__dfrtp_1_111 sky130_fd_sc_hs__clkbuf_4_1/X VDD VSS sky130_fd_sc_hs__mux2_1_105/A0
+ sky130_fd_sc_hs__clkbuf_2_35/X sky130_fd_sc_hs__mux2_1_105/X VSS VDD sky130_fd_sc_hs__dfrtp_1
Xsky130_fd_sc_hs__dfrtp_1_122 sky130_fd_sc_hs__buf_8_1/X VDD VSS sky130_fd_sc_hs__xor2_1_4/B
+ sky130_fd_sc_hs__clkinv_1_17/A sky130_fd_sc_hs__mux2_1_116/X VSS VDD sky130_fd_sc_hs__dfrtp_1
Xsky130_fd_sc_hs__dfrtp_1_133 sky130_fd_sc_hs__clkbuf_4_3/A VDD VSS sky130_fd_sc_hs__mux2_1_132/A0
+ sky130_fd_sc_hs__clkinv_1_37/A sky130_fd_sc_hs__mux2_1_132/X VSS VDD sky130_fd_sc_hs__dfrtp_1
Xsky130_fd_sc_hs__dfrtp_1_144 sky130_fd_sc_hs__clkbuf_4_10/X VDD VSS sky130_fd_sc_hs__mux2_1_173/A0
+ sky130_fd_sc_hs__clkinv_1_35/A sky130_fd_sc_hs__mux2_1_173/X VSS VDD sky130_fd_sc_hs__dfrtp_1
Xsky130_fd_sc_hs__dfrtp_1_155 sky130_fd_sc_hs__clkbuf_4_5/X VDD VSS sky130_fd_sc_hs__mux2_1_139/A0
+ sky130_fd_sc_hs__clkinv_1_44/A sky130_fd_sc_hs__mux2_1_139/X VSS VDD sky130_fd_sc_hs__dfrtp_1
Xsky130_fd_sc_hs__dfrtp_1_166 sky130_fd_sc_hs__clkbuf_4_5/X VDD VSS sky130_fd_sc_hs__mux2_1_146/A0
+ sky130_fd_sc_hs__clkinv_1_39/A sky130_fd_sc_hs__mux2_1_146/X VSS VDD sky130_fd_sc_hs__dfrtp_1
Xsky130_fd_sc_hs__dfrtp_1_177 sky130_fd_sc_hs__clkbuf_16_5/X VDD VSS sky130_fd_sc_hs__buf_1_46/A
+ sky130_fd_sc_hs__clkbuf_2_62/X sky130_fd_sc_hs__o21ai_1_26/Y VSS VDD sky130_fd_sc_hs__dfrtp_1
Xsky130_fd_sc_hs__dfrtp_1_188 sky130_fd_sc_hs__clkbuf_4_10/X VDD VSS sky130_fd_sc_hs__maj3_1_8/B
+ sky130_fd_sc_hs__clkinv_2_1/A sky130_fd_sc_hs__mux2_1_140/X VSS VDD sky130_fd_sc_hs__dfrtp_1
Xsky130_fd_sc_hs__dfrtp_1_199 sky130_fd_sc_hs__buf_8_0/X VDD VSS sky130_fd_sc_hs__mux2_1_73/A0
+ sky130_fd_sc_hs__clkbuf_2_3/X sky130_fd_sc_hs__mux2_1_73/X VSS VDD sky130_fd_sc_hs__dfrtp_1
Xsky130_fd_sc_hs__buf_8_2 VDD VSS sky130_fd_sc_hs__buf_8_2/X sky130_fd_sc_hs__buf_8_2/A
+ VSS VDD sky130_fd_sc_hs__buf_8
Xsky130_fd_sc_hs__o21a_1_6 VDD VSS sky130_fd_sc_hs__o21a_1_6/X sky130_fd_sc_hs__o21a_1_6/A2
+ sky130_fd_sc_hs__o21a_1_6/B1 sky130_fd_sc_hs__a21o_1_0/X VSS VDD sky130_fd_sc_hs__o21a_1
Xsky130_fd_sc_hs__clkinv_1_150 VDD VSS sky130_fd_sc_hs__clkinv_1_150/A sky130_fd_sc_hs__clkinv_1_150/Y
+ VSS VDD sky130_fd_sc_hs__clkinv_1
Xsky130_fd_sc_hs__clkinv_1_161 VDD VSS sky130_fd_sc_hs__clkinv_1_161/A sky130_fd_sc_hs__clkinv_1_161/Y
+ VSS VDD sky130_fd_sc_hs__clkinv_1
Xsky130_fd_sc_hs__o311ai_1_13 VDD VSS sky130_fd_sc_hs__nor2_1_75/Y sky130_fd_sc_hs__or2_1_14/B
+ sky130_fd_sc_hs__nand2_1_99/A sky130_fd_sc_hs__nand2_1_98/Y sky130_fd_sc_hs__and2_1_20/B
+ sky130_fd_sc_hs__nor2_1_78/B VSS VDD sky130_fd_sc_hs__o311ai_1
Xsky130_fd_sc_hs__nor2_1_120 VDD VSS sky130_fd_sc_hs__nor2_2_2/B sky130_fd_sc_hs__or3_1_3/B
+ sky130_fd_sc_hs__nor2_4_0/A VSS VDD sky130_fd_sc_hs__nor2_1
Xsky130_fd_sc_hs__nor2_1_131 VDD VSS sky130_fd_sc_hs__nor2_1_131/B sky130_fd_sc_hs__nor3_1_22/B
+ sky130_fd_sc_hs__and2_1_34/B VSS VDD sky130_fd_sc_hs__nor2_1
Xsky130_fd_sc_hs__nor2_1_142 VDD VSS sky130_fd_sc_hs__or3_1_4/X sky130_fd_sc_hs__and2_1_35/B
+ sky130_fd_sc_hs__nor3_1_36/A VSS VDD sky130_fd_sc_hs__nor2_1
Xsky130_fd_sc_hs__nor2_1_153 VDD VSS sky130_fd_sc_hs__nor3b_1_3/B sky130_fd_sc_hs__nor2_1_153/Y
+ sky130_fd_sc_hs__or2_1_21/X VSS VDD sky130_fd_sc_hs__nor2_1
Xsky130_fd_sc_hs__clkinv_1_7 VDD VSS sky130_fd_sc_hs__clkinv_1_7/A sky130_fd_sc_hs__clkinv_1_7/Y
+ VSS VDD sky130_fd_sc_hs__clkinv_1
Xsky130_fd_sc_hs__nor2_1_164 VDD VSS sky130_fd_sc_hs__and2_1_38/B sky130_fd_sc_hs__nor2_1_167/B
+ sky130_fd_sc_hs__xor2_1_53/A VSS VDD sky130_fd_sc_hs__nor2_1
Xsky130_fd_sc_hs__a22oi_1_40 VDD VSS sky130_fd_sc_hs__mux2_1_170/A0 sky130_fd_sc_hs__and4_1_2/C
+ sky130_fd_sc_hs__a22oi_1_7/B1 sky130_fd_sc_hs__nand2_1_51/B sky130_fd_sc_hs__mux2_1_173/A0
+ VSS VDD sky130_fd_sc_hs__a22oi_1
Xsky130_fd_sc_hs__nor2_1_175 VDD VSS sky130_fd_sc_hs__o21ai_1_58/Y sky130_fd_sc_hs__nor2_1_175/Y
+ sky130_fd_sc_hs__o21a_1_4/B1 VSS VDD sky130_fd_sc_hs__nor2_1
Xsky130_fd_sc_hs__a22oi_1_51 VDD VSS sky130_fd_sc_hs__mux2_1_154/A0 sky130_fd_sc_hs__and4_1_3/B
+ sky130_fd_sc_hs__a22oi_1_5/A2 sky130_fd_sc_hs__a222o_1_2/A2 sky130_fd_sc_hs__mux2_1_155/A0
+ VSS VDD sky130_fd_sc_hs__a22oi_1
Xsky130_fd_sc_hs__a22oi_1_62 VDD VSS sky130_fd_sc_hs__nor2_1_152/A sky130_fd_sc_hs__a22oi_1_62/Y
+ sky130_fd_sc_hs__nor2b_1_49/Y sky130_fd_sc_hs__and2_1_33/X sky130_fd_sc_hs__o22ai_1_2/B2
+ VSS VDD sky130_fd_sc_hs__a22oi_1
Xsky130_fd_sc_hs__nor2_1_186 VDD VSS sky130_fd_sc_hs__o31ai_1_8/A3 sky130_fd_sc_hs__xor2_1_92/B
+ sky130_fd_sc_hs__nor2_1_74/B VSS VDD sky130_fd_sc_hs__nor2_1
Xsky130_fd_sc_hs__a22oi_1_73 VDD VSS sky130_fd_sc_hs__nand4_1_9/C sky130_fd_sc_hs__dfstp_1_2/D
+ sky130_fd_sc_hs__buf_8_16/X sky130_fd_sc_hs__buf_8_18/X sky130_fd_sc_hs__nor2_1_177/A
+ VSS VDD sky130_fd_sc_hs__a22oi_1
Xsky130_fd_sc_hs__a22oi_1_84 VDD VSS sky130_fd_sc_hs__mux2_1_298/A1 sky130_fd_sc_hs__and4_1_7/A
+ sky130_fd_sc_hs__nand2_1_200/B sky130_fd_sc_hs__a222o_1_7/A2 sky130_fd_sc_hs__mux2_1_353/A1
+ VSS VDD sky130_fd_sc_hs__a22oi_1
Xsky130_fd_sc_hs__a22oi_1_95 VDD VSS sky130_fd_sc_hs__mux2_1_356/A0 sky130_fd_sc_hs__nand3_1_37/B
+ sky130_fd_sc_hs__nand2_1_51/B sky130_fd_sc_hs__buf_4_5/X sky130_fd_sc_hs__mux2_1_362/A0
+ VSS VDD sky130_fd_sc_hs__a22oi_1
Xsky130_fd_sc_hs__mux2_1_104 VDD VSS sky130_fd_sc_hs__mux2_1_104/X sky130_fd_sc_hs__mux2_1_1/S
+ sky130_fd_sc_hs__mux2_1_98/A1 sky130_fd_sc_hs__mux2_1_104/A1 VSS VDD sky130_fd_sc_hs__mux2_1
Xsky130_fd_sc_hs__mux2_1_115 VDD VSS sky130_fd_sc_hs__mux2_1_115/X sky130_fd_sc_hs__mux2_1_94/S
+ sky130_fd_sc_hs__or2_1_3/B sky130_fd_sc_hs__a22o_1_40/B2 VSS VDD sky130_fd_sc_hs__mux2_1
Xsky130_fd_sc_hs__mux2_1_126 VDD VSS sky130_fd_sc_hs__mux2_1_126/X sky130_fd_sc_hs__mux2_1_99/S
+ sky130_fd_sc_hs__a22o_1_60/B2 sky130_fd_sc_hs__mux2_1_126/A1 VSS VDD sky130_fd_sc_hs__mux2_1
Xsky130_fd_sc_hs__mux2_1_137 VDD VSS sky130_fd_sc_hs__mux2_1_137/X sky130_fd_sc_hs__mux2_1_9/S
+ sky130_fd_sc_hs__mux2_1_137/A0 sky130_fd_sc_hs__a22o_1_60/B2 VSS VDD sky130_fd_sc_hs__mux2_1
Xsky130_fd_sc_hs__mux2_1_148 VDD VSS sky130_fd_sc_hs__mux2_1_148/X sky130_fd_sc_hs__mux2_1_99/S
+ sky130_fd_sc_hs__a22o_1_40/B2 sky130_fd_sc_hs__nand2_1_52/A VSS VDD sky130_fd_sc_hs__mux2_1
Xsky130_fd_sc_hs__mux2_1_159 VDD VSS sky130_fd_sc_hs__mux2_1_159/X sky130_fd_sc_hs__mux2_1_94/S
+ sky130_fd_sc_hs__maj3_1_9/B sky130_fd_sc_hs__a22o_1_75/B2 VSS VDD sky130_fd_sc_hs__mux2_1
Xsky130_fd_sc_hs__buf_1_9 VDD VSS sky130_fd_sc_hs__buf_1_9/A srm_total_count[3] VSS
+ VDD sky130_fd_sc_hs__buf_1
Xsky130_fd_sc_hs__or3_1_5 VDD VSS sky130_fd_sc_hs__or3_1_6/A sky130_fd_sc_hs__or3_1_5/B
+ sky130_fd_sc_hs__or3_1_6/C sky130_fd_sc_hs__or3_1_5/X VSS VDD sky130_fd_sc_hs__or3_1
Xsky130_fd_sc_hs__a31o_1_0 VDD VSS sky130_fd_sc_hs__and2_1_0/B sky130_fd_sc_hs__xor2_1_0/A
+ sky130_fd_sc_hs__xnor2_1_5/A sky130_fd_sc_hs__nor3_1_2/A sky130_fd_sc_hs__nor2_1_7/A
+ VSS VDD sky130_fd_sc_hs__a31o_1
Xsky130_fd_sc_hs__buf_1_107 VDD VSS sky130_fd_sc_hs__buf_1_107/A dac_p_force[9] VSS
+ VDD sky130_fd_sc_hs__buf_1
Xsky130_fd_sc_hs__buf_1_118 VDD VSS sky130_fd_sc_hs__buf_1_118/A dac_n_force[15] VSS
+ VDD sky130_fd_sc_hs__buf_1
Xsky130_fd_sc_hs__buf_1_129 VDD VSS sky130_fd_sc_hs__buf_1_129/A w_wr_data[8] VSS
+ VDD sky130_fd_sc_hs__buf_1
Xsky130_fd_sc_hs__mux2i_1_9 VDD VSS sky130_fd_sc_hs__mux2i_1_9/S sky130_fd_sc_hs__mux2i_1_9/A1
+ sky130_fd_sc_hs__or2_1_22/B sky130_fd_sc_hs__mux2i_1_9/Y VSS VDD sky130_fd_sc_hs__mux2i_1
Xsky130_fd_sc_hs__a31oi_1_9 VDD VSS sky130_fd_sc_hs__a31oi_1_9/Y sky130_fd_sc_hs__nor2_4_0/Y
+ sky130_fd_sc_hs__and4_1_5/C sky130_fd_sc_hs__and4_1_5/B sky130_fd_sc_hs__and4_1_5/A
+ VSS VDD sky130_fd_sc_hs__a31oi_1
Xsky130_fd_sc_hs__o21a_1_10 VDD VSS sky130_fd_sc_hs__o21a_1_10/X sky130_fd_sc_hs__buf_1_22/X
+ sky130_fd_sc_hs__buf_8_2/A sky130_fd_sc_hs__xor2_1_9/A VSS VDD sky130_fd_sc_hs__o21a_1
Xsky130_fd_sc_hs__o21a_1_21 VDD VSS sky130_fd_sc_hs__o21a_1_21/X sky130_fd_sc_hs__o21a_1_21/A2
+ sky130_fd_sc_hs__nor2_4_0/Y sky130_fd_sc_hs__and2_1_31/X VSS VDD sky130_fd_sc_hs__o21a_1
Xsky130_fd_sc_hs__clkbuf_2_204 VDD VSS sky130_fd_sc_hs__dfrtp_2_4/CLK sky130_fd_sc_hs__inv_8_1/A
+ VSS VDD sky130_fd_sc_hs__clkbuf_2
Xsky130_fd_sc_hs__o21a_1_32 VDD VSS sky130_fd_sc_hs__o21a_1_32/X sky130_fd_sc_hs__nor3_1_53/C
+ sky130_fd_sc_hs__xnor3_1_1/X sky130_fd_sc_hs__nor3_1_53/A VSS VDD sky130_fd_sc_hs__o21a_1
Xsky130_fd_sc_hs__clkbuf_2_215 VDD VSS sky130_fd_sc_hs__clkbuf_2_215/X sky130_fd_sc_hs__clkbuf_8_17/A
+ VSS VDD sky130_fd_sc_hs__clkbuf_2
Xsky130_fd_sc_hs__clkbuf_2_226 VDD VSS sky130_fd_sc_hs__clkbuf_2_226/X sky130_fd_sc_hs__clkbuf_8_17/A
+ VSS VDD sky130_fd_sc_hs__clkbuf_2
Xsky130_fd_sc_hs__clkbuf_2_237 VDD VSS sky130_fd_sc_hs__clkbuf_2_237/X sky130_fd_sc_hs__clkbuf_8_17/A
+ VSS VDD sky130_fd_sc_hs__clkbuf_2
Xsky130_fd_sc_hs__nand2_1_204 VDD VSS sky130_fd_sc_hs__a22oi_1_83/Y sky130_fd_sc_hs__nand2_1_204/Y
+ sky130_fd_sc_hs__a22oi_1_91/Y VSS VDD sky130_fd_sc_hs__nand2_1
Xsky130_fd_sc_hs__nand2_1_215 VDD VSS sky130_fd_sc_hs__nor3_1_34/Y sky130_fd_sc_hs__buf_1_96/A
+ sky130_fd_sc_hs__nor2b_1_48/Y VSS VDD sky130_fd_sc_hs__nand2_1
Xsky130_fd_sc_hs__nand2_1_226 VDD VSS sky130_fd_sc_hs__nand2_1_226/B sky130_fd_sc_hs__nor3_1_55/A
+ sky130_fd_sc_hs__nand2_1_226/A VSS VDD sky130_fd_sc_hs__nand2_1
Xsky130_fd_sc_hs__nand2_1_237 VDD VSS sky130_fd_sc_hs__o21ai_1_9/Y sky130_fd_sc_hs__nand2_1_237/Y
+ sky130_fd_sc_hs__nand2_1_237/A VSS VDD sky130_fd_sc_hs__nand2_1
Xsky130_fd_sc_hs__and2_1_11 VDD VSS sky130_fd_sc_hs__or2_1_3/A sky130_fd_sc_hs__nor2_1_27/B
+ sky130_fd_sc_hs__nor2_1_11/A VSS VDD sky130_fd_sc_hs__and2_1
Xsky130_fd_sc_hs__and2_1_22 VDD VSS sky130_fd_sc_hs__and2_1_7/A sky130_fd_sc_hs__xor2_1_46/A
+ sky130_fd_sc_hs__nor2_1_70/A VSS VDD sky130_fd_sc_hs__and2_1
Xsky130_fd_sc_hs__and2_1_33 VDD VSS sky130_fd_sc_hs__or2_1_29/A sky130_fd_sc_hs__or3b_1_0/A
+ sky130_fd_sc_hs__and2_1_33/X VSS VDD sky130_fd_sc_hs__and2_1
Xsky130_fd_sc_hs__and2_1_44 VDD VSS sky130_fd_sc_hs__maj3_1_52/A sky130_fd_sc_hs__maj3_1_52/B
+ sky130_fd_sc_hs__and2_1_44/X VSS VDD sky130_fd_sc_hs__and2_1
Xsky130_fd_sc_hs__o2bb2ai_1_18 VDD VSS sky130_fd_sc_hs__dfrtp_1_277/D sky130_fd_sc_hs__xnor2_1_51/Y
+ sky130_fd_sc_hs__nor2_1_7/A sky130_fd_sc_hs__nand3_1_18/Y sky130_fd_sc_hs__nor2_1_45/B
+ VSS VDD sky130_fd_sc_hs__o2bb2ai_1
Xsky130_fd_sc_hs__o2bb2ai_1_29 VDD VSS sky130_fd_sc_hs__dfrtp_1_510/D sky130_fd_sc_hs__nand2_1_116/Y
+ sky130_fd_sc_hs__maj3_1_37/C sky130_fd_sc_hs__a21oi_1_117/Y sky130_fd_sc_hs__a32o_1_7/B1
+ VSS VDD sky130_fd_sc_hs__o2bb2ai_1
Xsky130_fd_sc_hs__nand3_1_13 VDD VSS sky130_fd_sc_hs__o21ai_1_17/Y sky130_fd_sc_hs__and2_1_10/A
+ sky130_fd_sc_hs__nand3b_1_1/Y sky130_fd_sc_hs__maj3_1_5/X VSS VDD sky130_fd_sc_hs__nand3_1
Xsky130_fd_sc_hs__nand3_1_24 VDD VSS sky130_fd_sc_hs__nor3_1_35/C sky130_fd_sc_hs__nand3_1_24/Y
+ sky130_fd_sc_hs__or2_1_22/B sky130_fd_sc_hs__o21a_1_27/B1 VSS VDD sky130_fd_sc_hs__nand3_1
Xsky130_fd_sc_hs__nand3_1_35 VDD VSS sky130_fd_sc_hs__nor3_1_48/C sky130_fd_sc_hs__nor2_2_7/B
+ sky130_fd_sc_hs__nor3_1_48/B sky130_fd_sc_hs__nor3_1_48/A VSS VDD sky130_fd_sc_hs__nand3_1
Xsky130_fd_sc_hs__o2bb2ai_1_5 VDD VSS sky130_fd_sc_hs__o2bb2ai_1_5/Y sky130_fd_sc_hs__o31ai_1_1/Y
+ sky130_fd_sc_hs__or2_1_1/A sky130_fd_sc_hs__o21a_1_2/X sky130_fd_sc_hs__a32o_1_2/B1
+ VSS VDD sky130_fd_sc_hs__o2bb2ai_1
Xsky130_fd_sc_hs__nand3_1_46 VDD VSS sky130_fd_sc_hs__and4_1_6/X sky130_fd_sc_hs__and3_1_3/A
+ sky130_fd_sc_hs__nand3_1_46/B sky130_fd_sc_hs__xnor2_1_16/A VSS VDD sky130_fd_sc_hs__nand3_1
Xsky130_fd_sc_hs__mux2i_1_10 VDD VSS sky130_fd_sc_hs__mux2i_1_10/S sky130_fd_sc_hs__nand2_1_156/A
+ sky130_fd_sc_hs__or2_1_22/B sky130_fd_sc_hs__mux2i_1_10/Y VSS VDD sky130_fd_sc_hs__mux2i_1
Xsky130_fd_sc_hs__buf_1_10 VDD VSS sky130_fd_sc_hs__buf_1_10/A srm_total_count[0]
+ VSS VDD sky130_fd_sc_hs__buf_1
Xsky130_fd_sc_hs__buf_1_21 VDD VSS sky130_fd_sc_hs__buf_8_38/X sky130_fd_sc_hs__buf_8_0/A
+ VSS VDD sky130_fd_sc_hs__buf_1
Xsky130_fd_sc_hs__buf_1_32 VDD VSS sky130_fd_sc_hs__buf_1_32/A w_wr_data[19] VSS VDD
+ sky130_fd_sc_hs__buf_1
Xsky130_fd_sc_hs__buf_1_43 VDD VSS sky130_fd_sc_hs__buf_1_43/A w_wr_data[9] VSS VDD
+ sky130_fd_sc_hs__buf_1
Xsky130_fd_sc_hs__buf_1_54 VDD VSS sky130_fd_sc_hs__buf_1_54/A raw_code_o[15] VSS
+ VDD sky130_fd_sc_hs__buf_1
Xsky130_fd_sc_hs__buf_1_65 VDD VSS srm_decision_valid sky130_fd_sc_hs__buf_1_65/X
+ VSS VDD sky130_fd_sc_hs__buf_1
Xsky130_fd_sc_hs__buf_1_76 VDD VSS sky130_fd_sc_hs__buf_1_76/A sky130_fd_sc_hs__buf_1_76/X
+ VSS VDD sky130_fd_sc_hs__buf_1
Xsky130_fd_sc_hs__buf_1_87 VDD VSS sky130_fd_sc_hs__buf_1_87/A sky130_fd_sc_hs__buf_8_16/A
+ VSS VDD sky130_fd_sc_hs__buf_1
Xsky130_fd_sc_hs__buf_1_98 VDD VSS sky130_fd_sc_hs__buf_1_98/A dac_n_force[9] VSS
+ VDD sky130_fd_sc_hs__buf_1
Xsky130_fd_sc_hs__a22o_1_90 VDD VSS sky130_fd_sc_hs__a22o_1_90/X sky130_fd_sc_hs__a22o_1_90/B2
+ sky130_fd_sc_hs__a22o_1_90/B1 sky130_fd_sc_hs__a22o_1_90/A2 sky130_fd_sc_hs__maj3_1_50/C
+ VSS VDD sky130_fd_sc_hs__a22o_1
Xsky130_fd_sc_hs__clkbuf_2_90 VDD VSS sky130_fd_sc_hs__clkinv_1_60/A sky130_fd_sc_hs__clkbuf_2_92/A
+ VSS VDD sky130_fd_sc_hs__clkbuf_2
Xsky130_fd_sc_hs__maj3_1_30 VDD VSS sky130_fd_sc_hs__nor2_1_77/A sky130_fd_sc_hs__xor2_1_54/A
+ sky130_fd_sc_hs__maj3_1_30/X sky130_fd_sc_hs__xor2_1_54/B VSS VDD sky130_fd_sc_hs__maj3_1
Xsky130_fd_sc_hs__maj3_1_41 VDD VSS sky130_fd_sc_hs__xor2_1_70/A sky130_fd_sc_hs__xor2_1_70/B
+ sky130_fd_sc_hs__maj3_1_41/X sky130_fd_sc_hs__maj3_1_41/C VSS VDD sky130_fd_sc_hs__maj3_1
Xsky130_fd_sc_hs__maj3_1_52 VDD VSS sky130_fd_sc_hs__maj3_1_52/A sky130_fd_sc_hs__maj3_1_52/B
+ sky130_fd_sc_hs__maj3_1_52/X sky130_fd_sc_hs__maj3_1_52/C VSS VDD sky130_fd_sc_hs__maj3_1
Xsky130_fd_sc_hs__maj3_1_63 VDD VSS sky130_fd_sc_hs__xor2_1_88/A sky130_fd_sc_hs__xor2_1_88/B
+ sky130_fd_sc_hs__maj3_1_63/X sky130_fd_sc_hs__maj3_1_63/C VSS VDD sky130_fd_sc_hs__maj3_1
Xsky130_fd_sc_hs__o21bai_1_2 VDD VSS sky130_fd_sc_hs__o32a_1_0/A2 sky130_fd_sc_hs__o21bai_1_2/Y
+ sky130_fd_sc_hs__and3_1_9/C sky130_fd_sc_hs__and3_1_9/A VSS VDD sky130_fd_sc_hs__o21bai_1
Xsky130_fd_sc_hs__nor2b_1_8 VDD VSS sky130_fd_sc_hs__xor2_1_18/A sky130_fd_sc_hs__nor2b_1_8/Y
+ sky130_fd_sc_hs__nor2b_1_8/A VSS VDD sky130_fd_sc_hs__nor2b_1
Xsky130_fd_sc_hs__nand2_1_90 VDD VSS sky130_fd_sc_hs__or2_1_1/B sky130_fd_sc_hs__and2_1_50/A
+ sky130_fd_sc_hs__or2_1_1/A VSS VDD sky130_fd_sc_hs__nand2_1
Xsky130_fd_sc_hs__a222oi_1_20 VDD VSS sky130_fd_sc_hs__mux2_1_335/A1 sky130_fd_sc_hs__nand2_1_200/B
+ sky130_fd_sc_hs__a22oi_1_7/B1 sky130_fd_sc_hs__clkbuf_8_15/X sky130_fd_sc_hs__mux2_1_337/A0
+ sky130_fd_sc_hs__nand2_1_199/B sky130_fd_sc_hs__mux2_1_297/A0 VSS VDD sky130_fd_sc_hs__a222oi_1
Xsky130_fd_sc_hs__o31ai_1_12 VDD VSS sky130_fd_sc_hs__and4_1_5/X sky130_fd_sc_hs__a31oi_1_10/Y
+ sky130_fd_sc_hs__o31ai_1_12/B1 sky130_fd_sc_hs__buf_8_12/A sky130_fd_sc_hs__o31ai_1_12/Y
+ VSS VDD sky130_fd_sc_hs__o31ai_1
Xsky130_fd_sc_hs__clkbuf_16_19 VDD VSS sky130_fd_sc_hs__clkinv_4_7/A sky130_fd_sc_hs__clkbuf_8_19/X
+ VSS VDD sky130_fd_sc_hs__clkbuf_16
Xsky130_fd_sc_hs__nor2_1_6 VDD VSS sky130_fd_sc_hs__or2_1_0/B sky130_fd_sc_hs__nor2_1_6/Y
+ sky130_fd_sc_hs__or2_1_0/A VSS VDD sky130_fd_sc_hs__nor2_1
Xsky130_fd_sc_hs__clkbuf_16_3 VDD VSS sky130_fd_sc_hs__clkbuf_4_3/A sky130_fd_sc_hs__clkbuf_4_4/A
+ VSS VDD sky130_fd_sc_hs__clkbuf_16
Xsky130_fd_sc_hs__dfrtp_1_507 sky130_fd_sc_hs__clkbuf_4_22/X VDD VSS sky130_fd_sc_hs__or3_1_4/C
+ sky130_fd_sc_hs__clkinv_1_97/A sky130_fd_sc_hs__o31ai_1_14/Y VSS VDD sky130_fd_sc_hs__dfrtp_1
Xsky130_fd_sc_hs__dfrtp_1_518 sky130_fd_sc_hs__clkbuf_4_22/X VDD VSS sky130_fd_sc_hs__a22o_1_95/A1
+ sky130_fd_sc_hs__clkinv_1_77/A sky130_fd_sc_hs__a22o_1_113/X VSS VDD sky130_fd_sc_hs__dfrtp_1
Xsky130_fd_sc_hs__dfrtp_1_529 sky130_fd_sc_hs__clkbuf_4_24/X VDD VSS sky130_fd_sc_hs__buf_1_134/A
+ sky130_fd_sc_hs__clkinv_1_108/A sky130_fd_sc_hs__mux2_1_252/X VSS VDD sky130_fd_sc_hs__dfrtp_1
Xsky130_fd_sc_hs__a21oi_1_14 VDD VSS sky130_fd_sc_hs__nor2_1_38/Y sky130_fd_sc_hs__a21oi_1_14/Y
+ sky130_fd_sc_hs__nand2_1_15/Y sky130_fd_sc_hs__xnor3_1_0/B VSS VDD sky130_fd_sc_hs__a21oi_1
Xsky130_fd_sc_hs__a21oi_1_25 VDD VSS sky130_fd_sc_hs__o21ai_1_7/Y sky130_fd_sc_hs__o21ai_1_5/A2
+ sky130_fd_sc_hs__and2_1_5/X sky130_fd_sc_hs__nor2_1_15/Y VSS VDD sky130_fd_sc_hs__a21oi_1
Xsky130_fd_sc_hs__a21oi_1_36 VDD VSS sky130_fd_sc_hs__o31ai_1_4/A1 sky130_fd_sc_hs__a22o_1_16/B2
+ sky130_fd_sc_hs__or2_1_5/X sky130_fd_sc_hs__or2_1_4/A VSS VDD sky130_fd_sc_hs__a21oi_1
Xsky130_fd_sc_hs__a21oi_1_47 VDD VSS sky130_fd_sc_hs__nor2_1_36/Y sky130_fd_sc_hs__a21oi_1_47/Y
+ sky130_fd_sc_hs__buf_8_3/X sky130_fd_sc_hs__nor3_1_46/B VSS VDD sky130_fd_sc_hs__a21oi_1
Xsky130_fd_sc_hs__a21oi_1_58 VDD VSS sky130_fd_sc_hs__nor2_1_48/A sky130_fd_sc_hs__a32o_1_4/B1
+ sky130_fd_sc_hs__and3_1_7/X sky130_fd_sc_hs__buf_1_66/X VSS VDD sky130_fd_sc_hs__a21oi_1
Xsky130_fd_sc_hs__a21oi_1_69 VDD VSS sky130_fd_sc_hs__or2_1_8/X sky130_fd_sc_hs__nand3_1_18/C
+ sky130_fd_sc_hs__o32a_1_0/A1 sky130_fd_sc_hs__or2_1_0/A VSS VDD sky130_fd_sc_hs__a21oi_1
Xsky130_fd_sc_hs__dfrtp_1_12 sky130_fd_sc_hs__clkbuf_4_4/X VDD VSS sky130_fd_sc_hs__mux2_1_17/A0
+ sky130_fd_sc_hs__clkbuf_2_4/X sky130_fd_sc_hs__mux2_1_17/X VSS VDD sky130_fd_sc_hs__dfrtp_1
Xsky130_fd_sc_hs__a22oi_1_100 VDD VSS sky130_fd_sc_hs__mux2_1_416/A1 sky130_fd_sc_hs__nand3_1_43/C
+ sky130_fd_sc_hs__buf_16_8/X sky130_fd_sc_hs__a22o_1_8/A2 sky130_fd_sc_hs__mux2_1_457/A0
+ VSS VDD sky130_fd_sc_hs__a22oi_1
Xsky130_fd_sc_hs__dfrtp_1_23 sky130_fd_sc_hs__clkbuf_4_3/X VDD VSS sky130_fd_sc_hs__mux2_1_24/A0
+ sky130_fd_sc_hs__clkbuf_2_7/X sky130_fd_sc_hs__mux2_1_24/X VSS VDD sky130_fd_sc_hs__dfrtp_1
Xsky130_fd_sc_hs__dfrtp_1_34 sky130_fd_sc_hs__clkbuf_4_3/X VDD VSS sky130_fd_sc_hs__mux2_1_29/A1
+ sky130_fd_sc_hs__clkbuf_2_10/X sky130_fd_sc_hs__mux2_1_29/X VSS VDD sky130_fd_sc_hs__dfrtp_1
Xsky130_fd_sc_hs__a22oi_1_111 VDD VSS sky130_fd_sc_hs__mux2_1_454/A1 sky130_fd_sc_hs__nand2_1_226/A
+ sky130_fd_sc_hs__buf_16_9/X sky130_fd_sc_hs__a22o_1_9/A2 sky130_fd_sc_hs__mux2_1_455/A1
+ VSS VDD sky130_fd_sc_hs__a22oi_1
Xsky130_fd_sc_hs__dfrtp_1_45 sky130_fd_sc_hs__clkbuf_4_0/X VDD VSS sky130_fd_sc_hs__mux2_1_42/A1
+ sky130_fd_sc_hs__clkbuf_2_24/X sky130_fd_sc_hs__mux2_1_42/X VSS VDD sky130_fd_sc_hs__dfrtp_1
Xsky130_fd_sc_hs__dfrtp_1_56 sky130_fd_sc_hs__buf_8_38/X VDD VSS sky130_fd_sc_hs__mux2_1_98/A0
+ sky130_fd_sc_hs__clkinv_1_9/A sky130_fd_sc_hs__mux2_1_98/X VSS VDD sky130_fd_sc_hs__dfrtp_1
Xsky130_fd_sc_hs__dfrtp_1_67 sky130_fd_sc_hs__clkbuf_4_0/X VDD VSS sky130_fd_sc_hs__mux2_1_62/A1
+ sky130_fd_sc_hs__clkbuf_2_29/X sky130_fd_sc_hs__mux2_1_62/X VSS VDD sky130_fd_sc_hs__dfrtp_1
Xsky130_fd_sc_hs__dfrtp_1_78 sky130_fd_sc_hs__buf_8_0/X VDD VSS sky130_fd_sc_hs__mux2_1_90/A0
+ sky130_fd_sc_hs__clkbuf_2_25/X sky130_fd_sc_hs__mux2_1_90/X VSS VDD sky130_fd_sc_hs__dfrtp_1
Xsky130_fd_sc_hs__dfrtp_1_89 sky130_fd_sc_hs__clkbuf_4_0/X VDD VSS sky130_fd_sc_hs__mux2_1_85/A1
+ sky130_fd_sc_hs__clkbuf_2_14/X sky130_fd_sc_hs__mux2_1_85/X VSS VDD sky130_fd_sc_hs__dfrtp_1
Xsky130_fd_sc_hs__a22o_1_102 VDD VSS sky130_fd_sc_hs__a22o_1_102/X sky130_fd_sc_hs__a22o_1_102/B2
+ sky130_fd_sc_hs__or2_1_20/X sky130_fd_sc_hs__buf_8_13/X sky130_fd_sc_hs__maj3_1_46/C
+ VSS VDD sky130_fd_sc_hs__a22o_1
Xsky130_fd_sc_hs__a22o_1_113 VDD VSS sky130_fd_sc_hs__a22o_1_113/X sky130_fd_sc_hs__a22o_1_95/A1
+ sky130_fd_sc_hs__buf_8_16/A sky130_fd_sc_hs__buf_8_18/A sky130_fd_sc_hs__maj3_1_38/C
+ VSS VDD sky130_fd_sc_hs__a22o_1
Xsky130_fd_sc_hs__a22o_1_124 VDD VSS sky130_fd_sc_hs__nor3_1_49/B sky130_fd_sc_hs__mux2_1_334/A0
+ sky130_fd_sc_hs__a22oi_1_7/B1 sky130_fd_sc_hs__buf_4_5/X sky130_fd_sc_hs__mux2_1_468/A0
+ VSS VDD sky130_fd_sc_hs__a22o_1
Xsky130_fd_sc_hs__a22o_1_135 VDD VSS sky130_fd_sc_hs__nor3_1_54/C sky130_fd_sc_hs__mux2_1_467/A0
+ sky130_fd_sc_hs__nand2_1_51/B sky130_fd_sc_hs__a22oi_1_5/A2 sky130_fd_sc_hs__mux2_1_438/A0
+ VSS VDD sky130_fd_sc_hs__a22o_1
Xsky130_fd_sc_hs__nor3_4_4 VDD VSS sky130_fd_sc_hs__or3b_1_0/B sky130_fd_sc_hs__nor3_4_7/C
+ sky130_fd_sc_hs__nor3_4_6/C sky130_fd_sc_hs__nor3_4_4/Y VSS VDD sky130_fd_sc_hs__nor3_4
Xsky130_fd_sc_hs__o21ai_1_80 VDD VSS sky130_fd_sc_hs__dfstp_1_3/D sky130_fd_sc_hs__o21ai_1_80/B1
+ sky130_fd_sc_hs__nor3_1_47/Y sky130_fd_sc_hs__nand4_1_4/Y VSS VDD sky130_fd_sc_hs__o21ai_1
Xsky130_fd_sc_hs__dfrtp_1_304 sky130_fd_sc_hs__clkbuf_4_13/X VDD VSS sky130_fd_sc_hs__buf_1_34/A
+ sky130_fd_sc_hs__clkinv_1_56/A sky130_fd_sc_hs__buf_1_89/X VSS VDD sky130_fd_sc_hs__dfrtp_1
Xsky130_fd_sc_hs__o21ai_1_91 VDD VSS sky130_fd_sc_hs__o21ai_1_91/Y sky130_fd_sc_hs__o21a_1_4/B1
+ sky130_fd_sc_hs__o21a_1_30/X sky130_fd_sc_hs__o21ai_1_91/A1 VSS VDD sky130_fd_sc_hs__o21ai_1
Xsky130_fd_sc_hs__dfrtp_1_315 sky130_fd_sc_hs__clkbuf_4_13/X VDD VSS sky130_fd_sc_hs__buf_1_35/A
+ sky130_fd_sc_hs__clkbuf_2_84/X sky130_fd_sc_hs__buf_1_77/X VSS VDD sky130_fd_sc_hs__dfrtp_1
Xsky130_fd_sc_hs__dfrtp_1_326 sky130_fd_sc_hs__buf_8_8/X VDD VSS sky130_fd_sc_hs__a22o_1_70/A1
+ sky130_fd_sc_hs__clkinv_1_60/A sky130_fd_sc_hs__mux2_1_215/X VSS VDD sky130_fd_sc_hs__dfrtp_1
Xsky130_fd_sc_hs__dfrtp_1_337 sky130_fd_sc_hs__clkbuf_4_15/X VDD VSS sky130_fd_sc_hs__xor2_1_34/B
+ sky130_fd_sc_hs__clkbuf_2_93/X sky130_fd_sc_hs__mux2_1_209/X VSS VDD sky130_fd_sc_hs__dfrtp_1
Xsky130_fd_sc_hs__dfrtp_1_348 sky130_fd_sc_hs__clkbuf_4_56/X VDD VSS sky130_fd_sc_hs__xor2_1_39/B
+ sky130_fd_sc_hs__clkinv_1_69/A sky130_fd_sc_hs__mux2_1_225/X VSS VDD sky130_fd_sc_hs__dfrtp_1
Xsky130_fd_sc_hs__dfrtp_1_359 sky130_fd_sc_hs__clkbuf_4_15/X VDD VSS sky130_fd_sc_hs__mux2_1_9/A1
+ sky130_fd_sc_hs__clkbuf_2_103/X sky130_fd_sc_hs__a22o_1_68/X VSS VDD sky130_fd_sc_hs__dfrtp_1
Xsky130_fd_sc_hs__and2_1_5 VDD VSS sky130_fd_sc_hs__or2_1_1/X sky130_fd_sc_hs__and2_1_5/B
+ sky130_fd_sc_hs__and2_1_5/X VSS VDD sky130_fd_sc_hs__and2_1
Xsky130_fd_sc_hs__clkbuf_4_14 VDD VSS sky130_fd_sc_hs__buf_8_6/X sky130_fd_sc_hs__clkbuf_4_14/X
+ VSS VDD sky130_fd_sc_hs__clkbuf_4
Xsky130_fd_sc_hs__clkbuf_4_25 VDD VSS sky130_fd_sc_hs__buf_4_1/A sky130_fd_sc_hs__buf_16_2/A
+ VSS VDD sky130_fd_sc_hs__clkbuf_4
Xsky130_fd_sc_hs__clkbuf_4_36 VDD VSS sky130_fd_sc_hs__buf_4_5/A sky130_fd_sc_hs__a22o_1_8/A2
+ VSS VDD sky130_fd_sc_hs__clkbuf_4
Xsky130_fd_sc_hs__clkbuf_8_1 VDD VSS sky130_fd_sc_hs__nand2_1_9/B sky130_fd_sc_hs__nor2_2_0/Y
+ VSS VDD sky130_fd_sc_hs__clkbuf_8
Xsky130_fd_sc_hs__clkbuf_4_47 VDD VSS sky130_fd_sc_hs__buf_4_4/X sky130_fd_sc_hs__a22oi_1_6/B1
+ VSS VDD sky130_fd_sc_hs__clkbuf_4
Xsky130_fd_sc_hs__a21oi_1_190 VDD VSS sky130_fd_sc_hs__o31ai_1_4/A1 sky130_fd_sc_hs__o21ai_1_94/B1
+ sky130_fd_sc_hs__xnor2_1_131/Y sky130_fd_sc_hs__o21a_1_31/X VSS VDD sky130_fd_sc_hs__a21oi_1
Xsky130_fd_sc_hs__mux2_1_308 VDD VSS sky130_fd_sc_hs__mux2_1_308/X sky130_fd_sc_hs__mux2_1_328/S
+ sky130_fd_sc_hs__mux2_1_308/A0 sky130_fd_sc_hs__mux2_1_477/A1 VSS VDD sky130_fd_sc_hs__mux2_1
Xsky130_fd_sc_hs__mux2_1_319 VDD VSS sky130_fd_sc_hs__mux2_1_319/X sky130_fd_sc_hs__buf_16_0/A
+ sky130_fd_sc_hs__xor2_1_52/B sky130_fd_sc_hs__a22o_1_67/B2 VSS VDD sky130_fd_sc_hs__mux2_1
Xsky130_fd_sc_hs__xor2_1_19 VDD VSS sky130_fd_sc_hs__maj3_1_7/A sky130_fd_sc_hs__maj3_1_7/B
+ sky130_fd_sc_hs__xor2_1_19/X VSS VDD sky130_fd_sc_hs__xor2_1
Xsky130_fd_sc_hs__nor3_1_10 VDD VSS sky130_fd_sc_hs__o21a_1_4/A2 sky130_fd_sc_hs__o21a_1_5/X
+ sky130_fd_sc_hs__nor3_1_11/Y sky130_fd_sc_hs__buf_8_2/X VSS VDD sky130_fd_sc_hs__nor3_1
Xsky130_fd_sc_hs__nor3_1_21 VDD VSS sky130_fd_sc_hs__nor3_1_21/Y sky130_fd_sc_hs__o21a_1_14/X
+ sky130_fd_sc_hs__nor3_1_21/B sky130_fd_sc_hs__buf_8_2/X VSS VDD sky130_fd_sc_hs__nor3_1
Xsky130_fd_sc_hs__nor3_1_32 VDD VSS sky130_fd_sc_hs__nor3_1_32/Y sky130_fd_sc_hs__nor3_1_41/B
+ sky130_fd_sc_hs__nor3_1_32/B sky130_fd_sc_hs__nor3_1_32/A VSS VDD sky130_fd_sc_hs__nor3_1
Xsky130_fd_sc_hs__nor3_1_43 VDD VSS sky130_fd_sc_hs__nor3_1_43/Y sky130_fd_sc_hs__nor3_1_43/C
+ sky130_fd_sc_hs__nor3_1_43/B sky130_fd_sc_hs__nor3_1_43/A VSS VDD sky130_fd_sc_hs__nor3_1
Xsky130_fd_sc_hs__nor3_1_54 VDD VSS sky130_fd_sc_hs__nor3_1_54/Y sky130_fd_sc_hs__nor3_1_54/C
+ sky130_fd_sc_hs__nor3_1_54/B sky130_fd_sc_hs__nor3_1_54/A VSS VDD sky130_fd_sc_hs__nor3_1
Xsky130_fd_sc_hs__dfrtp_1_101 sky130_fd_sc_hs__buf_8_0/A VDD VSS sky130_fd_sc_hs__maj3_1_2/B
+ sky130_fd_sc_hs__clkbuf_2_31/X sky130_fd_sc_hs__mux2_1_94/X VSS VDD sky130_fd_sc_hs__dfrtp_1
Xsky130_fd_sc_hs__dfrtp_1_112 sky130_fd_sc_hs__clkbuf_4_1/X VDD VSS sky130_fd_sc_hs__maj3_1_4/A
+ sky130_fd_sc_hs__clkbuf_2_35/X sky130_fd_sc_hs__a22o_1_15/X VSS VDD sky130_fd_sc_hs__dfrtp_1
Xsky130_fd_sc_hs__dfrtp_1_123 sky130_fd_sc_hs__buf_8_1/A VDD VSS sky130_fd_sc_hs__xor2_1_5/B
+ sky130_fd_sc_hs__clkinv_2_0/A sky130_fd_sc_hs__mux2_1_117/X VSS VDD sky130_fd_sc_hs__dfrtp_1
Xsky130_fd_sc_hs__dfrtp_1_134 sky130_fd_sc_hs__clkbuf_4_3/X VDD VSS sky130_fd_sc_hs__buf_1_23/A
+ sky130_fd_sc_hs__clkinv_1_32/A sky130_fd_sc_hs__mux2_1_124/X VSS VDD sky130_fd_sc_hs__dfrtp_1
Xsky130_fd_sc_hs__dfrtp_1_145 sky130_fd_sc_hs__clkbuf_4_10/X VDD VSS sky130_fd_sc_hs__mux2_1_134/A1
+ sky130_fd_sc_hs__clkinv_1_37/A sky130_fd_sc_hs__mux2_1_134/X VSS VDD sky130_fd_sc_hs__dfrtp_1
Xsky130_fd_sc_hs__dfrtp_1_156 sky130_fd_sc_hs__clkbuf_4_5/X VDD VSS sky130_fd_sc_hs__maj3_1_9/C
+ sky130_fd_sc_hs__clkinv_1_38/A sky130_fd_sc_hs__mux2_1_144/X VSS VDD sky130_fd_sc_hs__dfrtp_1
Xsky130_fd_sc_hs__dfrtp_1_167 sky130_fd_sc_hs__clkbuf_4_5/X VDD VSS sky130_fd_sc_hs__xor2_1_17/B
+ sky130_fd_sc_hs__clkbuf_2_55/X sky130_fd_sc_hs__mux2_1_152/X VSS VDD sky130_fd_sc_hs__dfrtp_1
Xsky130_fd_sc_hs__dfrtp_1_178 sky130_fd_sc_hs__clkbuf_16_5/X VDD VSS sky130_fd_sc_hs__buf_1_183/A
+ sky130_fd_sc_hs__clkbuf_2_62/X sky130_fd_sc_hs__mux2_1_167/X VSS VDD sky130_fd_sc_hs__dfrtp_1
Xsky130_fd_sc_hs__dfrtp_1_189 sky130_fd_sc_hs__clkbuf_4_5/X VDD VSS sky130_fd_sc_hs__mux2_1_149/A0
+ sky130_fd_sc_hs__clkinv_1_39/A sky130_fd_sc_hs__mux2_1_149/X VSS VDD sky130_fd_sc_hs__dfrtp_1
Xsky130_fd_sc_hs__buf_8_3 VDD VSS sky130_fd_sc_hs__buf_8_3/X sky130_fd_sc_hs__buf_8_3/A
+ VSS VDD sky130_fd_sc_hs__buf_8
Xsky130_fd_sc_hs__o21a_1_7 VDD VSS sky130_fd_sc_hs__o21a_1_7/X sky130_fd_sc_hs__o21a_1_7/A2
+ sky130_fd_sc_hs__xnor2_1_1/Y sky130_fd_sc_hs__o21a_1_7/A1 VSS VDD sky130_fd_sc_hs__o21a_1
Xsky130_fd_sc_hs__clkinv_1_140 VDD VSS sky130_fd_sc_hs__xnor2_1_124/B sky130_fd_sc_hs__maj3_1_68/C
+ VSS VDD sky130_fd_sc_hs__clkinv_1
Xsky130_fd_sc_hs__clkinv_1_151 VDD VSS sky130_fd_sc_hs__xnor2_1_133/Y sky130_fd_sc_hs__maj3_1_54/C
+ VSS VDD sky130_fd_sc_hs__clkinv_1
Xsky130_fd_sc_hs__clkinv_1_162 VDD VSS sky130_fd_sc_hs__nor3_1_44/B sky130_fd_sc_hs__nor2_1_177/A
+ VSS VDD sky130_fd_sc_hs__clkinv_1
Xsky130_fd_sc_hs__o311ai_1_14 VDD VSS sky130_fd_sc_hs__or2_1_17/A sky130_fd_sc_hs__or2_1_16/A
+ sky130_fd_sc_hs__and2_1_25/A sky130_fd_sc_hs__clkinv_1_78/Y sky130_fd_sc_hs__nand3_1_22/C
+ sky130_fd_sc_hs__or2_1_16/B VSS VDD sky130_fd_sc_hs__o311ai_1
Xsky130_fd_sc_hs__nor2_1_110 VDD VSS sky130_fd_sc_hs__buf_8_21/X sky130_fd_sc_hs__nor2_1_110/Y
+ sky130_fd_sc_hs__xor2_1_69/A VSS VDD sky130_fd_sc_hs__nor2_1
Xsky130_fd_sc_hs__nor2_1_121 VDD VSS sky130_fd_sc_hs__nor3_1_41/B sky130_fd_sc_hs__nor2_1_121/Y
+ sky130_fd_sc_hs__nor3_1_32/B VSS VDD sky130_fd_sc_hs__nor2_1
Xsky130_fd_sc_hs__dfrtp_1_690 sky130_fd_sc_hs__clkbuf_4_33/X VDD VSS sky130_fd_sc_hs__mux2_1_386/A0
+ sky130_fd_sc_hs__clkinv_1_158/A sky130_fd_sc_hs__mux2_1_386/X VSS VDD sky130_fd_sc_hs__dfrtp_1
Xsky130_fd_sc_hs__nor2_1_132 VDD VSS sky130_fd_sc_hs__nor2_1_132/B sky130_fd_sc_hs__nor2_1_132/Y
+ sky130_fd_sc_hs__nor3_1_36/B VSS VDD sky130_fd_sc_hs__nor2_1
Xsky130_fd_sc_hs__nor2_1_143 VDD VSS sky130_fd_sc_hs__nor2_1_146/B sky130_fd_sc_hs__nor2_1_143/Y
+ sky130_fd_sc_hs__nor3b_1_1/B VSS VDD sky130_fd_sc_hs__nor2_1
Xsky130_fd_sc_hs__nor2_1_154 VDD VSS sky130_fd_sc_hs__nor3_1_41/C sky130_fd_sc_hs__nor2_1_154/Y
+ sky130_fd_sc_hs__nor3_1_41/B VSS VDD sky130_fd_sc_hs__nor2_1
Xsky130_fd_sc_hs__a22oi_1_30 VDD VSS sky130_fd_sc_hs__mux2_1_79/A1 sky130_fd_sc_hs__nand2_1_14/A
+ sky130_fd_sc_hs__a22oi_1_6/A2 sky130_fd_sc_hs__a22o_1_8/A2 sky130_fd_sc_hs__mux2_1_63/A0
+ VSS VDD sky130_fd_sc_hs__a22oi_1
Xsky130_fd_sc_hs__nor2_1_165 VDD VSS sky130_fd_sc_hs__and2_1_39/B sky130_fd_sc_hs__or3_1_0/A
+ sky130_fd_sc_hs__or2_1_15/A VSS VDD sky130_fd_sc_hs__nor2_1
Xsky130_fd_sc_hs__clkinv_1_8 VDD VSS sky130_fd_sc_hs__clkinv_1_8/A sky130_fd_sc_hs__clkinv_1_8/Y
+ VSS VDD sky130_fd_sc_hs__clkinv_1
Xsky130_fd_sc_hs__a22oi_1_41 VDD VSS sky130_fd_sc_hs__mux2_1_178/A1 sky130_fd_sc_hs__and4_1_2/B
+ sky130_fd_sc_hs__a222o_1_3/C2 sky130_fd_sc_hs__a22o_1_9/A2 sky130_fd_sc_hs__mux2_1_128/A1
+ VSS VDD sky130_fd_sc_hs__a22oi_1
Xsky130_fd_sc_hs__nor2_1_176 VDD VSS sky130_fd_sc_hs__or3b_1_0/A sky130_fd_sc_hs__nor2_1_176/Y
+ sky130_fd_sc_hs__or2_1_29/A VSS VDD sky130_fd_sc_hs__nor2_1
Xsky130_fd_sc_hs__a22oi_1_52 VDD VSS sky130_fd_sc_hs__mux2_1_482/A0 sky130_fd_sc_hs__and4_1_3/A
+ sky130_fd_sc_hs__a22oi_1_7/B1 sky130_fd_sc_hs__nand2_1_33/B sky130_fd_sc_hs__mux2_1_486/A0
+ VSS VDD sky130_fd_sc_hs__a22oi_1
Xsky130_fd_sc_hs__a22oi_1_63 VDD VSS sky130_fd_sc_hs__nor2_1_147/A sky130_fd_sc_hs__a22oi_1_63/Y
+ sky130_fd_sc_hs__nor2b_1_51/Y sky130_fd_sc_hs__nor2_1_176/Y sky130_fd_sc_hs__o22a_1_0/A1
+ VSS VDD sky130_fd_sc_hs__a22oi_1
Xsky130_fd_sc_hs__a22oi_1_74 VDD VSS sky130_fd_sc_hs__mux2_1_463/A0 sky130_fd_sc_hs__a22oi_1_74/Y
+ sky130_fd_sc_hs__a22oi_1_5/A2 sky130_fd_sc_hs__a22oi_1_6/A2 sky130_fd_sc_hs__mux2_1_272/A1
+ VSS VDD sky130_fd_sc_hs__a22oi_1
Xsky130_fd_sc_hs__a22oi_1_85 VDD VSS sky130_fd_sc_hs__xor2_1_56/A sky130_fd_sc_hs__a22oi_1_85/Y
+ sky130_fd_sc_hs__a22o_1_8/B1 sky130_fd_sc_hs__a22o_1_8/A2 sky130_fd_sc_hs__mux2_1_481/A0
+ VSS VDD sky130_fd_sc_hs__a22oi_1
Xsky130_fd_sc_hs__a22oi_1_96 VDD VSS sky130_fd_sc_hs__mux2_1_361/A1 sky130_fd_sc_hs__nand3_1_37/A
+ sky130_fd_sc_hs__buf_16_9/X sky130_fd_sc_hs__a22oi_1_7/B1 sky130_fd_sc_hs__mux2_1_365/A0
+ VSS VDD sky130_fd_sc_hs__a22oi_1
Xsky130_fd_sc_hs__mux2_1_105 VDD VSS sky130_fd_sc_hs__mux2_1_105/X sky130_fd_sc_hs__buf_16_1/X
+ sky130_fd_sc_hs__mux2_1_105/A0 sky130_fd_sc_hs__mux2_1_98/A1 VSS VDD sky130_fd_sc_hs__mux2_1
Xsky130_fd_sc_hs__mux2_1_116 VDD VSS sky130_fd_sc_hs__mux2_1_116/X sky130_fd_sc_hs__buf_16_0/X
+ sky130_fd_sc_hs__xor2_1_4/B sky130_fd_sc_hs__a22o_1_40/B2 VSS VDD sky130_fd_sc_hs__mux2_1
Xsky130_fd_sc_hs__mux2_1_127 VDD VSS sky130_fd_sc_hs__mux2_1_127/X sky130_fd_sc_hs__buf_16_5/X
+ sky130_fd_sc_hs__mux2_1_127/A0 sky130_fd_sc_hs__a22o_1_60/B2 VSS VDD sky130_fd_sc_hs__mux2_1
Xsky130_fd_sc_hs__mux2_1_138 VDD VSS sky130_fd_sc_hs__mux2_1_138/X sky130_fd_sc_hs__buf_16_0/X
+ sky130_fd_sc_hs__xnor2_1_27/A sky130_fd_sc_hs__mux2_1_40/A0 VSS VDD sky130_fd_sc_hs__mux2_1
Xsky130_fd_sc_hs__mux2_1_149 VDD VSS sky130_fd_sc_hs__mux2_1_149/X sky130_fd_sc_hs__buf_16_5/X
+ sky130_fd_sc_hs__mux2_1_149/A0 sky130_fd_sc_hs__a22o_1_40/B2 VSS VDD sky130_fd_sc_hs__mux2_1
Xsky130_fd_sc_hs__or3_1_6 VDD VSS sky130_fd_sc_hs__or3_1_6/A sky130_fd_sc_hs__or3_1_6/B
+ sky130_fd_sc_hs__or3_1_6/C sky130_fd_sc_hs__or3_1_6/X VSS VDD sky130_fd_sc_hs__or3_1
Xsky130_fd_sc_hs__a31o_1_1 VDD VSS sky130_fd_sc_hs__a31o_1_1/X sky130_fd_sc_hs__a31o_1_1/A3
+ sky130_fd_sc_hs__xor2_1_7/A sky130_fd_sc_hs__a31o_1_1/A1 sky130_fd_sc_hs__nor2b_1_2/Y
+ VSS VDD sky130_fd_sc_hs__a31o_1
Xsky130_fd_sc_hs__buf_1_108 VDD VSS sky130_fd_sc_hs__buf_1_108/A dac_n_force[2] VSS
+ VDD sky130_fd_sc_hs__buf_1
Xsky130_fd_sc_hs__buf_1_119 VDD VSS sky130_fd_sc_hs__o22ai_1_9/Y dac_p_force[10] VSS
+ VDD sky130_fd_sc_hs__buf_1
Xsky130_fd_sc_hs__o21a_1_11 VDD VSS sky130_fd_sc_hs__o21a_1_11/X sky130_fd_sc_hs__xor2_1_8/X
+ sky130_fd_sc_hs__o21a_1_11/B1 sky130_fd_sc_hs__o21a_1_8/X VSS VDD sky130_fd_sc_hs__o21a_1
Xsky130_fd_sc_hs__o21a_1_22 VDD VSS sky130_fd_sc_hs__or2_1_20/A sky130_fd_sc_hs__xor2_1_73/X
+ sky130_fd_sc_hs__o21a_1_22/B1 sky130_fd_sc_hs__maj3_1_43/X VSS VDD sky130_fd_sc_hs__o21a_1
Xsky130_fd_sc_hs__clkbuf_2_205 VDD VSS sky130_fd_sc_hs__clkinv_1_155/A sky130_fd_sc_hs__clkinv_2_11/A
+ VSS VDD sky130_fd_sc_hs__clkbuf_2
Xsky130_fd_sc_hs__clkbuf_2_216 VDD VSS sky130_fd_sc_hs__clkbuf_2_216/X sky130_fd_sc_hs__clkbuf_8_17/A
+ VSS VDD sky130_fd_sc_hs__clkbuf_2
Xsky130_fd_sc_hs__clkbuf_2_227 VDD VSS sky130_fd_sc_hs__buf_8_2/A sky130_fd_sc_hs__buf_1_96/A
+ VSS VDD sky130_fd_sc_hs__clkbuf_2
Xsky130_fd_sc_hs__nand2_1_205 VDD VSS sky130_fd_sc_hs__nand2_1_205/B sky130_fd_sc_hs__nand2_1_205/Y
+ sky130_fd_sc_hs__a22oi_1_94/Y VSS VDD sky130_fd_sc_hs__nand2_1
Xsky130_fd_sc_hs__clkbuf_2_238 VDD VSS sky130_fd_sc_hs__dfrtp_2_1/CLK sky130_fd_sc_hs__clkinv_4_6/A
+ VSS VDD sky130_fd_sc_hs__clkbuf_2
Xsky130_fd_sc_hs__nand2_1_216 VDD VSS sky130_fd_sc_hs__nor2_1_177/Y sky130_fd_sc_hs__nand2_1_216/Y
+ sky130_fd_sc_hs__nor2b_1_48/Y VSS VDD sky130_fd_sc_hs__nand2_1
Xsky130_fd_sc_hs__nand2_1_227 VDD VSS sky130_fd_sc_hs__a22o_1_8/B1 sky130_fd_sc_hs__nand4_1_15/A
+ sky130_fd_sc_hs__nor2_1_183/A VSS VDD sky130_fd_sc_hs__nand2_1
Xsky130_fd_sc_hs__nand2_1_238 VDD VSS sky130_fd_sc_hs__nor2b_1_50/Y sky130_fd_sc_hs__o22ai_1_14/B1
+ sky130_fd_sc_hs__nor3_1_34/Y VSS VDD sky130_fd_sc_hs__nand2_1
Xsky130_fd_sc_hs__and2_1_12 VDD VSS sky130_fd_sc_hs__maj3_1_9/A sky130_fd_sc_hs__nor2_1_31/B
+ sky130_fd_sc_hs__o21a_1_7/A1 VSS VDD sky130_fd_sc_hs__and2_1
Xsky130_fd_sc_hs__and2_1_23 VDD VSS sky130_fd_sc_hs__nor2_1_77/A sky130_fd_sc_hs__xor2_1_54/A
+ sky130_fd_sc_hs__or2_1_14/A VSS VDD sky130_fd_sc_hs__and2_1
Xsky130_fd_sc_hs__and2_1_34 VDD VSS sky130_fd_sc_hs__and2_1_34/A sky130_fd_sc_hs__and2_1_34/B
+ sky130_fd_sc_hs__or2_1_22/A VSS VDD sky130_fd_sc_hs__and2_1
Xsky130_fd_sc_hs__and2_1_45 VDD VSS sky130_fd_sc_hs__maj3_1_56/A sky130_fd_sc_hs__and2_1_45/B
+ sky130_fd_sc_hs__and2_1_45/X VSS VDD sky130_fd_sc_hs__and2_1
Xsky130_fd_sc_hs__mux2_1_480 VDD VSS sky130_fd_sc_hs__mux2_1_480/X sky130_fd_sc_hs__mux2_1_8/S
+ sky130_fd_sc_hs__mux2_1_480/A0 sky130_fd_sc_hs__mux2_1_98/A1 VSS VDD sky130_fd_sc_hs__mux2_1
Xsky130_fd_sc_hs__o2bb2ai_1_19 VDD VSS sky130_fd_sc_hs__dfrtp_1_392/D sky130_fd_sc_hs__a31o_1_10/X
+ sky130_fd_sc_hs__maj3_1_22/C sky130_fd_sc_hs__a21oi_1_71/Y sky130_fd_sc_hs__a32o_1_7/B1
+ VSS VDD sky130_fd_sc_hs__o2bb2ai_1
Xsky130_fd_sc_hs__nand3_1_14 VDD VSS sky130_fd_sc_hs__xnor2_1_38/Y sky130_fd_sc_hs__nand3_1_14/Y
+ sky130_fd_sc_hs__nand3b_1_1/Y sky130_fd_sc_hs__nand3b_1_1/C VSS VDD sky130_fd_sc_hs__nand3_1
Xsky130_fd_sc_hs__nand3_1_25 VDD VSS sky130_fd_sc_hs__nand4_1_7/D sky130_fd_sc_hs__mux2i_1_0/S
+ sky130_fd_sc_hs__nor2_1_136/Y sky130_fd_sc_hs__nor3_1_37/C VSS VDD sky130_fd_sc_hs__nand3_1
Xsky130_fd_sc_hs__nand3_1_36 VDD VSS sky130_fd_sc_hs__nand3_1_36/C sky130_fd_sc_hs__and2_1_39/B
+ sky130_fd_sc_hs__nand3_1_36/B sky130_fd_sc_hs__o2111a_1_0/X VSS VDD sky130_fd_sc_hs__nand3_1
Xsky130_fd_sc_hs__o211a_2_0 VDD VSS sky130_fd_sc_hs__o21a_1_6/A2 sky130_fd_sc_hs__nor2_1_33/Y
+ sky130_fd_sc_hs__a21o_1_0/X sky130_fd_sc_hs__o21a_1_6/B1 sky130_fd_sc_hs__o21a_1_7/A2
+ VSS VDD sky130_fd_sc_hs__o211a_2
Xsky130_fd_sc_hs__o2bb2ai_1_6 VDD VSS sky130_fd_sc_hs__o2bb2ai_1_6/Y sky130_fd_sc_hs__o31ai_1_5/Y
+ sky130_fd_sc_hs__xor2_1_9/A sky130_fd_sc_hs__o21a_1_7/X sky130_fd_sc_hs__a32o_1_2/B1
+ VSS VDD sky130_fd_sc_hs__o2bb2ai_1
Xsky130_fd_sc_hs__mux2i_1_11 VDD VSS sky130_fd_sc_hs__mux2i_1_11/S sky130_fd_sc_hs__o32ai_1_0/A1
+ sky130_fd_sc_hs__or2_1_22/B sky130_fd_sc_hs__mux2i_1_11/Y VSS VDD sky130_fd_sc_hs__mux2i_1
Xsky130_fd_sc_hs__buf_1_11 VDD VSS sky130_fd_sc_hs__buf_1_11/A srm_residue_o[1] VSS
+ VDD sky130_fd_sc_hs__buf_1
Xsky130_fd_sc_hs__buf_1_22 VDD VSS sky130_fd_sc_hs__buf_8_36/X sky130_fd_sc_hs__buf_1_22/X
+ VSS VDD sky130_fd_sc_hs__buf_1
Xsky130_fd_sc_hs__buf_1_33 VDD VSS sky130_fd_sc_hs__buf_1_33/A raw_code_o[13] VSS
+ VDD sky130_fd_sc_hs__buf_1
Xsky130_fd_sc_hs__buf_1_44 VDD VSS sky130_fd_sc_hs__buf_1_44/A w_wr_data[10] VSS VDD
+ sky130_fd_sc_hs__buf_1
Xsky130_fd_sc_hs__buf_1_55 VDD VSS sky130_fd_sc_hs__buf_1_55/A calib_overrange_bits[4]
+ VSS VDD sky130_fd_sc_hs__buf_1
Xsky130_fd_sc_hs__buf_1_66 VDD VSS srm_decision_bit sky130_fd_sc_hs__buf_1_66/X VSS
+ VDD sky130_fd_sc_hs__buf_1
Xsky130_fd_sc_hs__buf_1_77 VDD VSS sky130_fd_sc_hs__buf_1_77/A sky130_fd_sc_hs__buf_1_77/X
+ VSS VDD sky130_fd_sc_hs__buf_1
Xsky130_fd_sc_hs__buf_1_88 VDD VSS sky130_fd_sc_hs__buf_1_88/A sky130_fd_sc_hs__buf_1_88/X
+ VSS VDD sky130_fd_sc_hs__buf_1
Xsky130_fd_sc_hs__buf_1_99 VDD VSS sky130_fd_sc_hs__buf_1_99/A dac_p_force[12] VSS
+ VDD sky130_fd_sc_hs__buf_1
Xsky130_fd_sc_hs__a22o_1_80 VDD VSS sky130_fd_sc_hs__a22o_1_80/X sky130_fd_sc_hs__a31oi_1_8/Y
+ sky130_fd_sc_hs__a21o_1_8/X sky130_fd_sc_hs__a32o_1_7/B1 sky130_fd_sc_hs__xnor2_1_85/A
+ VSS VDD sky130_fd_sc_hs__a22o_1
Xsky130_fd_sc_hs__a22o_1_91 VDD VSS sky130_fd_sc_hs__a22o_1_91/X sky130_fd_sc_hs__a22o_1_91/B2
+ sky130_fd_sc_hs__buf_8_17/A sky130_fd_sc_hs__buf_8_15/A sky130_fd_sc_hs__a22o_1_91/A1
+ VSS VDD sky130_fd_sc_hs__a22o_1
Xsky130_fd_sc_hs__a21o_1_0 VDD VSS sky130_fd_sc_hs__a21o_1_0/X sky130_fd_sc_hs__maj3_1_7/A
+ sky130_fd_sc_hs__a21o_1_0/B1 sky130_fd_sc_hs__xor2_1_20/B VSS VDD sky130_fd_sc_hs__a21o_1
Xsky130_fd_sc_hs__clkbuf_2_80 VDD VSS sky130_fd_sc_hs__clkbuf_2_80/X sky130_fd_sc_hs__clkbuf_2_92/A
+ VSS VDD sky130_fd_sc_hs__clkbuf_2
Xsky130_fd_sc_hs__clkbuf_2_91 VDD VSS sky130_fd_sc_hs__clkinv_2_6/A sky130_fd_sc_hs__clkbuf_2_92/A
+ VSS VDD sky130_fd_sc_hs__clkbuf_2
Xsky130_fd_sc_hs__maj3_1_20 VDD VSS sky130_fd_sc_hs__and2_1_6/A sky130_fd_sc_hs__xor2_1_35/A
+ sky130_fd_sc_hs__maj3_1_20/X sky130_fd_sc_hs__xor2_1_35/B VSS VDD sky130_fd_sc_hs__maj3_1
Xsky130_fd_sc_hs__maj3_1_31 VDD VSS sky130_fd_sc_hs__xor2_1_60/A sky130_fd_sc_hs__xor2_1_60/B
+ sky130_fd_sc_hs__xor2_1_58/A sky130_fd_sc_hs__maj3_1_31/C VSS VDD sky130_fd_sc_hs__maj3_1
Xsky130_fd_sc_hs__maj3_1_42 VDD VSS sky130_fd_sc_hs__maj3_1_42/A sky130_fd_sc_hs__maj3_1_46/X
+ sky130_fd_sc_hs__or2_1_19/A sky130_fd_sc_hs__maj3_1_42/C VSS VDD sky130_fd_sc_hs__maj3_1
Xsky130_fd_sc_hs__maj3_1_53 VDD VSS sky130_fd_sc_hs__maj3_1_54/X sky130_fd_sc_hs__maj3_1_55/X
+ sky130_fd_sc_hs__maj3_1_64/A sky130_fd_sc_hs__maj3_1_53/C VSS VDD sky130_fd_sc_hs__maj3_1
Xsky130_fd_sc_hs__maj3_1_64 VDD VSS sky130_fd_sc_hs__maj3_1_64/A sky130_fd_sc_hs__maj3_1_64/B
+ sky130_fd_sc_hs__maj3_1_64/X sky130_fd_sc_hs__maj3_1_64/C VSS VDD sky130_fd_sc_hs__maj3_1
Xsky130_fd_sc_hs__o21bai_1_3 VDD VSS sky130_fd_sc_hs__nor2_1_48/A sky130_fd_sc_hs__o21bai_1_3/Y
+ sky130_fd_sc_hs__nand3_1_20/Y sky130_fd_sc_hs__nor4b_1_0/Y VSS VDD sky130_fd_sc_hs__o21bai_1
Xsky130_fd_sc_hs__nor2b_1_9 VDD VSS sky130_fd_sc_hs__nand3_1_14/Y sky130_fd_sc_hs__nor2b_1_9/Y
+ sky130_fd_sc_hs__nor2b_1_9/A VSS VDD sky130_fd_sc_hs__nor2b_1
Xsky130_fd_sc_hs__nand2_1_80 VDD VSS sky130_fd_sc_hs__or2_1_12/B sky130_fd_sc_hs__a21o_1_3/A1
+ sky130_fd_sc_hs__or2_1_12/A VSS VDD sky130_fd_sc_hs__nand2_1
Xsky130_fd_sc_hs__a222oi_1_10 VDD VSS sky130_fd_sc_hs__a22o_1_9/A2 sky130_fd_sc_hs__mux2_1_190/A1
+ sky130_fd_sc_hs__a22oi_1_6/B1 sky130_fd_sc_hs__a22oi_1_5/A2 sky130_fd_sc_hs__mux2_1_195/A0
+ sky130_fd_sc_hs__nand3_1_7/A sky130_fd_sc_hs__xor2_1_35/B VSS VDD sky130_fd_sc_hs__a222oi_1
Xsky130_fd_sc_hs__nand2_1_91 VDD VSS sky130_fd_sc_hs__and2_1_19/A sky130_fd_sc_hs__xor2_1_49/B
+ sky130_fd_sc_hs__nand2_1_91/A VSS VDD sky130_fd_sc_hs__nand2_1
Xsky130_fd_sc_hs__a222oi_1_21 VDD VSS sky130_fd_sc_hs__mux2_1_470/A1 sky130_fd_sc_hs__nand2_1_200/B
+ sky130_fd_sc_hs__a22oi_1_7/B1 sky130_fd_sc_hs__clkbuf_8_15/X sky130_fd_sc_hs__mux2_1_357/A0
+ sky130_fd_sc_hs__nand2_1_213/B sky130_fd_sc_hs__mux2_1_358/A0 VSS VDD sky130_fd_sc_hs__a222oi_1
Xsky130_fd_sc_hs__o31ai_1_13 VDD VSS sky130_fd_sc_hs__o31ai_1_13/A3 sky130_fd_sc_hs__and2_1_32/B
+ sky130_fd_sc_hs__o31ai_1_13/B1 sky130_fd_sc_hs__nor2_4_3/A sky130_fd_sc_hs__o31ai_1_13/Y
+ VSS VDD sky130_fd_sc_hs__o31ai_1
Xsky130_fd_sc_hs__nor2_1_7 VDD VSS sky130_fd_sc_hs__xor2_1_0/X sky130_fd_sc_hs__nor3_1_3/C
+ sky130_fd_sc_hs__nor2_1_7/A VSS VDD sky130_fd_sc_hs__nor2_1
Xsky130_fd_sc_hs__clkbuf_16_4 VDD VSS sky130_fd_sc_hs__inv_8_0/A sky130_fd_sc_hs__clkbuf_8_19/X
+ VSS VDD sky130_fd_sc_hs__clkbuf_16
Xsky130_fd_sc_hs__dfrtp_1_508 sky130_fd_sc_hs__clkbuf_4_22/A VDD VSS sky130_fd_sc_hs__maj3_1_46/C
+ sky130_fd_sc_hs__clkbuf_2_142/X sky130_fd_sc_hs__a22o_1_102/X VSS VDD sky130_fd_sc_hs__dfrtp_1
Xsky130_fd_sc_hs__dfrtp_1_519 sky130_fd_sc_hs__clkbuf_4_22/X VDD VSS sky130_fd_sc_hs__xor2_1_69/A
+ sky130_fd_sc_hs__clkinv_1_98/A sky130_fd_sc_hs__dfrtp_1_519/D VSS VDD sky130_fd_sc_hs__dfrtp_1
Xsky130_fd_sc_hs__nor3_4_10 VDD VSS sky130_fd_sc_hs__or3b_1_0/B sky130_fd_sc_hs__nor3_4_8/B
+ sky130_fd_sc_hs__nor3_4_9/C sky130_fd_sc_hs__buf_4_7/A VSS VDD sky130_fd_sc_hs__nor3_4
Xsky130_fd_sc_hs__a21oi_1_15 VDD VSS sky130_fd_sc_hs__a21oi_1_40/Y sky130_fd_sc_hs__nor2_1_63/B
+ sky130_fd_sc_hs__xnor2_1_20/Y sky130_fd_sc_hs__o21ai_1_7/B1 VSS VDD sky130_fd_sc_hs__a21oi_1
Xsky130_fd_sc_hs__a21oi_1_26 VDD VSS sky130_fd_sc_hs__o21ai_1_8/Y sky130_fd_sc_hs__o21ai_1_5/A1
+ sky130_fd_sc_hs__xnor2_1_15/Y sky130_fd_sc_hs__buf_8_10/X VSS VDD sky130_fd_sc_hs__a21oi_1
Xsky130_fd_sc_hs__a21oi_1_37 VDD VSS sky130_fd_sc_hs__o31ai_1_4/A1 sky130_fd_sc_hs__a21oi_1_37/Y
+ sky130_fd_sc_hs__nor2b_1_5/Y sky130_fd_sc_hs__nand2_1_45/Y VSS VDD sky130_fd_sc_hs__a21oi_1
Xsky130_fd_sc_hs__a21oi_1_48 VDD VSS sky130_fd_sc_hs__nor2_1_37/Y sky130_fd_sc_hs__a21oi_1_48/Y
+ sky130_fd_sc_hs__buf_8_3/A sky130_fd_sc_hs__nand4_1_9/C VSS VDD sky130_fd_sc_hs__a21oi_1
Xsky130_fd_sc_hs__a21oi_1_59 VDD VSS sky130_fd_sc_hs__o31ai_1_6/A1 sky130_fd_sc_hs__a21oi_1_59/Y
+ sky130_fd_sc_hs__or2_1_10/X sky130_fd_sc_hs__o21a_1_16/A1 VSS VDD sky130_fd_sc_hs__a21oi_1
Xsky130_fd_sc_hs__dfrtp_1_13 sky130_fd_sc_hs__clkbuf_4_4/A VDD VSS sky130_fd_sc_hs__maj3_1_0/B
+ sky130_fd_sc_hs__clkinv_1_2/A sky130_fd_sc_hs__mux2_1_14/X VSS VDD sky130_fd_sc_hs__dfrtp_1
Xsky130_fd_sc_hs__a22oi_1_101 VDD VSS sky130_fd_sc_hs__mux2_1_407/A1 sky130_fd_sc_hs__nand4_1_14/D
+ sky130_fd_sc_hs__a22o_1_9/A2 sky130_fd_sc_hs__nand2_1_33/B sky130_fd_sc_hs__mux2_1_406/A0
+ VSS VDD sky130_fd_sc_hs__a22oi_1
Xsky130_fd_sc_hs__dfrtp_1_24 sky130_fd_sc_hs__clkbuf_4_3/X VDD VSS sky130_fd_sc_hs__mux2_1_26/A0
+ sky130_fd_sc_hs__clkbuf_2_12/X sky130_fd_sc_hs__mux2_1_26/X VSS VDD sky130_fd_sc_hs__dfrtp_1
Xsky130_fd_sc_hs__a22oi_1_112 VDD VSS sky130_fd_sc_hs__mux2_1_449/A1 sky130_fd_sc_hs__nand4_1_15/D
+ sky130_fd_sc_hs__buf_16_9/X sky130_fd_sc_hs__buf_16_7/X sky130_fd_sc_hs__mux2_1_448/A0
+ VSS VDD sky130_fd_sc_hs__a22oi_1
Xsky130_fd_sc_hs__dfrtp_1_35 sky130_fd_sc_hs__clkbuf_4_3/X VDD VSS sky130_fd_sc_hs__mux2_1_30/A1
+ sky130_fd_sc_hs__clkbuf_2_8/X sky130_fd_sc_hs__mux2_1_30/X VSS VDD sky130_fd_sc_hs__dfrtp_1
Xsky130_fd_sc_hs__dfrtp_1_46 sky130_fd_sc_hs__clkbuf_4_0/X VDD VSS sky130_fd_sc_hs__mux2_1_43/A1
+ sky130_fd_sc_hs__clkbuf_2_14/X sky130_fd_sc_hs__mux2_1_43/X VSS VDD sky130_fd_sc_hs__dfrtp_1
Xsky130_fd_sc_hs__dfrtp_1_57 sky130_fd_sc_hs__buf_8_38/X VDD VSS sky130_fd_sc_hs__mux2_1_56/A0
+ sky130_fd_sc_hs__clkinv_1_9/A sky130_fd_sc_hs__mux2_1_56/X VSS VDD sky130_fd_sc_hs__dfrtp_1
Xsky130_fd_sc_hs__dfrtp_1_68 sky130_fd_sc_hs__clkbuf_4_0/X VDD VSS sky130_fd_sc_hs__mux2_1_66/A0
+ sky130_fd_sc_hs__clkbuf_2_25/X sky130_fd_sc_hs__mux2_1_66/X VSS VDD sky130_fd_sc_hs__dfrtp_1
Xsky130_fd_sc_hs__dfrtp_1_79 sky130_fd_sc_hs__buf_8_0/X VDD VSS sky130_fd_sc_hs__mux2_1_70/A1
+ sky130_fd_sc_hs__clkinv_1_11/A sky130_fd_sc_hs__mux2_1_70/X VSS VDD sky130_fd_sc_hs__dfrtp_1
Xsky130_fd_sc_hs__a311o_1_0 VDD VSS sky130_fd_sc_hs__a311o_1_0/X sky130_fd_sc_hs__or2_1_0/X
+ sky130_fd_sc_hs__nor3_1_4/B sky130_fd_sc_hs__nor3_1_3/C sky130_fd_sc_hs__nor2_1_2/B
+ sky130_fd_sc_hs__nor3_1_4/A VSS VDD sky130_fd_sc_hs__a311o_1
Xsky130_fd_sc_hs__a22o_1_103 VDD VSS sky130_fd_sc_hs__buf_1_114/A sky130_fd_sc_hs__nor2_1_148/Y
+ sky130_fd_sc_hs__nand2_1_125/Y sky130_fd_sc_hs__buf_8_20/X sky130_fd_sc_hs__nor3_1_41/A
+ VSS VDD sky130_fd_sc_hs__a22o_1
Xsky130_fd_sc_hs__a22o_1_114 VDD VSS sky130_fd_sc_hs__a22o_1_114/X sky130_fd_sc_hs__nor3_1_48/A
+ sky130_fd_sc_hs__buf_8_16/X sky130_fd_sc_hs__buf_8_18/X sky130_fd_sc_hs__or2_1_21/A
+ VSS VDD sky130_fd_sc_hs__a22o_1
Xsky130_fd_sc_hs__a22o_1_125 VDD VSS sky130_fd_sc_hs__a22o_1_125/X sky130_fd_sc_hs__xnor2_1_127/Y
+ sky130_fd_sc_hs__buf_8_26/X sky130_fd_sc_hs__o31ai_4_0/Y sky130_fd_sc_hs__maj3_1_52/A
+ VSS VDD sky130_fd_sc_hs__a22o_1
Xsky130_fd_sc_hs__a22o_1_136 VDD VSS sky130_fd_sc_hs__nor3_1_54/B sky130_fd_sc_hs__mux2_1_471/A1
+ sky130_fd_sc_hs__buf_16_8/X sky130_fd_sc_hs__a22o_1_8/B1 sky130_fd_sc_hs__xor2_1_86/B
+ VSS VDD sky130_fd_sc_hs__a22o_1
Xsky130_fd_sc_hs__nor3_4_5 VDD VSS sky130_fd_sc_hs__or3b_1_0/B sky130_fd_sc_hs__nor3_4_6/C
+ sky130_fd_sc_hs__nor3_4_9/C sky130_fd_sc_hs__nor3_4_5/Y VSS VDD sky130_fd_sc_hs__nor3_4
Xsky130_fd_sc_hs__dfstp_1_0 sky130_fd_sc_hs__buf_8_4/X VDD VSS sky130_fd_sc_hs__nor2_1_41/A
+ sky130_fd_sc_hs__nor2_1_46/Y sky130_fd_sc_hs__dfstp_1_0/CLK VSS VDD sky130_fd_sc_hs__dfstp_1
Xsky130_fd_sc_hs__o21ai_1_70 VDD VSS sky130_fd_sc_hs__o21ai_1_70/Y sky130_fd_sc_hs__buf_1_48/A
+ sky130_fd_sc_hs__o31a_1_5/X sky130_fd_sc_hs__nor2_1_161/Y VSS VDD sky130_fd_sc_hs__o21ai_1
Xsky130_fd_sc_hs__o21ai_1_81 VDD VSS sky130_fd_sc_hs__o21ai_1_81/Y sky130_fd_sc_hs__buf_4_6/X
+ sky130_fd_sc_hs__nor2_1_162/Y sky130_fd_sc_hs__or3_1_6/A VSS VDD sky130_fd_sc_hs__o21ai_1
Xsky130_fd_sc_hs__dfrtp_1_305 sky130_fd_sc_hs__clkbuf_4_13/X VDD VSS sky130_fd_sc_hs__buf_1_40/A
+ sky130_fd_sc_hs__clkinv_1_56/A sky130_fd_sc_hs__buf_1_78/X VSS VDD sky130_fd_sc_hs__dfrtp_1
Xsky130_fd_sc_hs__o21ai_1_92 VDD VSS sky130_fd_sc_hs__o21ai_1_92/Y sky130_fd_sc_hs__buf_8_37/X
+ sky130_fd_sc_hs__buf_8_36/X sky130_fd_sc_hs__xor2_1_88/A VSS VDD sky130_fd_sc_hs__o21ai_1
Xsky130_fd_sc_hs__dfrtp_1_316 sky130_fd_sc_hs__clkbuf_4_13/X VDD VSS sky130_fd_sc_hs__buf_1_45/A
+ sky130_fd_sc_hs__clkbuf_2_84/X sky130_fd_sc_hs__buf_1_68/X VSS VDD sky130_fd_sc_hs__dfrtp_1
Xsky130_fd_sc_hs__dfrtp_1_327 sky130_fd_sc_hs__buf_8_8/A VDD VSS sky130_fd_sc_hs__mux2_1_214/A0
+ sky130_fd_sc_hs__clkinv_1_60/A sky130_fd_sc_hs__mux2_1_214/X VSS VDD sky130_fd_sc_hs__dfrtp_1
Xsky130_fd_sc_hs__dfrtp_1_338 sky130_fd_sc_hs__clkbuf_4_15/X VDD VSS sky130_fd_sc_hs__xor2_1_34/A
+ sky130_fd_sc_hs__clkbuf_2_93/X sky130_fd_sc_hs__mux2_1_210/X VSS VDD sky130_fd_sc_hs__dfrtp_1
Xsky130_fd_sc_hs__dfrtp_1_349 sky130_fd_sc_hs__clkbuf_4_14/X VDD VSS sky130_fd_sc_hs__maj3_1_23/C
+ sky130_fd_sc_hs__clkbuf_2_95/X sky130_fd_sc_hs__a22o_1_49/X VSS VDD sky130_fd_sc_hs__dfrtp_1
Xsky130_fd_sc_hs__buf_16_0 sky130_fd_sc_hs__buf_16_0/X VDD VSS sky130_fd_sc_hs__buf_16_0/A
+ VSS VDD sky130_fd_sc_hs__buf_16
Xsky130_fd_sc_hs__and2_1_6 VDD VSS sky130_fd_sc_hs__and2_1_6/A sky130_fd_sc_hs__and2_1_6/B
+ sky130_fd_sc_hs__and2_1_6/X VSS VDD sky130_fd_sc_hs__and2_1
Xsky130_fd_sc_hs__clkbuf_4_15 VDD VSS sky130_fd_sc_hs__buf_8_9/X sky130_fd_sc_hs__clkbuf_4_15/X
+ VSS VDD sky130_fd_sc_hs__clkbuf_4
Xsky130_fd_sc_hs__clkbuf_4_26 VDD VSS sky130_fd_sc_hs__or3_1_6/X sky130_fd_sc_hs__buf_16_16/A
+ VSS VDD sky130_fd_sc_hs__clkbuf_4
Xsky130_fd_sc_hs__clkbuf_4_37 VDD VSS sky130_fd_sc_hs__nor2_2_9/Y sky130_fd_sc_hs__nand2_1_51/B
+ VSS VDD sky130_fd_sc_hs__clkbuf_4
Xsky130_fd_sc_hs__clkbuf_4_48 VDD VSS sky130_fd_sc_hs__nor2_2_4/Y sky130_fd_sc_hs__buf_16_12/A
+ VSS VDD sky130_fd_sc_hs__clkbuf_4
Xsky130_fd_sc_hs__clkbuf_8_2 VDD VSS sky130_fd_sc_hs__clkbuf_8_2/X sky130_fd_sc_hs__clkbuf_8_4/A
+ VSS VDD sky130_fd_sc_hs__clkbuf_8
Xsky130_fd_sc_hs__a21oi_1_180 VDD VSS sky130_fd_sc_hs__o31ai_1_4/A1 sky130_fd_sc_hs__a22o_1_120/B2
+ sky130_fd_sc_hs__or2_1_28/B sky130_fd_sc_hs__or2_1_28/A VSS VDD sky130_fd_sc_hs__a21oi_1
Xsky130_fd_sc_hs__a21oi_1_191 VDD VSS sky130_fd_sc_hs__nor2_4_3/A sky130_fd_sc_hs__mux2_1_250/A1
+ sky130_fd_sc_hs__o211ai_1_15/Y sky130_fd_sc_hs__o21ai_1_102/Y VSS VDD sky130_fd_sc_hs__a21oi_1
Xsky130_fd_sc_hs__mux2_1_309 VDD VSS sky130_fd_sc_hs__mux2_1_309/X sky130_fd_sc_hs__buf_8_23/X
+ sky130_fd_sc_hs__mux2_1_309/A0 sky130_fd_sc_hs__a22o_1_61/B2 VSS VDD sky130_fd_sc_hs__mux2_1
Xsky130_fd_sc_hs__nor3_1_11 VDD VSS sky130_fd_sc_hs__nor3_1_11/Y sky130_fd_sc_hs__o21a_1_5/A2
+ sky130_fd_sc_hs__o21a_1_5/B1 sky130_fd_sc_hs__o21a_1_5/A1 VSS VDD sky130_fd_sc_hs__nor3_1
Xsky130_fd_sc_hs__nor3_1_22 VDD VSS sky130_fd_sc_hs__nor3_1_22/Y sky130_fd_sc_hs__o22ai_1_0/Y
+ sky130_fd_sc_hs__nor3_1_22/B sky130_fd_sc_hs__nor3_1_22/A VSS VDD sky130_fd_sc_hs__nor3_1
Xsky130_fd_sc_hs__nor3_1_33 VDD VSS sky130_fd_sc_hs__nor3_1_33/Y sky130_fd_sc_hs__nor3_1_33/C
+ sky130_fd_sc_hs__nor3_1_41/B sky130_fd_sc_hs__nor3_1_33/A VSS VDD sky130_fd_sc_hs__nor3_1
Xsky130_fd_sc_hs__nor3_1_44 VDD VSS sky130_fd_sc_hs__nor3_1_44/Y sky130_fd_sc_hs__or2_1_30/B
+ sky130_fd_sc_hs__nor3_1_44/B sky130_fd_sc_hs__or2_1_21/B VSS VDD sky130_fd_sc_hs__nor3_1
Xsky130_fd_sc_hs__nor3_1_55 VDD VSS sky130_fd_sc_hs__nor3_1_55/Y sky130_fd_sc_hs__nor3_1_55/C
+ sky130_fd_sc_hs__nor3_1_55/B sky130_fd_sc_hs__nor3_1_55/A VSS VDD sky130_fd_sc_hs__nor3_1
Xsky130_fd_sc_hs__dfrtp_1_102 sky130_fd_sc_hs__clkbuf_4_1/X VDD VSS sky130_fd_sc_hs__mux2_1_104/A1
+ sky130_fd_sc_hs__clkbuf_2_35/X sky130_fd_sc_hs__mux2_1_104/X VSS VDD sky130_fd_sc_hs__dfrtp_1
Xsky130_fd_sc_hs__dfrtp_1_113 sky130_fd_sc_hs__clkbuf_4_2/X VDD VSS sky130_fd_sc_hs__mux2_1_108/A1
+ sky130_fd_sc_hs__clkbuf_2_40/X sky130_fd_sc_hs__mux2_1_108/X VSS VDD sky130_fd_sc_hs__dfrtp_1
Xsky130_fd_sc_hs__dfrtp_1_124 sky130_fd_sc_hs__clkbuf_4_2/X VDD VSS sky130_fd_sc_hs__mux2_1_484/A1
+ sky130_fd_sc_hs__clkinv_1_28/A sky130_fd_sc_hs__mux2_1_484/X VSS VDD sky130_fd_sc_hs__dfrtp_1
Xsky130_fd_sc_hs__dfrtp_1_135 sky130_fd_sc_hs__clkbuf_4_3/X VDD VSS sky130_fd_sc_hs__buf_1_32/A
+ sky130_fd_sc_hs__clkinv_1_32/A sky130_fd_sc_hs__mux2_1_122/X VSS VDD sky130_fd_sc_hs__dfrtp_1
Xsky130_fd_sc_hs__dfrtp_1_146 sky130_fd_sc_hs__clkbuf_4_3/A VDD VSS sky130_fd_sc_hs__mux2_1_135/A0
+ sky130_fd_sc_hs__clkinv_1_34/A sky130_fd_sc_hs__mux2_1_135/X VSS VDD sky130_fd_sc_hs__dfrtp_1
Xsky130_fd_sc_hs__dfrtp_1_157 sky130_fd_sc_hs__clkbuf_4_5/X VDD VSS sky130_fd_sc_hs__mux2_1_158/A0
+ sky130_fd_sc_hs__clkinv_1_44/A sky130_fd_sc_hs__mux2_1_158/X VSS VDD sky130_fd_sc_hs__dfrtp_1
Xsky130_fd_sc_hs__dfrtp_1_168 sky130_fd_sc_hs__clkbuf_4_5/X VDD VSS sky130_fd_sc_hs__mux2_1_157/A0
+ sky130_fd_sc_hs__clkbuf_2_55/X sky130_fd_sc_hs__mux2_1_157/X VSS VDD sky130_fd_sc_hs__dfrtp_1
Xsky130_fd_sc_hs__dfrtp_1_179 sky130_fd_sc_hs__clkbuf_16_5/X VDD VSS sky130_fd_sc_hs__buf_1_53/A
+ sky130_fd_sc_hs__clkbuf_2_62/X sky130_fd_sc_hs__a21oi_1_48/Y VSS VDD sky130_fd_sc_hs__dfrtp_1
Xsky130_fd_sc_hs__buf_8_4 VDD VSS sky130_fd_sc_hs__buf_8_4/X sky130_fd_sc_hs__buf_8_4/A
+ VSS VDD sky130_fd_sc_hs__buf_8
Xsky130_fd_sc_hs__o21a_1_8 VDD VSS sky130_fd_sc_hs__o21a_1_8/X sky130_fd_sc_hs__xor2_1_10/X
+ sky130_fd_sc_hs__o21a_1_8/B1 sky130_fd_sc_hs__o21a_1_9/X VSS VDD sky130_fd_sc_hs__o21a_1
Xsky130_fd_sc_hs__clkinv_1_130 VDD VSS sky130_fd_sc_hs__clkinv_1_130/A sky130_fd_sc_hs__clkinv_1_130/Y
+ VSS VDD sky130_fd_sc_hs__clkinv_1
Xsky130_fd_sc_hs__clkinv_1_141 VDD VSS sky130_fd_sc_hs__clkinv_1_141/A sky130_fd_sc_hs__clkinv_1_141/Y
+ VSS VDD sky130_fd_sc_hs__clkinv_1
Xsky130_fd_sc_hs__clkinv_1_152 VDD VSS sky130_fd_sc_hs__xnor2_1_136/Y sky130_fd_sc_hs__maj3_1_57/C
+ VSS VDD sky130_fd_sc_hs__clkinv_1
Xsky130_fd_sc_hs__clkinv_1_163 VDD VSS sky130_fd_sc_hs__xor2_1_80/X sky130_fd_sc_hs__or3_1_8/B
+ VSS VDD sky130_fd_sc_hs__clkinv_1
Xsky130_fd_sc_hs__o311ai_1_15 VDD VSS sky130_fd_sc_hs__nor3_1_25/B sky130_fd_sc_hs__nor3_1_25/A
+ sky130_fd_sc_hs__o31ai_1_10/B1 sky130_fd_sc_hs__a31o_1_13/A2 sky130_fd_sc_hs__and2_1_27/B
+ sky130_fd_sc_hs__nor3_1_25/C VSS VDD sky130_fd_sc_hs__o311ai_1
Xsky130_fd_sc_hs__nor2_1_100 VDD VSS sky130_fd_sc_hs__nor3_1_26/C sky130_fd_sc_hs__buf_1_86/A
+ sky130_fd_sc_hs__nor2_4_0/B VSS VDD sky130_fd_sc_hs__nor2_1
Xsky130_fd_sc_hs__nor2_1_111 VDD VSS sky130_fd_sc_hs__buf_8_11/X sky130_fd_sc_hs__nor2_1_111/Y
+ sky130_fd_sc_hs__xor2_1_70/B VSS VDD sky130_fd_sc_hs__nor2_1
Xsky130_fd_sc_hs__dfrtp_1_680 sky130_fd_sc_hs__clkbuf_4_35/X VDD VSS sky130_fd_sc_hs__a222o_1_6/C1
+ sky130_fd_sc_hs__clkbuf_2_210/X sky130_fd_sc_hs__mux2_1_381/X VSS VDD sky130_fd_sc_hs__dfrtp_1
Xsky130_fd_sc_hs__nor2_1_122 VDD VSS sky130_fd_sc_hs__o22ai_1_2/Y sky130_fd_sc_hs__nor2_1_122/Y
+ sky130_fd_sc_hs__nor3_1_32/Y VSS VDD sky130_fd_sc_hs__nor2_1
Xsky130_fd_sc_hs__dfrtp_1_691 sky130_fd_sc_hs__clkbuf_4_33/X VDD VSS sky130_fd_sc_hs__nand2_1_218/A
+ sky130_fd_sc_hs__clkbuf_2_213/X sky130_fd_sc_hs__mux2_1_396/X VSS VDD sky130_fd_sc_hs__dfrtp_1
Xsky130_fd_sc_hs__nor2_1_133 VDD VSS sky130_fd_sc_hs__nor3_1_36/Y sky130_fd_sc_hs__nor4b_1_1/B
+ sky130_fd_sc_hs__or2_1_22/A VSS VDD sky130_fd_sc_hs__nor2_1
Xsky130_fd_sc_hs__nor2_1_144 VDD VSS sky130_fd_sc_hs__nor2_1_146/A sky130_fd_sc_hs__nand4_1_6/D
+ sky130_fd_sc_hs__xor2_1_75/A VSS VDD sky130_fd_sc_hs__nor2_1
Xsky130_fd_sc_hs__a22oi_1_20 VDD VSS sky130_fd_sc_hs__mux2_1_50/A1 sky130_fd_sc_hs__and4_1_1/C
+ sky130_fd_sc_hs__buf_16_9/X sky130_fd_sc_hs__a22o_1_8/B1 sky130_fd_sc_hs__xor2_1_50/A
+ VSS VDD sky130_fd_sc_hs__a22oi_1
Xsky130_fd_sc_hs__nor2_1_155 VDD VSS sky130_fd_sc_hs__nor2_1_155/B sky130_fd_sc_hs__nor2_1_155/Y
+ sky130_fd_sc_hs__nor3_1_39/Y VSS VDD sky130_fd_sc_hs__nor2_1
Xsky130_fd_sc_hs__clkinv_1_9 VDD VSS sky130_fd_sc_hs__clkinv_1_9/A sky130_fd_sc_hs__clkinv_1_9/Y
+ VSS VDD sky130_fd_sc_hs__clkinv_1
Xsky130_fd_sc_hs__a22oi_1_31 VDD VSS sky130_fd_sc_hs__mux2_1_89/A1 sky130_fd_sc_hs__nand2_1_17/A
+ sky130_fd_sc_hs__buf_16_9/X sky130_fd_sc_hs__a22oi_1_6/B1 sky130_fd_sc_hs__maj3_1_2/C
+ VSS VDD sky130_fd_sc_hs__a22oi_1
Xsky130_fd_sc_hs__nor2_1_166 VDD VSS sky130_fd_sc_hs__and2_1_41/B sky130_fd_sc_hs__o31a_1_6/A3
+ sky130_fd_sc_hs__nor2_1_77/A VSS VDD sky130_fd_sc_hs__nor2_1
Xsky130_fd_sc_hs__a22oi_1_42 VDD VSS sky130_fd_sc_hs__maj3_1_8/C sky130_fd_sc_hs__and4_1_2/D
+ sky130_fd_sc_hs__a22oi_1_6/B1 sky130_fd_sc_hs__a22o_1_8/A2 sky130_fd_sc_hs__mux2_1_174/A0
+ VSS VDD sky130_fd_sc_hs__a22oi_1
Xsky130_fd_sc_hs__nor2_1_177 VDD VSS sky130_fd_sc_hs__or2_1_30/X sky130_fd_sc_hs__nor2_1_177/Y
+ sky130_fd_sc_hs__nor2_1_177/A VSS VDD sky130_fd_sc_hs__nor2_1
Xsky130_fd_sc_hs__a22oi_1_53 VDD VSS sky130_fd_sc_hs__mux2_1_147/A1 sky130_fd_sc_hs__nand4_1_1/D
+ sky130_fd_sc_hs__a22o_1_9/A2 sky130_fd_sc_hs__a22o_1_8/B1 sky130_fd_sc_hs__or2_1_3/B
+ VSS VDD sky130_fd_sc_hs__a22oi_1
Xsky130_fd_sc_hs__a22oi_1_64 VDD VSS sky130_fd_sc_hs__o32ai_1_0/B2 sky130_fd_sc_hs__a22oi_1_64/Y
+ sky130_fd_sc_hs__nor2b_1_49/Y sky130_fd_sc_hs__nor2b_1_51/Y sky130_fd_sc_hs__nor3_1_41/A
+ VSS VDD sky130_fd_sc_hs__a22oi_1
Xsky130_fd_sc_hs__a22oi_1_75 VDD VSS sky130_fd_sc_hs__maj3_1_52/C sky130_fd_sc_hs__a22oi_1_75/Y
+ sky130_fd_sc_hs__buf_4_4/X sky130_fd_sc_hs__a222o_1_2/A2 sky130_fd_sc_hs__mux2_1_274/A0
+ VSS VDD sky130_fd_sc_hs__a22oi_1
Xsky130_fd_sc_hs__a22oi_1_86 VDD VSS sky130_fd_sc_hs__mux2_1_316/A0 sky130_fd_sc_hs__nand4_1_10/C
+ sky130_fd_sc_hs__buf_8_31/X sky130_fd_sc_hs__a222o_1_2/A2 sky130_fd_sc_hs__mux2_1_315/A0
+ VSS VDD sky130_fd_sc_hs__a22oi_1
Xsky130_fd_sc_hs__a22oi_1_97 VDD VSS sky130_fd_sc_hs__mux2_1_386/A0 sky130_fd_sc_hs__a41o_1_0/A3
+ sky130_fd_sc_hs__nand2_1_33/B sky130_fd_sc_hs__a22oi_1_6/B1 sky130_fd_sc_hs__xnor3_1_1/C
+ VSS VDD sky130_fd_sc_hs__a22oi_1
Xsky130_fd_sc_hs__mux2_1_106 VDD VSS sky130_fd_sc_hs__mux2_1_106/X sky130_fd_sc_hs__mux2_1_7/S
+ sky130_fd_sc_hs__mux2_1_106/A0 sky130_fd_sc_hs__mux2_1_98/A1 VSS VDD sky130_fd_sc_hs__mux2_1
Xsky130_fd_sc_hs__mux2_1_117 VDD VSS sky130_fd_sc_hs__mux2_1_117/X sky130_fd_sc_hs__buf_16_0/A
+ sky130_fd_sc_hs__xor2_1_5/B sky130_fd_sc_hs__a22o_1_61/B2 VSS VDD sky130_fd_sc_hs__mux2_1
Xsky130_fd_sc_hs__mux2_1_128 VDD VSS sky130_fd_sc_hs__mux2_1_128/X sky130_fd_sc_hs__buf_16_3/X
+ sky130_fd_sc_hs__a22o_1_60/B2 sky130_fd_sc_hs__mux2_1_128/A1 VSS VDD sky130_fd_sc_hs__mux2_1
Xsky130_fd_sc_hs__mux2_1_139 VDD VSS sky130_fd_sc_hs__mux2_1_139/X sky130_fd_sc_hs__mux2_1_8/S
+ sky130_fd_sc_hs__mux2_1_139/A0 sky130_fd_sc_hs__a22o_1_40/B2 VSS VDD sky130_fd_sc_hs__mux2_1
Xsky130_fd_sc_hs__or3_1_7 VDD VSS sky130_fd_sc_hs__or3_1_7/A sky130_fd_sc_hs__or3_1_7/B
+ sky130_fd_sc_hs__or3_1_7/C sky130_fd_sc_hs__or3_1_7/X VSS VDD sky130_fd_sc_hs__or3_1
Xsky130_fd_sc_hs__a31o_1_2 VDD VSS sky130_fd_sc_hs__a31o_1_2/X sky130_fd_sc_hs__xor2_1_27/X
+ sky130_fd_sc_hs__a31o_1_2/A2 sky130_fd_sc_hs__a31o_1_2/A1 sky130_fd_sc_hs__buf_8_12/X
+ VSS VDD sky130_fd_sc_hs__a31o_1
Xsky130_fd_sc_hs__buf_1_109 VDD VSS sky130_fd_sc_hs__buf_1_109/A dac_n_force[12] VSS
+ VDD sky130_fd_sc_hs__buf_1
Xsky130_fd_sc_hs__o21a_1_12 VDD VSS sky130_fd_sc_hs__o21a_1_12/X sky130_fd_sc_hs__buf_1_22/X
+ sky130_fd_sc_hs__buf_8_2/X sky130_fd_sc_hs__xor2_1_18/A VSS VDD sky130_fd_sc_hs__o21a_1
Xsky130_fd_sc_hs__clkbuf_2_206 VDD VSS sky130_fd_sc_hs__clkinv_1_154/A sky130_fd_sc_hs__inv_8_1/A
+ VSS VDD sky130_fd_sc_hs__clkbuf_2
Xsky130_fd_sc_hs__o21a_1_23 VDD VSS sky130_fd_sc_hs__o21a_1_23/X sky130_fd_sc_hs__o21a_1_23/A2
+ sky130_fd_sc_hs__a32o_1_9/B1 sky130_fd_sc_hs__or3b_1_1/A VSS VDD sky130_fd_sc_hs__o21a_1
Xsky130_fd_sc_hs__clkbuf_2_217 VDD VSS sky130_fd_sc_hs__clkbuf_2_217/X sky130_fd_sc_hs__clkbuf_8_17/A
+ VSS VDD sky130_fd_sc_hs__clkbuf_2
Xsky130_fd_sc_hs__clkbuf_2_228 VDD VSS sky130_fd_sc_hs__clkbuf_2_228/X sky130_fd_sc_hs__clkinv_2_11/A
+ VSS VDD sky130_fd_sc_hs__clkbuf_2
Xsky130_fd_sc_hs__nand2_1_206 VDD VSS sky130_fd_sc_hs__o31ai_4_0/Y sky130_fd_sc_hs__o31ai_1_19/B1
+ sky130_fd_sc_hs__xor2_1_88/A VSS VDD sky130_fd_sc_hs__nand2_1
Xsky130_fd_sc_hs__clkbuf_2_239 VDD VSS sky130_fd_sc_hs__clkbuf_2_239/X sky130_fd_sc_hs__clkinv_4_6/A
+ VSS VDD sky130_fd_sc_hs__clkbuf_2
Xsky130_fd_sc_hs__nand2_1_217 VDD VSS sky130_fd_sc_hs__a22o_1_8/B1 sky130_fd_sc_hs__a41o_1_0/A1
+ sky130_fd_sc_hs__xnor3_1_1/B VSS VDD sky130_fd_sc_hs__nand2_1
Xsky130_fd_sc_hs__nand2_1_228 VDD VSS sky130_fd_sc_hs__buf_16_8/X sky130_fd_sc_hs__nand3_1_45/A
+ sky130_fd_sc_hs__nand2_1_228/A VSS VDD sky130_fd_sc_hs__nand2_1
Xsky130_fd_sc_hs__and2_1_13 VDD VSS sky130_fd_sc_hs__maj3_1_9/X sky130_fd_sc_hs__nor2_1_32/B
+ sky130_fd_sc_hs__and2_1_13/X VSS VDD sky130_fd_sc_hs__and2_1
Xsky130_fd_sc_hs__and2_1_24 VDD VSS sky130_fd_sc_hs__and2_1_24/A sky130_fd_sc_hs__and2_1_24/B
+ sky130_fd_sc_hs__and2_1_24/X VSS VDD sky130_fd_sc_hs__and2_1
Xsky130_fd_sc_hs__and2_1_35 VDD VSS sky130_fd_sc_hs__nor3_1_36/B sky130_fd_sc_hs__and2_1_35/B
+ sky130_fd_sc_hs__or2_1_22/B VSS VDD sky130_fd_sc_hs__and2_1
Xsky130_fd_sc_hs__and2_1_46 VDD VSS sky130_fd_sc_hs__and2_1_46/A sky130_fd_sc_hs__and2_1_46/B
+ sky130_fd_sc_hs__and2_1_46/X VSS VDD sky130_fd_sc_hs__and2_1
Xsky130_fd_sc_hs__mux2_1_470 VDD VSS sky130_fd_sc_hs__mux2_1_470/X sky130_fd_sc_hs__buf_8_24/X
+ sky130_fd_sc_hs__dfrtp_2_1/Q sky130_fd_sc_hs__mux2_1_470/A1 VSS VDD sky130_fd_sc_hs__mux2_1
Xsky130_fd_sc_hs__mux2_1_481 VDD VSS sky130_fd_sc_hs__mux2_1_481/X sky130_fd_sc_hs__mux2_1_98/S
+ sky130_fd_sc_hs__mux2_1_481/A0 sky130_fd_sc_hs__a22o_1_64/B2 VSS VDD sky130_fd_sc_hs__mux2_1
Xsky130_fd_sc_hs__nand3_1_15 VDD VSS sky130_fd_sc_hs__nand3_1_15/C sky130_fd_sc_hs__xnor3_1_0/C
+ sky130_fd_sc_hs__nand3_1_15/B sky130_fd_sc_hs__and4_1_2/X VSS VDD sky130_fd_sc_hs__nand3_1
Xsky130_fd_sc_hs__nand3_1_26 VDD VSS sky130_fd_sc_hs__nand4_1_6/D sky130_fd_sc_hs__mux2i_1_8/S
+ sky130_fd_sc_hs__nor3_1_39/B sky130_fd_sc_hs__nor3_1_37/C VSS VDD sky130_fd_sc_hs__nand3_1
Xsky130_fd_sc_hs__nand3_1_37 VDD VSS sky130_fd_sc_hs__nand3_1_37/C sky130_fd_sc_hs__nand3_1_37/Y
+ sky130_fd_sc_hs__nand3_1_37/B sky130_fd_sc_hs__nand3_1_37/A VSS VDD sky130_fd_sc_hs__nand3_1
Xsky130_fd_sc_hs__o2bb2ai_1_7 VDD VSS sky130_fd_sc_hs__o2bb2ai_1_7/Y sky130_fd_sc_hs__o21ai_1_22/Y
+ sky130_fd_sc_hs__maj3_1_9/A sky130_fd_sc_hs__o21a_1_7/A2 sky130_fd_sc_hs__a32o_1_2/B1
+ VSS VDD sky130_fd_sc_hs__o2bb2ai_1
Xsky130_fd_sc_hs__o211a_2_1 VDD VSS sky130_fd_sc_hs__nor4b_1_0/Y sky130_fd_sc_hs__and2_1_15/A
+ sky130_fd_sc_hs__o211a_2_1/A1 sky130_fd_sc_hs__buf_1_67/A sky130_fd_sc_hs__o211a_2_1/X
+ VSS VDD sky130_fd_sc_hs__o211a_2
Xsky130_fd_sc_hs__mux2i_1_12 VDD VSS sky130_fd_sc_hs__nor3b_1_1/Y sky130_fd_sc_hs__or2_1_22/B
+ sky130_fd_sc_hs__nor2_1_147/A sky130_fd_sc_hs__mux2i_1_12/Y VSS VDD sky130_fd_sc_hs__mux2i_1
Xsky130_fd_sc_hs__buf_1_12 VDD VSS sky130_fd_sc_hs__buf_1_12/A srm_busy VSS VDD sky130_fd_sc_hs__buf_1
Xsky130_fd_sc_hs__buf_1_23 VDD VSS sky130_fd_sc_hs__buf_1_23/A w_wr_data[16] VSS VDD
+ sky130_fd_sc_hs__buf_1
Xsky130_fd_sc_hs__buf_1_34 VDD VSS sky130_fd_sc_hs__buf_1_34/A raw_code_o[19] VSS
+ VDD sky130_fd_sc_hs__buf_1
Xsky130_fd_sc_hs__buf_1_45 VDD VSS sky130_fd_sc_hs__buf_1_45/A raw_code_o[5] VSS VDD
+ sky130_fd_sc_hs__buf_1
Xsky130_fd_sc_hs__buf_1_56 VDD VSS sky130_fd_sc_hs__buf_1_56/A calib_overrange_bits[5]
+ VSS VDD sky130_fd_sc_hs__buf_1
Xsky130_fd_sc_hs__buf_1_67 VDD VSS sky130_fd_sc_hs__buf_1_67/A sky130_fd_sc_hs__buf_1_67/X
+ VSS VDD sky130_fd_sc_hs__buf_1
Xsky130_fd_sc_hs__buf_1_78 VDD VSS sky130_fd_sc_hs__buf_1_78/A sky130_fd_sc_hs__buf_1_78/X
+ VSS VDD sky130_fd_sc_hs__buf_1
Xsky130_fd_sc_hs__buf_1_89 VDD VSS sky130_fd_sc_hs__buf_1_89/A sky130_fd_sc_hs__buf_1_89/X
+ VSS VDD sky130_fd_sc_hs__buf_1
Xsky130_fd_sc_hs__a22o_1_70 VDD VSS sky130_fd_sc_hs__nor3_1_8/C sky130_fd_sc_hs__a22o_1_70/B2
+ sky130_fd_sc_hs__nand2_1_51/B sky130_fd_sc_hs__a22oi_1_5/A2 sky130_fd_sc_hs__a22o_1_70/A1
+ VSS VDD sky130_fd_sc_hs__a22o_1
Xsky130_fd_sc_hs__a22o_1_81 VDD VSS sky130_fd_sc_hs__a22o_1_81/X sky130_fd_sc_hs__a22o_1_81/B2
+ sky130_fd_sc_hs__or2_1_17/X sky130_fd_sc_hs__buf_8_13/A sky130_fd_sc_hs__maj3_1_49/C
+ VSS VDD sky130_fd_sc_hs__a22o_1
Xsky130_fd_sc_hs__a22o_1_92 VDD VSS sky130_fd_sc_hs__a22o_1_92/X sky130_fd_sc_hs__a22o_1_92/B2
+ sky130_fd_sc_hs__buf_8_17/X sky130_fd_sc_hs__buf_8_15/X sky130_fd_sc_hs__a22o_1_93/B2
+ VSS VDD sky130_fd_sc_hs__a22o_1
Xsky130_fd_sc_hs__a21o_1_1 VDD VSS sky130_fd_sc_hs__a21o_1_1/X sky130_fd_sc_hs__a21o_1_1/A1
+ sky130_fd_sc_hs__a21o_1_1/B1 sky130_fd_sc_hs__nor2_1_48/Y VSS VDD sky130_fd_sc_hs__a21o_1
Xsky130_fd_sc_hs__clkbuf_2_70 VDD VSS sky130_fd_sc_hs__clkbuf_2_70/X sky130_fd_sc_hs__clkinv_4_2/A
+ VSS VDD sky130_fd_sc_hs__clkbuf_2
Xsky130_fd_sc_hs__clkbuf_2_81 VDD VSS sky130_fd_sc_hs__clkbuf_2_81/X sky130_fd_sc_hs__clkinv_4_2/A
+ VSS VDD sky130_fd_sc_hs__clkbuf_2
Xsky130_fd_sc_hs__clkbuf_2_92 VDD VSS sky130_fd_sc_hs__clkinv_1_61/A sky130_fd_sc_hs__clkbuf_2_92/A
+ VSS VDD sky130_fd_sc_hs__clkbuf_2
Xsky130_fd_sc_hs__maj3_1_10 VDD VSS sky130_fd_sc_hs__maj3_1_9/A sky130_fd_sc_hs__maj3_1_9/B
+ sky130_fd_sc_hs__or2_1_7/B sky130_fd_sc_hs__maj3_1_10/C VSS VDD sky130_fd_sc_hs__maj3_1
Xsky130_fd_sc_hs__maj3_1_21 VDD VSS sky130_fd_sc_hs__xor2_1_33/A sky130_fd_sc_hs__xor2_1_33/B
+ sky130_fd_sc_hs__maj3_1_21/X sky130_fd_sc_hs__maj3_1_21/C VSS VDD sky130_fd_sc_hs__maj3_1
Xsky130_fd_sc_hs__maj3_1_32 VDD VSS sky130_fd_sc_hs__xor2_1_61/A sky130_fd_sc_hs__xor2_1_61/B
+ sky130_fd_sc_hs__maj3_1_32/X sky130_fd_sc_hs__maj3_1_32/C VSS VDD sky130_fd_sc_hs__maj3_1
Xsky130_fd_sc_hs__maj3_1_43 VDD VSS sky130_fd_sc_hs__maj3_1_43/A sky130_fd_sc_hs__maj3_1_43/B
+ sky130_fd_sc_hs__maj3_1_43/X sky130_fd_sc_hs__maj3_1_43/C VSS VDD sky130_fd_sc_hs__maj3_1
Xsky130_fd_sc_hs__maj3_1_54 VDD VSS sky130_fd_sc_hs__maj3_1_65/X sky130_fd_sc_hs__maj3_1_66/X
+ sky130_fd_sc_hs__maj3_1_54/X sky130_fd_sc_hs__maj3_1_54/C VSS VDD sky130_fd_sc_hs__maj3_1
Xsky130_fd_sc_hs__maj3_1_65 VDD VSS sky130_fd_sc_hs__xnor3_1_2/A sky130_fd_sc_hs__xnor3_1_2/B
+ sky130_fd_sc_hs__maj3_1_65/X sky130_fd_sc_hs__xnor3_1_2/C VSS VDD sky130_fd_sc_hs__maj3_1
Xsky130_fd_sc_hs__o21bai_1_4 VDD VSS sky130_fd_sc_hs__a22oi_1_58/Y sky130_fd_sc_hs__o21bai_1_4/Y
+ sky130_fd_sc_hs__nor3_1_30/Y sky130_fd_sc_hs__nor3_1_34/C VSS VDD sky130_fd_sc_hs__o21bai_1
Xsky130_fd_sc_hs__nand2_1_70 VDD VSS sky130_fd_sc_hs__and3_1_5/X sky130_fd_sc_hs__o32a_1_0/A3
+ sky130_fd_sc_hs__nor2_1_40/B VSS VDD sky130_fd_sc_hs__nand2_1
Xsky130_fd_sc_hs__nand2_1_81 VDD VSS sky130_fd_sc_hs__a32o_1_6/A3 sky130_fd_sc_hs__a31o_1_7/A1
+ sky130_fd_sc_hs__nand2_1_81/A VSS VDD sky130_fd_sc_hs__nand2_1
Xsky130_fd_sc_hs__nand2_1_92 VDD VSS sky130_fd_sc_hs__nor2_1_48/Y sky130_fd_sc_hs__nand2_1_92/Y
+ sky130_fd_sc_hs__and3_1_6/A VSS VDD sky130_fd_sc_hs__nand2_1
Xsky130_fd_sc_hs__a222oi_1_11 VDD VSS sky130_fd_sc_hs__a22o_1_9/A2 sky130_fd_sc_hs__mux2_1_206/A1
+ sky130_fd_sc_hs__a22oi_1_6/B1 sky130_fd_sc_hs__a22oi_1_5/A2 sky130_fd_sc_hs__mux2_1_214/A0
+ sky130_fd_sc_hs__nand3_1_9/A sky130_fd_sc_hs__xor2_1_46/B VSS VDD sky130_fd_sc_hs__a222oi_1
Xsky130_fd_sc_hs__a222oi_1_22 VDD VSS sky130_fd_sc_hs__a22o_1_9/A2 sky130_fd_sc_hs__mux2_1_384/A1
+ sky130_fd_sc_hs__a22oi_1_6/B1 sky130_fd_sc_hs__a22oi_1_5/A2 sky130_fd_sc_hs__mux2_1_380/A0
+ sky130_fd_sc_hs__nand2_1_214/A sky130_fd_sc_hs__xor2_1_90/B VSS VDD sky130_fd_sc_hs__a222oi_1
Xsky130_fd_sc_hs__o31ai_1_14 VDD VSS sky130_fd_sc_hs__nor3_1_36/Y sky130_fd_sc_hs__or3_1_4/X
+ sky130_fd_sc_hs__o31ai_1_14/B1 sky130_fd_sc_hs__or2_1_22/A sky130_fd_sc_hs__o31ai_1_14/Y
+ VSS VDD sky130_fd_sc_hs__o31ai_1
Xsky130_fd_sc_hs__nor2_1_8 VDD VSS sky130_fd_sc_hs__nor3_1_3/A sky130_fd_sc_hs__nor2_1_8/Y
+ sky130_fd_sc_hs__nor2_1_8/A VSS VDD sky130_fd_sc_hs__nor2_1
Xsky130_fd_sc_hs__clkbuf_16_5 VDD VSS sky130_fd_sc_hs__clkbuf_16_5/X sky130_fd_sc_hs__clkbuf_2_61/X
+ VSS VDD sky130_fd_sc_hs__clkbuf_16
Xsky130_fd_sc_hs__dfrtp_1_509 sky130_fd_sc_hs__clkbuf_4_22/X VDD VSS sky130_fd_sc_hs__maj3_1_40/C
+ sky130_fd_sc_hs__clkinv_1_98/A sky130_fd_sc_hs__a22o_1_99/X VSS VDD sky130_fd_sc_hs__dfrtp_1
Xsky130_fd_sc_hs__a21oi_1_16 VDD VSS sky130_fd_sc_hs__and3_1_4/A sky130_fd_sc_hs__nor2_1_14/A
+ sky130_fd_sc_hs__nor3_1_6/Y sky130_fd_sc_hs__and3_1_4/B VSS VDD sky130_fd_sc_hs__a21oi_1
Xsky130_fd_sc_hs__a21oi_1_27 VDD VSS sky130_fd_sc_hs__and2_1_4/X sky130_fd_sc_hs__xnor2_1_14/A
+ sky130_fd_sc_hs__and2_1_5/X sky130_fd_sc_hs__nor2_1_15/Y VSS VDD sky130_fd_sc_hs__a21oi_1
Xsky130_fd_sc_hs__a21oi_1_38 VDD VSS sky130_fd_sc_hs__and3_1_3/B sky130_fd_sc_hs__o31ai_1_4/A2
+ sky130_fd_sc_hs__and3_1_3/C sky130_fd_sc_hs__and3_1_3/A VSS VDD sky130_fd_sc_hs__a21oi_1
Xsky130_fd_sc_hs__a21oi_1_49 VDD VSS sky130_fd_sc_hs__buf_8_19/X sky130_fd_sc_hs__a21oi_1_49/Y
+ sky130_fd_sc_hs__nand3b_1_0/Y sky130_fd_sc_hs__o21ai_1_13/Y VSS VDD sky130_fd_sc_hs__a21oi_1
Xsky130_fd_sc_hs__dfrtp_1_14 sky130_fd_sc_hs__clkbuf_4_4/X VDD VSS sky130_fd_sc_hs__mux2_1_11/A1
+ sky130_fd_sc_hs__clkbuf_2_5/X sky130_fd_sc_hs__mux2_1_11/X VSS VDD sky130_fd_sc_hs__dfrtp_1
Xsky130_fd_sc_hs__dfrtp_1_25 sky130_fd_sc_hs__clkbuf_4_3/A VDD VSS sky130_fd_sc_hs__mux2_1_28/A0
+ sky130_fd_sc_hs__clkbuf_2_8/X sky130_fd_sc_hs__mux2_1_28/X VSS VDD sky130_fd_sc_hs__dfrtp_1
Xsky130_fd_sc_hs__a22oi_1_102 VDD VSS sky130_fd_sc_hs__mux2_1_434/A1 sky130_fd_sc_hs__nand4_1_15/C
+ sky130_fd_sc_hs__a222o_1_3/C2 sky130_fd_sc_hs__a222o_1_2/A2 sky130_fd_sc_hs__mux2_1_459/A0
+ VSS VDD sky130_fd_sc_hs__a22oi_1
Xsky130_fd_sc_hs__a22oi_1_113 VDD VSS sky130_fd_sc_hs__mux2_1_450/A0 sky130_fd_sc_hs__nand4_1_15/B
+ sky130_fd_sc_hs__a22oi_1_7/B1 sky130_fd_sc_hs__a22oi_1_5/A2 sky130_fd_sc_hs__mux2_1_451/A0
+ VSS VDD sky130_fd_sc_hs__a22oi_1
Xsky130_fd_sc_hs__dfrtp_1_36 sky130_fd_sc_hs__clkbuf_4_3/X VDD VSS sky130_fd_sc_hs__mux2_1_36/A1
+ sky130_fd_sc_hs__clkbuf_2_7/X sky130_fd_sc_hs__mux2_1_36/X VSS VDD sky130_fd_sc_hs__dfrtp_1
Xsky130_fd_sc_hs__dfrtp_1_47 sky130_fd_sc_hs__clkbuf_4_0/X VDD VSS sky130_fd_sc_hs__mux2_1_41/A0
+ sky130_fd_sc_hs__clkbuf_2_14/X sky130_fd_sc_hs__mux2_1_41/X VSS VDD sky130_fd_sc_hs__dfrtp_1
Xsky130_fd_sc_hs__dfrtp_1_58 sky130_fd_sc_hs__buf_8_38/X VDD VSS sky130_fd_sc_hs__xor2_1_1/A
+ sky130_fd_sc_hs__clkbuf_2_23/X sky130_fd_sc_hs__mux2_1_58/X VSS VDD sky130_fd_sc_hs__dfrtp_1
Xsky130_fd_sc_hs__dfrtp_1_69 sky130_fd_sc_hs__clkbuf_4_0/X VDD VSS sky130_fd_sc_hs__mux2_1_68/A1
+ sky130_fd_sc_hs__clkbuf_2_24/X sky130_fd_sc_hs__mux2_1_68/X VSS VDD sky130_fd_sc_hs__dfrtp_1
Xsky130_fd_sc_hs__a311o_1_1 VDD VSS sky130_fd_sc_hs__a32o_1_1/A3 sky130_fd_sc_hs__nand2_1_8/A
+ sky130_fd_sc_hs__o21a_1_0/X sky130_fd_sc_hs__nor3_1_5/B sky130_fd_sc_hs__nand2_1_5/B
+ sky130_fd_sc_hs__and2_1_0/B VSS VDD sky130_fd_sc_hs__a311o_1
Xsky130_fd_sc_hs__a22o_1_104 VDD VSS sky130_fd_sc_hs__buf_1_118/A sky130_fd_sc_hs__buf_8_20/X
+ sky130_fd_sc_hs__nor2_1_149/Y sky130_fd_sc_hs__nand2_1_125/Y sky130_fd_sc_hs__mux2i_1_5/A1
+ VSS VDD sky130_fd_sc_hs__a22o_1
Xsky130_fd_sc_hs__a22o_1_115 VDD VSS sky130_fd_sc_hs__a22o_1_115/X sky130_fd_sc_hs__nand4_1_9/D
+ sky130_fd_sc_hs__buf_8_16/X sky130_fd_sc_hs__buf_8_18/X sky130_fd_sc_hs__nand2_1_123/A
+ VSS VDD sky130_fd_sc_hs__a22o_1
Xsky130_fd_sc_hs__a22o_1_126 VDD VSS sky130_fd_sc_hs__nor3_1_49/A sky130_fd_sc_hs__mux2_1_346/A0
+ sky130_fd_sc_hs__nand2_1_51/B sky130_fd_sc_hs__nand2_1_33/B sky130_fd_sc_hs__mux2_1_345/A0
+ VSS VDD sky130_fd_sc_hs__a22o_1
Xsky130_fd_sc_hs__a22o_1_137 VDD VSS sky130_fd_sc_hs__nor3_1_55/C sky130_fd_sc_hs__mux2_1_447/A0
+ sky130_fd_sc_hs__a22oi_1_7/B1 sky130_fd_sc_hs__a22oi_1_6/A2 sky130_fd_sc_hs__mux2_1_446/A1
+ VSS VDD sky130_fd_sc_hs__a22o_1
Xsky130_fd_sc_hs__nor3_4_6 VDD VSS sky130_fd_sc_hs__or3b_1_0/B sky130_fd_sc_hs__nor3_4_8/C
+ sky130_fd_sc_hs__nor3_4_6/C sky130_fd_sc_hs__nor3_4_6/Y VSS VDD sky130_fd_sc_hs__nor3_4
Xsky130_fd_sc_hs__dfstp_1_1 sky130_fd_sc_hs__clkbuf_4_28/X VDD VSS sky130_fd_sc_hs__nor3_1_48/B
+ sky130_fd_sc_hs__dfstp_1_1/D sky130_fd_sc_hs__dfstp_1_1/CLK VSS VDD sky130_fd_sc_hs__dfstp_1
Xsky130_fd_sc_hs__nand4b_1_0 VDD VSS sky130_fd_sc_hs__nor3_1_24/Y sky130_fd_sc_hs__nand4b_1_0/D
+ sky130_fd_sc_hs__nand4b_1_0/Y sky130_fd_sc_hs__nand4b_1_0/C sky130_fd_sc_hs__nand4_1_3/B
+ VSS VDD sky130_fd_sc_hs__nand4b_1
Xsky130_fd_sc_hs__o21ai_1_60 VDD VSS sky130_fd_sc_hs__and2_1_32/B sky130_fd_sc_hs__or3b_1_0/B
+ sky130_fd_sc_hs__or3b_1_1/B sky130_fd_sc_hs__or3b_1_1/A VSS VDD sky130_fd_sc_hs__o21ai_1
Xsky130_fd_sc_hs__o21ai_1_71 VDD VSS sky130_fd_sc_hs__o41ai_1_3/A2 sky130_fd_sc_hs__nand4_1_9/D
+ sky130_fd_sc_hs__nor2_1_162/B sky130_fd_sc_hs__nor2b_1_45/A VSS VDD sky130_fd_sc_hs__o21ai_1
Xsky130_fd_sc_hs__o21ai_1_82 VDD VSS sky130_fd_sc_hs__o21ai_1_82/Y sky130_fd_sc_hs__o31ai_2_0/B1
+ sky130_fd_sc_hs__nor2_2_6/B sky130_fd_sc_hs__nand4_1_9/D VSS VDD sky130_fd_sc_hs__o21ai_1
Xsky130_fd_sc_hs__dfrtp_1_306 sky130_fd_sc_hs__clkbuf_4_13/X VDD VSS sky130_fd_sc_hs__buf_1_42/A
+ sky130_fd_sc_hs__clkbuf_2_84/X sky130_fd_sc_hs__buf_1_71/X VSS VDD sky130_fd_sc_hs__dfrtp_1
Xsky130_fd_sc_hs__o21ai_1_93 VDD VSS sky130_fd_sc_hs__o21ai_1_93/Y sky130_fd_sc_hs__o21a_1_4/B1
+ sky130_fd_sc_hs__o21ai_1_93/A2 sky130_fd_sc_hs__o21ai_1_93/A1 VSS VDD sky130_fd_sc_hs__o21ai_1
Xsky130_fd_sc_hs__dfrtp_1_317 sky130_fd_sc_hs__buf_8_7/X VDD VSS sky130_fd_sc_hs__xor2_1_30/B
+ sky130_fd_sc_hs__clkinv_1_59/A sky130_fd_sc_hs__mux2_1_202/X VSS VDD sky130_fd_sc_hs__dfrtp_1
Xsky130_fd_sc_hs__dfrtp_1_328 sky130_fd_sc_hs__clkbuf_4_14/X VDD VSS sky130_fd_sc_hs__a22o_1_39/B2
+ sky130_fd_sc_hs__clkinv_1_61/A sky130_fd_sc_hs__a22o_1_39/X VSS VDD sky130_fd_sc_hs__dfrtp_1
Xsky130_fd_sc_hs__dfrtp_1_339 sky130_fd_sc_hs__clkbuf_4_14/X VDD VSS sky130_fd_sc_hs__maj3_1_24/C
+ sky130_fd_sc_hs__clkinv_1_65/A sky130_fd_sc_hs__dfrtp_1_339/D VSS VDD sky130_fd_sc_hs__dfrtp_1
Xsky130_fd_sc_hs__buf_16_1 sky130_fd_sc_hs__buf_16_1/X VDD VSS sky130_fd_sc_hs__buf_16_1/A
+ VSS VDD sky130_fd_sc_hs__buf_16
Xsky130_fd_sc_hs__and2_1_7 VDD VSS sky130_fd_sc_hs__and2_1_7/A sky130_fd_sc_hs__and2_1_7/B
+ sky130_fd_sc_hs__and2_1_7/X VSS VDD sky130_fd_sc_hs__and2_1
Xsky130_fd_sc_hs__clkbuf_4_16 VDD VSS sky130_fd_sc_hs__clkbuf_4_19/X sky130_fd_sc_hs__clkbuf_4_16/X
+ VSS VDD sky130_fd_sc_hs__clkbuf_4
Xsky130_fd_sc_hs__clkbuf_4_27 VDD VSS sky130_fd_sc_hs__or2_1_25/X sky130_fd_sc_hs__buf_16_3/A
+ VSS VDD sky130_fd_sc_hs__clkbuf_4
Xsky130_fd_sc_hs__clkbuf_4_38 VDD VSS sky130_fd_sc_hs__nor3_4_6/Y sky130_fd_sc_hs__a22o_1_9/A2
+ VSS VDD sky130_fd_sc_hs__clkbuf_4
Xsky130_fd_sc_hs__clkbuf_4_49 VDD VSS sky130_fd_sc_hs__buf_8_28/A sky130_fd_sc_hs__mux2_1_4/S
+ VSS VDD sky130_fd_sc_hs__clkbuf_4
Xsky130_fd_sc_hs__clkbuf_8_3 VDD VSS sky130_fd_sc_hs__clkbuf_8_4/A dec_clk VSS VDD
+ sky130_fd_sc_hs__clkbuf_8
Xsky130_fd_sc_hs__a21oi_1_170 VDD VSS sky130_fd_sc_hs__nor2_1_156/Y sky130_fd_sc_hs__dfrtp_1_467/D
+ sky130_fd_sc_hs__buf_8_11/X sky130_fd_sc_hs__o21ai_1_98/Y VSS VDD sky130_fd_sc_hs__a21oi_1
Xsky130_fd_sc_hs__a21oi_1_181 VDD VSS sky130_fd_sc_hs__o31ai_1_4/A1 sky130_fd_sc_hs__o21ai_1_85/B1
+ sky130_fd_sc_hs__or2_1_27/X sky130_fd_sc_hs__o21ai_1_85/A1 VSS VDD sky130_fd_sc_hs__a21oi_1
Xsky130_fd_sc_hs__a21oi_1_192 VDD VSS sky130_fd_sc_hs__nand2_1_205/Y sky130_fd_sc_hs__nand3_1_38/C
+ sky130_fd_sc_hs__a222o_1_3/C2 sky130_fd_sc_hs__mux2_1_359/A1 VSS VDD sky130_fd_sc_hs__a21oi_1
Xsky130_fd_sc_hs__nor3_1_12 VDD VSS sky130_fd_sc_hs__nor3_1_12/Y sky130_fd_sc_hs__nor3_1_12/C
+ sky130_fd_sc_hs__xor2_1_21/X sky130_fd_sc_hs__nor3_1_12/A VSS VDD sky130_fd_sc_hs__nor3_1
Xsky130_fd_sc_hs__nor3_1_23 VDD VSS sky130_fd_sc_hs__nor3_1_23/Y sky130_fd_sc_hs__nor3_1_26/C
+ sky130_fd_sc_hs__nor2_4_0/B sky130_fd_sc_hs__or2_1_21/B VSS VDD sky130_fd_sc_hs__nor3_1
Xsky130_fd_sc_hs__nor3_1_34 VDD VSS sky130_fd_sc_hs__nor3_1_34/Y sky130_fd_sc_hs__nor3_1_34/C
+ sky130_fd_sc_hs__or2_1_30/A sky130_fd_sc_hs__nor3_1_44/B VSS VDD sky130_fd_sc_hs__nor3_1
Xsky130_fd_sc_hs__nor3_1_45 VDD VSS sky130_fd_sc_hs__nor3_1_45/Y sky130_fd_sc_hs__o21a_1_28/X
+ sky130_fd_sc_hs__nor3_1_45/B sky130_fd_sc_hs__buf_8_37/A VSS VDD sky130_fd_sc_hs__nor3_1
Xsky130_fd_sc_hs__dfrtp_1_103 sky130_fd_sc_hs__buf_8_38/X VDD VSS sky130_fd_sc_hs__xor2_1_1/B
+ sky130_fd_sc_hs__clkinv_1_24/A sky130_fd_sc_hs__mux2_1_95/X VSS VDD sky130_fd_sc_hs__dfrtp_1
Xsky130_fd_sc_hs__dfrtp_1_114 sky130_fd_sc_hs__clkbuf_4_2/X VDD VSS sky130_fd_sc_hs__xor2_1_3/A
+ sky130_fd_sc_hs__clkbuf_2_39/X sky130_fd_sc_hs__a32o_1_2/X VSS VDD sky130_fd_sc_hs__dfrtp_1
Xsky130_fd_sc_hs__dfrtp_1_125 sky130_fd_sc_hs__buf_8_1/A VDD VSS sky130_fd_sc_hs__nor2_1_26/A
+ sky130_fd_sc_hs__clkinv_2_0/A sky130_fd_sc_hs__nand2_1_44/Y VSS VDD sky130_fd_sc_hs__dfrtp_1
Xsky130_fd_sc_hs__dfrtp_1_136 sky130_fd_sc_hs__clkbuf_4_3/X VDD VSS sky130_fd_sc_hs__buf_1_25/A
+ sky130_fd_sc_hs__clkinv_1_32/A sky130_fd_sc_hs__mux2_1_125/X VSS VDD sky130_fd_sc_hs__dfrtp_1
Xsky130_fd_sc_hs__dfrtp_1_147 sky130_fd_sc_hs__clkbuf_4_10/X VDD VSS sky130_fd_sc_hs__mux2_1_129/A1
+ sky130_fd_sc_hs__clkinv_1_35/A sky130_fd_sc_hs__mux2_1_129/X VSS VDD sky130_fd_sc_hs__dfrtp_1
Xsky130_fd_sc_hs__dfrtp_1_158 sky130_fd_sc_hs__clkbuf_4_5/X VDD VSS sky130_fd_sc_hs__maj3_1_9/B
+ sky130_fd_sc_hs__clkinv_1_44/A sky130_fd_sc_hs__mux2_1_159/X VSS VDD sky130_fd_sc_hs__dfrtp_1
Xsky130_fd_sc_hs__dfrtp_1_169 sky130_fd_sc_hs__clkbuf_4_5/X VDD VSS sky130_fd_sc_hs__mux2_1_151/A1
+ sky130_fd_sc_hs__clkbuf_2_55/X sky130_fd_sc_hs__mux2_1_151/X VSS VDD sky130_fd_sc_hs__dfrtp_1
Xsky130_fd_sc_hs__buf_8_5 VDD VSS sky130_fd_sc_hs__buf_8_5/X sky130_fd_sc_hs__buf_8_5/A
+ VSS VDD sky130_fd_sc_hs__buf_8
Xsky130_fd_sc_hs__clkinv_1_120 VDD VSS sky130_fd_sc_hs__dfstp_1_3/CLK sky130_fd_sc_hs__clkinv_1_120/Y
+ VSS VDD sky130_fd_sc_hs__clkinv_1
Xsky130_fd_sc_hs__o21a_1_9 VDD VSS sky130_fd_sc_hs__o21a_1_9/X sky130_fd_sc_hs__xor2_1_14/X
+ sky130_fd_sc_hs__o21a_1_9/B1 sky130_fd_sc_hs__o21a_1_9/A1 VSS VDD sky130_fd_sc_hs__o21a_1
Xsky130_fd_sc_hs__clkinv_1_131 VDD VSS sky130_fd_sc_hs__clkinv_1_131/A sky130_fd_sc_hs__clkinv_1_131/Y
+ VSS VDD sky130_fd_sc_hs__clkinv_1
Xsky130_fd_sc_hs__clkinv_1_142 VDD VSS sky130_fd_sc_hs__clkinv_1_142/A sky130_fd_sc_hs__clkinv_1_142/Y
+ VSS VDD sky130_fd_sc_hs__clkinv_1
Xsky130_fd_sc_hs__clkinv_1_153 VDD VSS sky130_fd_sc_hs__or3b_1_0/B sky130_fd_sc_hs__nand4b_1_2/B
+ VSS VDD sky130_fd_sc_hs__clkinv_1
Xsky130_fd_sc_hs__o311ai_1_16 VDD VSS sky130_fd_sc_hs__or3_1_2/B sky130_fd_sc_hs__or3_1_2/A
+ sky130_fd_sc_hs__nand2b_1_44/Y sky130_fd_sc_hs__a31o_1_12/A2 sky130_fd_sc_hs__and2_1_26/B
+ sky130_fd_sc_hs__or3_1_2/C VSS VDD sky130_fd_sc_hs__o311ai_1
Xsky130_fd_sc_hs__nor2_1_101 VDD VSS sky130_fd_sc_hs__nor2_1_94/B sky130_fd_sc_hs__nor2_1_101/Y
+ sky130_fd_sc_hs__nor2_1_98/A VSS VDD sky130_fd_sc_hs__nor2_1
Xsky130_fd_sc_hs__dfrtp_1_670 sky130_fd_sc_hs__clkbuf_4_31/X VDD VSS sky130_fd_sc_hs__xor2_1_80/A
+ sky130_fd_sc_hs__dfrtp_2_4/CLK sky130_fd_sc_hs__a32o_1_13/X VSS VDD sky130_fd_sc_hs__dfrtp_1
Xsky130_fd_sc_hs__nor2_1_112 VDD VSS sky130_fd_sc_hs__nor2_1_112/B sky130_fd_sc_hs__nor2_1_112/Y
+ sky130_fd_sc_hs__nor2_1_115/Y VSS VDD sky130_fd_sc_hs__nor2_1
Xsky130_fd_sc_hs__dfrtp_1_681 sky130_fd_sc_hs__clkbuf_4_35/X VDD VSS sky130_fd_sc_hs__nand3_1_41/A
+ sky130_fd_sc_hs__clkinv_1_157/A sky130_fd_sc_hs__mux2_1_374/X VSS VDD sky130_fd_sc_hs__dfrtp_1
Xsky130_fd_sc_hs__dfrtp_1_0 sky130_fd_sc_hs__clkbuf_4_4/X VDD VSS sky130_fd_sc_hs__mux2_1_1/A1
+ sky130_fd_sc_hs__clkinv_1_0/A sky130_fd_sc_hs__mux2_1_1/X VSS VDD sky130_fd_sc_hs__dfrtp_1
Xsky130_fd_sc_hs__nor2_1_123 VDD VSS sky130_fd_sc_hs__or2_1_30/B sky130_fd_sc_hs__nor3_1_41/B
+ sky130_fd_sc_hs__or2_1_30/A VSS VDD sky130_fd_sc_hs__nor2_1
Xsky130_fd_sc_hs__nor2_1_134 VDD VSS sky130_fd_sc_hs__nor4b_1_1/B sky130_fd_sc_hs__nor2_1_134/Y
+ sky130_fd_sc_hs__or3_1_4/A VSS VDD sky130_fd_sc_hs__nor2_1
Xsky130_fd_sc_hs__dfrtp_1_692 sky130_fd_sc_hs__clkbuf_4_33/X VDD VSS sky130_fd_sc_hs__maj3_1_56/A
+ sky130_fd_sc_hs__clkbuf_2_202/X sky130_fd_sc_hs__dfrtp_1_692/D VSS VDD sky130_fd_sc_hs__dfrtp_1
Xsky130_fd_sc_hs__a22oi_1_10 VDD VSS sky130_fd_sc_hs__mux2_1_30/A1 sky130_fd_sc_hs__nand2_1_1/A
+ sky130_fd_sc_hs__a222o_1_3/C2 sky130_fd_sc_hs__buf_16_7/X sky130_fd_sc_hs__mux2_1_34/A0
+ VSS VDD sky130_fd_sc_hs__a22oi_1
Xsky130_fd_sc_hs__nor2_1_145 VDD VSS sky130_fd_sc_hs__nor2_1_145/B sky130_fd_sc_hs__mux2i_1_7/S
+ sky130_fd_sc_hs__nor2_1_146/A VSS VDD sky130_fd_sc_hs__nor2_1
Xsky130_fd_sc_hs__a22oi_1_21 VDD VSS sky130_fd_sc_hs__mux2_1_60/A1 sky130_fd_sc_hs__nand3_1_8/A
+ sky130_fd_sc_hs__buf_16_8/X sky130_fd_sc_hs__a22oi_1_6/B1 sky130_fd_sc_hs__xor2_1_1/B
+ VSS VDD sky130_fd_sc_hs__a22oi_1
Xsky130_fd_sc_hs__nor2_1_156 VDD VSS sky130_fd_sc_hs__buf_8_11/X sky130_fd_sc_hs__nor2_1_156/Y
+ sky130_fd_sc_hs__xor2_1_69/B VSS VDD sky130_fd_sc_hs__nor2_1
Xsky130_fd_sc_hs__a22oi_1_32 VDD VSS sky130_fd_sc_hs__mux2_1_104/A1 sky130_fd_sc_hs__nand2_1_26/B
+ sky130_fd_sc_hs__a222o_1_3/C2 sky130_fd_sc_hs__buf_16_7/X sky130_fd_sc_hs__mux2_1_105/A0
+ VSS VDD sky130_fd_sc_hs__a22oi_1
Xsky130_fd_sc_hs__nor2_1_167 VDD VSS sky130_fd_sc_hs__nor2_1_167/B sky130_fd_sc_hs__or2_1_28/A
+ sky130_fd_sc_hs__and2_1_38/X VSS VDD sky130_fd_sc_hs__nor2_1
Xsky130_fd_sc_hs__a22oi_1_43 VDD VSS sky130_fd_sc_hs__mux2_1_129/A1 sky130_fd_sc_hs__and4_1_2/A
+ sky130_fd_sc_hs__buf_16_8/X sky130_fd_sc_hs__a22oi_1_6/A2 sky130_fd_sc_hs__mux2_1_134/A1
+ VSS VDD sky130_fd_sc_hs__a22oi_1
Xsky130_fd_sc_hs__nor2_1_178 VDD VSS sky130_fd_sc_hs__nor2_1_178/B sky130_fd_sc_hs__nor2_1_178/Y
+ sky130_fd_sc_hs__nor2_1_178/A VSS VDD sky130_fd_sc_hs__nor2_1
Xsky130_fd_sc_hs__a22oi_1_54 VDD VSS sky130_fd_sc_hs__mux2_1_153/A1 sky130_fd_sc_hs__and4_1_3/D
+ sky130_fd_sc_hs__a222o_1_3/C2 sky130_fd_sc_hs__a22oi_1_6/A2 sky130_fd_sc_hs__mux2_1_171/A1
+ VSS VDD sky130_fd_sc_hs__a22oi_1
Xsky130_fd_sc_hs__a22oi_1_65 VDD VSS sky130_fd_sc_hs__o22ai_1_2/A1 sky130_fd_sc_hs__a22oi_1_65/Y
+ sky130_fd_sc_hs__nor2b_1_49/Y sky130_fd_sc_hs__nor2b_1_51/Y sky130_fd_sc_hs__mux2i_1_9/A1
+ VSS VDD sky130_fd_sc_hs__a22oi_1
Xsky130_fd_sc_hs__a22oi_1_76 VDD VSS sky130_fd_sc_hs__mux2_1_276/A1 sky130_fd_sc_hs__nand3_1_33/B
+ sky130_fd_sc_hs__buf_16_9/X sky130_fd_sc_hs__buf_4_5/X sky130_fd_sc_hs__mux2_1_277/A0
+ VSS VDD sky130_fd_sc_hs__a22oi_1
Xsky130_fd_sc_hs__a22oi_1_87 VDD VSS sky130_fd_sc_hs__mux2_1_325/A0 sky130_fd_sc_hs__a22oi_1_87/Y
+ sky130_fd_sc_hs__buf_4_5/A sky130_fd_sc_hs__and3b_1_0/X sky130_fd_sc_hs__nor2_1_179/Y
+ VSS VDD sky130_fd_sc_hs__a22oi_1
Xsky130_fd_sc_hs__a22oi_1_98 VDD VSS sky130_fd_sc_hs__mux2_1_388/A0 sky130_fd_sc_hs__nand4_1_12/A
+ sky130_fd_sc_hs__nand2_1_51/B sky130_fd_sc_hs__a222o_1_3/C2 sky130_fd_sc_hs__mux2_1_390/A1
+ VSS VDD sky130_fd_sc_hs__a22oi_1
Xsky130_fd_sc_hs__mux2_1_107 VDD VSS sky130_fd_sc_hs__mux2_1_107/X sky130_fd_sc_hs__mux2_1_94/S
+ sky130_fd_sc_hs__xor2_1_5/A sky130_fd_sc_hs__a22o_1_61/B2 VSS VDD sky130_fd_sc_hs__mux2_1
Xsky130_fd_sc_hs__mux2_1_118 VDD VSS sky130_fd_sc_hs__mux2_1_118/X sky130_fd_sc_hs__mux2_1_99/S
+ sky130_fd_sc_hs__a22o_1_61/B2 sky130_fd_sc_hs__mux2_1_118/A1 VSS VDD sky130_fd_sc_hs__mux2_1
Xsky130_fd_sc_hs__mux2_1_129 VDD VSS sky130_fd_sc_hs__mux2_1_129/X sky130_fd_sc_hs__mux2_1_6/S
+ sky130_fd_sc_hs__a22o_1_60/B2 sky130_fd_sc_hs__mux2_1_129/A1 VSS VDD sky130_fd_sc_hs__mux2_1
Xsky130_fd_sc_hs__or3_1_8 VDD VSS sky130_fd_sc_hs__or3_1_8/A sky130_fd_sc_hs__or3_1_8/B
+ sky130_fd_sc_hs__or3_1_8/C sky130_fd_sc_hs__or3_1_8/X VSS VDD sky130_fd_sc_hs__or3_1
Xsky130_fd_sc_hs__a31o_1_3 VDD VSS sky130_fd_sc_hs__a31o_1_3/X sky130_fd_sc_hs__a31o_1_3/A3
+ sky130_fd_sc_hs__a31o_1_3/A2 sky130_fd_sc_hs__a31o_1_3/A1 sky130_fd_sc_hs__buf_8_12/X
+ VSS VDD sky130_fd_sc_hs__a31o_1
Xsky130_fd_sc_hs__o21a_1_13 VDD VSS sky130_fd_sc_hs__o21a_1_9/A1 sky130_fd_sc_hs__xor2_1_13/X
+ sky130_fd_sc_hs__o21a_1_13/B1 sky130_fd_sc_hs__a31oi_1_3/Y VSS VDD sky130_fd_sc_hs__o21a_1
Xsky130_fd_sc_hs__clkbuf_2_207 VDD VSS sky130_fd_sc_hs__clkinv_1_156/A sky130_fd_sc_hs__clkinv_2_11/A
+ VSS VDD sky130_fd_sc_hs__clkbuf_2
Xsky130_fd_sc_hs__o21a_1_24 VDD VSS sky130_fd_sc_hs__o21a_1_24/X sky130_fd_sc_hs__o21a_1_26/A2
+ sky130_fd_sc_hs__o221ai_1_2/Y sky130_fd_sc_hs__nor3_1_38/B VSS VDD sky130_fd_sc_hs__o21a_1
Xsky130_fd_sc_hs__clkbuf_2_218 VDD VSS sky130_fd_sc_hs__clkbuf_2_218/X sky130_fd_sc_hs__clkbuf_8_17/A
+ VSS VDD sky130_fd_sc_hs__clkbuf_2
Xsky130_fd_sc_hs__clkbuf_2_229 VDD VSS sky130_fd_sc_hs__clkbuf_2_229/X sky130_fd_sc_hs__clkbuf_8_17/A
+ VSS VDD sky130_fd_sc_hs__clkbuf_2
Xsky130_fd_sc_hs__nand2_1_207 VDD VSS sky130_fd_sc_hs__and3_1_14/A sky130_fd_sc_hs__xnor2_1_132/B
+ sky130_fd_sc_hs__a21bo_1_0/X VSS VDD sky130_fd_sc_hs__nand2_1
Xsky130_fd_sc_hs__nand2_1_218 VDD VSS sky130_fd_sc_hs__a22o_1_8/A2 sky130_fd_sc_hs__nand4_1_12/B
+ sky130_fd_sc_hs__nand2_1_218/A VSS VDD sky130_fd_sc_hs__nand2_1
Xsky130_fd_sc_hs__nand2_1_229 VDD VSS sky130_fd_sc_hs__xnor3_1_2/X sky130_fd_sc_hs__nand2_1_229/Y
+ sky130_fd_sc_hs__buf_8_36/X VSS VDD sky130_fd_sc_hs__nand2_1
Xsky130_fd_sc_hs__and2_1_14 VDD VSS sky130_fd_sc_hs__buf_1_66/X sky130_fd_sc_hs__and2_1_15/X
+ sky130_fd_sc_hs__and2_1_14/X VSS VDD sky130_fd_sc_hs__and2_1
Xsky130_fd_sc_hs__and2_1_25 VDD VSS sky130_fd_sc_hs__and2_1_25/A sky130_fd_sc_hs__or2_1_17/X
+ sky130_fd_sc_hs__and2_1_25/X VSS VDD sky130_fd_sc_hs__and2_1
Xsky130_fd_sc_hs__and2_1_36 VDD VSS sky130_fd_sc_hs__or2_1_21/A sky130_fd_sc_hs__or2_1_21/B
+ sky130_fd_sc_hs__and2_1_36/X VSS VDD sky130_fd_sc_hs__and2_1
Xsky130_fd_sc_hs__and2_1_47 VDD VSS sky130_fd_sc_hs__xor2_1_88/A sky130_fd_sc_hs__xor2_1_81/B
+ sky130_fd_sc_hs__and2_1_47/X VSS VDD sky130_fd_sc_hs__and2_1
Xsky130_fd_sc_hs__mux2_1_460 VDD VSS sky130_fd_sc_hs__mux2_1_460/X sky130_fd_sc_hs__buf_16_15/A
+ sky130_fd_sc_hs__a22o_1_91/B2 sky130_fd_sc_hs__nand2_1_228/A VSS VDD sky130_fd_sc_hs__mux2_1
Xsky130_fd_sc_hs__mux2_1_471 VDD VSS sky130_fd_sc_hs__mux2_1_471/X sky130_fd_sc_hs__buf_16_15/A
+ sky130_fd_sc_hs__a22o_1_94/B2 sky130_fd_sc_hs__mux2_1_471/A1 VSS VDD sky130_fd_sc_hs__mux2_1
Xsky130_fd_sc_hs__mux2_1_482 VDD VSS sky130_fd_sc_hs__mux2_1_482/X sky130_fd_sc_hs__mux2_1_8/S
+ sky130_fd_sc_hs__mux2_1_482/A0 sky130_fd_sc_hs__a22o_1_75/B2 VSS VDD sky130_fd_sc_hs__mux2_1
Xsky130_fd_sc_hs__nand3_1_16 VDD VSS sky130_fd_sc_hs__xor2_1_22/A sky130_fd_sc_hs__nor3_1_12/C
+ sky130_fd_sc_hs__xnor2_1_42/B sky130_fd_sc_hs__xnor2_1_42/A VSS VDD sky130_fd_sc_hs__nand3_1
Xsky130_fd_sc_hs__nand3_1_27 VDD VSS sky130_fd_sc_hs__nand4_1_7/D sky130_fd_sc_hs__nand3_1_27/Y
+ sky130_fd_sc_hs__nor3_1_39/B sky130_fd_sc_hs__nor3_1_37/C VSS VDD sky130_fd_sc_hs__nand3_1
Xsky130_fd_sc_hs__nand3_1_38 VDD VSS sky130_fd_sc_hs__nand3_1_38/C sky130_fd_sc_hs__and2_1_45/B
+ sky130_fd_sc_hs__nand3_1_38/B sky130_fd_sc_hs__nand3_1_38/A VSS VDD sky130_fd_sc_hs__nand3_1
Xsky130_fd_sc_hs__o2bb2ai_1_8 VDD VSS sky130_fd_sc_hs__o2bb2ai_1_8/Y sky130_fd_sc_hs__o21ai_1_21/Y
+ sky130_fd_sc_hs__maj3_1_7/A sky130_fd_sc_hs__a21o_1_0/B1 sky130_fd_sc_hs__a32o_1_2/B1
+ VSS VDD sky130_fd_sc_hs__o2bb2ai_1
Xsky130_fd_sc_hs__mux2i_1_13 VDD VSS sky130_fd_sc_hs__nand3_1_28/Y sky130_fd_sc_hs__nor3_1_41/A
+ sky130_fd_sc_hs__or2_1_22/B sky130_fd_sc_hs__mux2i_1_13/Y VSS VDD sky130_fd_sc_hs__mux2i_1
Xsky130_fd_sc_hs__buf_1_13 VDD VSS sky130_fd_sc_hs__buf_1_13/A srm_residue_o[9] VSS
+ VDD sky130_fd_sc_hs__buf_1
Xsky130_fd_sc_hs__buf_1_24 VDD VSS sky130_fd_sc_hs__buf_1_24/A w_wr_data[14] VSS VDD
+ sky130_fd_sc_hs__buf_1
Xsky130_fd_sc_hs__buf_1_35 VDD VSS sky130_fd_sc_hs__buf_1_35/A raw_code_o[8] VSS VDD
+ sky130_fd_sc_hs__buf_1
Xsky130_fd_sc_hs__buf_1_46 VDD VSS sky130_fd_sc_hs__buf_1_46/A calib_overrange_bits[9]
+ VSS VDD sky130_fd_sc_hs__buf_1
Xsky130_fd_sc_hs__buf_1_57 VDD VSS sky130_fd_sc_hs__buf_1_57/A calib_overrange_bits[6]
+ VSS VDD sky130_fd_sc_hs__buf_1
Xsky130_fd_sc_hs__buf_1_68 VDD VSS sky130_fd_sc_hs__buf_1_68/A sky130_fd_sc_hs__buf_1_68/X
+ VSS VDD sky130_fd_sc_hs__buf_1
Xsky130_fd_sc_hs__buf_1_79 VDD VSS sky130_fd_sc_hs__buf_1_79/A sky130_fd_sc_hs__buf_1_79/X
+ VSS VDD sky130_fd_sc_hs__buf_1
Xsky130_fd_sc_hs__a22o_1_60 VDD VSS sky130_fd_sc_hs__a22o_1_60/X sky130_fd_sc_hs__a22o_1_60/B2
+ sky130_fd_sc_hs__buf_8_17/X sky130_fd_sc_hs__buf_8_15/X sky130_fd_sc_hs__a22o_1_65/B2
+ VSS VDD sky130_fd_sc_hs__a22o_1
Xsky130_fd_sc_hs__a22o_1_71 VDD VSS sky130_fd_sc_hs__a22o_1_71/X sky130_fd_sc_hs__a22o_1_71/B2
+ sky130_fd_sc_hs__buf_8_16/A sky130_fd_sc_hs__buf_8_18/A sky130_fd_sc_hs__maj3_1_18/C
+ VSS VDD sky130_fd_sc_hs__a22o_1
Xsky130_fd_sc_hs__a22o_1_82 VDD VSS sky130_fd_sc_hs__a22o_1_82/X sky130_fd_sc_hs__a22o_1_82/B2
+ sky130_fd_sc_hs__a22o_1_93/B1 sky130_fd_sc_hs__a22o_1_93/A2 sky130_fd_sc_hs__maj3_1_31/C
+ VSS VDD sky130_fd_sc_hs__a22o_1
Xsky130_fd_sc_hs__a22o_1_93 VDD VSS sky130_fd_sc_hs__a22o_1_93/X sky130_fd_sc_hs__a22o_1_93/B2
+ sky130_fd_sc_hs__a22o_1_93/B1 sky130_fd_sc_hs__a22o_1_93/A2 sky130_fd_sc_hs__maj3_1_32/C
+ VSS VDD sky130_fd_sc_hs__a22o_1
Xsky130_fd_sc_hs__clkbuf_2_60 VDD VSS sky130_fd_sc_hs__clkinv_1_42/A sky130_fd_sc_hs__clkinv_4_1/A
+ VSS VDD sky130_fd_sc_hs__clkbuf_2
Xsky130_fd_sc_hs__a21o_1_2 VDD VSS sky130_fd_sc_hs__a21o_1_2/X sky130_fd_sc_hs__a31o_1_2/A1
+ sky130_fd_sc_hs__a21o_1_2/B1 sky130_fd_sc_hs__a21o_1_2/A2 VSS VDD sky130_fd_sc_hs__a21o_1
Xsky130_fd_sc_hs__clkbuf_2_71 VDD VSS sky130_fd_sc_hs__clkbuf_2_71/X sky130_fd_sc_hs__clkinv_4_2/A
+ VSS VDD sky130_fd_sc_hs__clkbuf_2
Xsky130_fd_sc_hs__clkbuf_2_82 VDD VSS sky130_fd_sc_hs__clkinv_2_4/A sky130_fd_sc_hs__clkinv_4_3/A
+ VSS VDD sky130_fd_sc_hs__clkbuf_2
Xsky130_fd_sc_hs__clkbuf_2_93 VDD VSS sky130_fd_sc_hs__clkbuf_2_93/X sky130_fd_sc_hs__clkinv_4_4/A
+ VSS VDD sky130_fd_sc_hs__clkbuf_2
Xsky130_fd_sc_hs__maj3_1_11 VDD VSS sky130_fd_sc_hs__xor2_1_18/A sky130_fd_sc_hs__xor2_1_18/B
+ sky130_fd_sc_hs__xor2_1_13/A sky130_fd_sc_hs__xor2_1_17/B VSS VDD sky130_fd_sc_hs__maj3_1
Xsky130_fd_sc_hs__maj3_1_22 VDD VSS sky130_fd_sc_hs__xor2_1_38/A sky130_fd_sc_hs__xor2_1_38/B
+ sky130_fd_sc_hs__xor2_1_37/A sky130_fd_sc_hs__maj3_1_22/C VSS VDD sky130_fd_sc_hs__maj3_1
Xsky130_fd_sc_hs__maj3_1_33 VDD VSS sky130_fd_sc_hs__xor2_1_63/A sky130_fd_sc_hs__xor2_1_63/B
+ sky130_fd_sc_hs__maj3_1_33/X sky130_fd_sc_hs__maj3_1_33/C VSS VDD sky130_fd_sc_hs__maj3_1
Xsky130_fd_sc_hs__maj3_1_44 VDD VSS sky130_fd_sc_hs__xor2_1_71/A sky130_fd_sc_hs__xor2_1_71/B
+ sky130_fd_sc_hs__xor2_1_73/A sky130_fd_sc_hs__maj3_1_44/C VSS VDD sky130_fd_sc_hs__maj3_1
Xsky130_fd_sc_hs__maj3_1_55 VDD VSS sky130_fd_sc_hs__xor2_1_86/A sky130_fd_sc_hs__xor2_1_86/B
+ sky130_fd_sc_hs__maj3_1_55/X sky130_fd_sc_hs__xor2_1_82/B VSS VDD sky130_fd_sc_hs__maj3_1
Xsky130_fd_sc_hs__maj3_1_66 VDD VSS sky130_fd_sc_hs__xor2_1_89/A sky130_fd_sc_hs__xor2_1_89/B
+ sky130_fd_sc_hs__maj3_1_66/X sky130_fd_sc_hs__maj3_1_66/C VSS VDD sky130_fd_sc_hs__maj3_1
Xsky130_fd_sc_hs__nand2_1_60 VDD VSS sky130_fd_sc_hs__or2_1_9/X sky130_fd_sc_hs__nand2_1_60/Y
+ sky130_fd_sc_hs__and2_1_15/X VSS VDD sky130_fd_sc_hs__nand2_1
Xsky130_fd_sc_hs__nand2_1_71 VDD VSS sky130_fd_sc_hs__o211ai_1_3/Y sky130_fd_sc_hs__nand2_1_71/Y
+ sky130_fd_sc_hs__buf_8_14/X VSS VDD sky130_fd_sc_hs__nand2_1
Xsky130_fd_sc_hs__mux2_1_290 VDD VSS sky130_fd_sc_hs__mux2_1_290/X sky130_fd_sc_hs__buf_4_0/X
+ sky130_fd_sc_hs__a222o_1_5/C2 sky130_fd_sc_hs__mux2_1_477/A1 VSS VDD sky130_fd_sc_hs__mux2_1
Xsky130_fd_sc_hs__nand2_1_82 VDD VSS sky130_fd_sc_hs__xor2_1_43/X sky130_fd_sc_hs__a31o_1_9/A1
+ sky130_fd_sc_hs__xnor2_1_67/A VSS VDD sky130_fd_sc_hs__nand2_1
Xsky130_fd_sc_hs__a222oi_1_12 VDD VSS sky130_fd_sc_hs__nand2_1_200/B sky130_fd_sc_hs__mux2_1_263/A1
+ sky130_fd_sc_hs__a222o_1_7/A2 sky130_fd_sc_hs__buf_4_7/X sky130_fd_sc_hs__mux2_1_265/A0
+ sky130_fd_sc_hs__and3_1_11/A sky130_fd_sc_hs__mux2_1_261/A1 VSS VDD sky130_fd_sc_hs__a222oi_1
Xsky130_fd_sc_hs__nand2_1_93 VDD VSS sky130_fd_sc_hs__xor2_1_56/A sky130_fd_sc_hs__nand2_1_99/A
+ sky130_fd_sc_hs__xor2_1_53/A VSS VDD sky130_fd_sc_hs__nand2_1
Xsky130_fd_sc_hs__a222oi_1_23 VDD VSS sky130_fd_sc_hs__mux2_1_398/A0 sky130_fd_sc_hs__nand2_1_33/B
+ sky130_fd_sc_hs__a22oi_1_6/B1 sky130_fd_sc_hs__a22o_1_8/B1 sky130_fd_sc_hs__xor2_1_88/B
+ sky130_fd_sc_hs__nand4_1_12/D sky130_fd_sc_hs__xor2_1_87/B VSS VDD sky130_fd_sc_hs__a222oi_1
Xsky130_fd_sc_hs__o31ai_1_15 VDD VSS sky130_fd_sc_hs__nor2_2_3/B sky130_fd_sc_hs__nor3_4_0/B
+ sky130_fd_sc_hs__o21ai_1_69/Y sky130_fd_sc_hs__o41ai_1_3/A2 sky130_fd_sc_hs__o31ai_1_15/Y
+ VSS VDD sky130_fd_sc_hs__o31ai_1
Xsky130_fd_sc_hs__nor2_1_9 VDD VSS sky130_fd_sc_hs__or2_1_2/A sky130_fd_sc_hs__nor2_1_9/Y
+ sky130_fd_sc_hs__nor2_1_9/A VSS VDD sky130_fd_sc_hs__nor2_1
Xsky130_fd_sc_hs__clkbuf_16_6 VDD VSS sky130_fd_sc_hs__clkbuf_16_6/X sky130_fd_sc_hs__clkbuf_8_2/X
+ VSS VDD sky130_fd_sc_hs__clkbuf_16
Xsky130_fd_sc_hs__a21oi_1_17 VDD VSS sky130_fd_sc_hs__and3_1_0/A sky130_fd_sc_hs__nor2_1_10/A
+ sky130_fd_sc_hs__nor3_1_7/Y sky130_fd_sc_hs__and3_1_0/B VSS VDD sky130_fd_sc_hs__a21oi_1
Xsky130_fd_sc_hs__a21oi_1_28 VDD VSS sky130_fd_sc_hs__o21ai_1_6/Y sky130_fd_sc_hs__a21oi_1_28/Y
+ sky130_fd_sc_hs__xnor2_1_25/Y sky130_fd_sc_hs__buf_8_10/X VSS VDD sky130_fd_sc_hs__a21oi_1
Xsky130_fd_sc_hs__a21oi_1_39 VDD VSS sky130_fd_sc_hs__xnor2_1_38/Y sky130_fd_sc_hs__nor2b_1_9/A
+ sky130_fd_sc_hs__nand3b_1_1/Y sky130_fd_sc_hs__nand3b_1_1/C VSS VDD sky130_fd_sc_hs__a21oi_1
Xsky130_fd_sc_hs__dfrtp_1_15 sky130_fd_sc_hs__clkbuf_4_4/X VDD VSS sky130_fd_sc_hs__mux2_1_7/A0
+ sky130_fd_sc_hs__clkbuf_2_4/X sky130_fd_sc_hs__mux2_1_7/X VSS VDD sky130_fd_sc_hs__dfrtp_1
Xsky130_fd_sc_hs__a22oi_1_103 VDD VSS sky130_fd_sc_hs__mux2_1_413/A1 sky130_fd_sc_hs__nand3_1_44/B
+ sky130_fd_sc_hs__buf_16_9/X sky130_fd_sc_hs__buf_16_7/X sky130_fd_sc_hs__mux2_1_410/A0
+ VSS VDD sky130_fd_sc_hs__a22oi_1
Xsky130_fd_sc_hs__dfrtp_1_26 sky130_fd_sc_hs__clkbuf_4_3/X VDD VSS sky130_fd_sc_hs__mux2_1_27/A0
+ sky130_fd_sc_hs__clkbuf_2_8/X sky130_fd_sc_hs__mux2_1_27/X VSS VDD sky130_fd_sc_hs__dfrtp_1
Xsky130_fd_sc_hs__dfrtp_1_37 sky130_fd_sc_hs__clkbuf_4_3/X VDD VSS sky130_fd_sc_hs__mux2_1_6/A1
+ sky130_fd_sc_hs__clkbuf_2_12/X sky130_fd_sc_hs__mux2_1_6/X VSS VDD sky130_fd_sc_hs__dfrtp_1
Xsky130_fd_sc_hs__a22oi_1_114 VDD VSS sky130_fd_sc_hs__mux2_1_442/A1 sky130_fd_sc_hs__nand3_1_45/C
+ sky130_fd_sc_hs__a22o_1_9/A2 sky130_fd_sc_hs__a22o_1_8/A2 sky130_fd_sc_hs__mux2_1_452/A0
+ VSS VDD sky130_fd_sc_hs__a22oi_1
Xsky130_fd_sc_hs__dfrtp_1_48 sky130_fd_sc_hs__clkbuf_4_0/X VDD VSS sky130_fd_sc_hs__mux2_1_81/A1
+ sky130_fd_sc_hs__clkbuf_2_24/X sky130_fd_sc_hs__mux2_1_81/X VSS VDD sky130_fd_sc_hs__dfrtp_1
Xsky130_fd_sc_hs__dfrtp_1_59 sky130_fd_sc_hs__clkbuf_4_1/X VDD VSS sky130_fd_sc_hs__mux2_1_60/A1
+ sky130_fd_sc_hs__clkbuf_2_23/X sky130_fd_sc_hs__mux2_1_60/X VSS VDD sky130_fd_sc_hs__dfrtp_1
Xsky130_fd_sc_hs__a311o_1_2 VDD VSS sky130_fd_sc_hs__and2_1_1/B sky130_fd_sc_hs__and2_1_2/X
+ sky130_fd_sc_hs__nor2_1_14/A sky130_fd_sc_hs__a311o_1_3/X sky130_fd_sc_hs__nor2_1_13/Y
+ sky130_fd_sc_hs__nand3_1_11/A VSS VDD sky130_fd_sc_hs__a311o_1
Xsky130_fd_sc_hs__a22o_1_105 VDD VSS sky130_fd_sc_hs__buf_1_117/A sky130_fd_sc_hs__buf_8_20/X
+ sky130_fd_sc_hs__nor2_1_148/Y sky130_fd_sc_hs__nand2_1_125/Y sky130_fd_sc_hs__nor3_1_41/A
+ VSS VDD sky130_fd_sc_hs__a22o_1
Xsky130_fd_sc_hs__a22o_1_116 VDD VSS sky130_fd_sc_hs__a22o_1_116/X sky130_fd_sc_hs__nor3_4_2/A
+ sky130_fd_sc_hs__buf_8_16/X sky130_fd_sc_hs__buf_8_18/X sky130_fd_sc_hs__or2_1_30/A
+ VSS VDD sky130_fd_sc_hs__a22o_1
Xsky130_fd_sc_hs__a22o_1_127 VDD VSS sky130_fd_sc_hs__a22o_1_127/X sky130_fd_sc_hs__xnor2_1_132/Y
+ sky130_fd_sc_hs__buf_8_26/X sky130_fd_sc_hs__o31ai_4_0/Y sky130_fd_sc_hs__xor2_1_86/A
+ VSS VDD sky130_fd_sc_hs__a22o_1
Xsky130_fd_sc_hs__a22o_1_138 VDD VSS sky130_fd_sc_hs__nor3_1_55/B sky130_fd_sc_hs__mux2_1_453/A1
+ sky130_fd_sc_hs__buf_16_8/X sky130_fd_sc_hs__a22oi_1_5/A2 sky130_fd_sc_hs__mux2_1_456/A0
+ VSS VDD sky130_fd_sc_hs__a22o_1
Xsky130_fd_sc_hs__nor3_4_7 VDD VSS sky130_fd_sc_hs__or3b_1_0/B sky130_fd_sc_hs__or2_1_29/X
+ sky130_fd_sc_hs__nor3_4_7/C sky130_fd_sc_hs__nor3_4_7/Y VSS VDD sky130_fd_sc_hs__nor3_4
Xsky130_fd_sc_hs__dfstp_1_2 sky130_fd_sc_hs__clkbuf_4_28/X VDD VSS sky130_fd_sc_hs__nor3_1_48/C
+ sky130_fd_sc_hs__dfstp_1_2/D sky130_fd_sc_hs__dfstp_1_2/CLK VSS VDD sky130_fd_sc_hs__dfstp_1
Xsky130_fd_sc_hs__nand4b_1_1 VDD VSS sky130_fd_sc_hs__nor3_1_37/C sky130_fd_sc_hs__nor3_1_37/B
+ sky130_fd_sc_hs__nor2_1_145/B sky130_fd_sc_hs__nor3_1_37/A sky130_fd_sc_hs__xor2_1_75/A
+ VSS VDD sky130_fd_sc_hs__nand4b_1
Xsky130_fd_sc_hs__o21ai_1_50 VDD VSS sky130_fd_sc_hs__o21ai_1_50/Y sky130_fd_sc_hs__buf_8_37/A
+ sky130_fd_sc_hs__buf_8_36/A sky130_fd_sc_hs__maj3_1_34/A VSS VDD sky130_fd_sc_hs__o21ai_1
Xsky130_fd_sc_hs__o21ai_1_61 VDD VSS sky130_fd_sc_hs__o21ai_1_61/Y sky130_fd_sc_hs__or2_1_30/A
+ sky130_fd_sc_hs__or2_1_21/X sky130_fd_sc_hs__nor3_1_44/B VSS VDD sky130_fd_sc_hs__o21ai_1
Xsky130_fd_sc_hs__o21ai_1_72 VDD VSS sky130_fd_sc_hs__o21ai_1_72/Y sky130_fd_sc_hs__buf_1_137/A
+ sky130_fd_sc_hs__o31a_1_4/X sky130_fd_sc_hs__nor2_1_161/Y VSS VDD sky130_fd_sc_hs__o21ai_1
Xsky130_fd_sc_hs__o21ai_1_83 VDD VSS sky130_fd_sc_hs__o21ai_1_83/Y sky130_fd_sc_hs__o21ai_1_83/B1
+ sky130_fd_sc_hs__nor2_2_3/B sky130_fd_sc_hs__nand4_1_8/Y VSS VDD sky130_fd_sc_hs__o21ai_1
Xsky130_fd_sc_hs__dfrtp_1_307 sky130_fd_sc_hs__clkbuf_4_13/X VDD VSS sky130_fd_sc_hs__buf_1_36/A
+ sky130_fd_sc_hs__clkbuf_2_84/X sky130_fd_sc_hs__buf_1_69/X VSS VDD sky130_fd_sc_hs__dfrtp_1
Xsky130_fd_sc_hs__o21ai_1_94 VDD VSS sky130_fd_sc_hs__o21ai_1_94/Y sky130_fd_sc_hs__o21ai_1_94/B1
+ sky130_fd_sc_hs__xnor2_1_131/Y sky130_fd_sc_hs__o21a_1_31/X VSS VDD sky130_fd_sc_hs__o21ai_1
Xsky130_fd_sc_hs__dfrtp_1_318 sky130_fd_sc_hs__clkbuf_4_13/X VDD VSS sky130_fd_sc_hs__xor2_1_30/A
+ sky130_fd_sc_hs__clkinv_1_59/A sky130_fd_sc_hs__mux2_1_201/X VSS VDD sky130_fd_sc_hs__dfrtp_1
Xsky130_fd_sc_hs__dfrtp_1_329 sky130_fd_sc_hs__clkbuf_4_14/X VDD VSS sky130_fd_sc_hs__xor2_1_33/B
+ sky130_fd_sc_hs__clkinv_2_6/A sky130_fd_sc_hs__mux2_1_208/X VSS VDD sky130_fd_sc_hs__dfrtp_1
Xsky130_fd_sc_hs__buf_16_2 sky130_fd_sc_hs__buf_16_2/X VDD VSS sky130_fd_sc_hs__buf_16_2/A
+ VSS VDD sky130_fd_sc_hs__buf_16
Xsky130_fd_sc_hs__dfrtp_1_830 sky130_fd_sc_hs__clkbuf_4_12/A VDD VSS sky130_fd_sc_hs__buf_1_10/A
+ sky130_fd_sc_hs__clkinv_1_5/A sky130_fd_sc_hs__a22o_1_19/X VSS VDD sky130_fd_sc_hs__dfrtp_1
Xsky130_fd_sc_hs__and2_1_8 VDD VSS sky130_fd_sc_hs__maj3_1_5/A sky130_fd_sc_hs__xor2_1_5/A
+ sky130_fd_sc_hs__and2_1_8/X VSS VDD sky130_fd_sc_hs__and2_1
Xsky130_fd_sc_hs__clkbuf_4_17 VDD VSS sky130_fd_sc_hs__buf_1_84/A sky130_fd_sc_hs__nor2_1_66/B
+ VSS VDD sky130_fd_sc_hs__clkbuf_4
Xsky130_fd_sc_hs__clkbuf_4_28 VDD VSS sky130_fd_sc_hs__buf_8_29/A sky130_fd_sc_hs__clkbuf_4_28/X
+ VSS VDD sky130_fd_sc_hs__clkbuf_4
Xsky130_fd_sc_hs__clkbuf_4_39 VDD VSS sky130_fd_sc_hs__nor2_2_11/Y sky130_fd_sc_hs__buf_16_8/A
+ VSS VDD sky130_fd_sc_hs__clkbuf_4
Xsky130_fd_sc_hs__clkbuf_8_4 VDD VSS sky130_fd_sc_hs__clkbuf_8_4/X sky130_fd_sc_hs__clkbuf_8_4/A
+ VSS VDD sky130_fd_sc_hs__clkbuf_8
Xsky130_fd_sc_hs__nand4bb_1_0 VDD VSS sky130_fd_sc_hs__xor2_1_75/A sky130_fd_sc_hs__nor3_1_37/C
+ sky130_fd_sc_hs__nor3_1_37/B sky130_fd_sc_hs__nor2_1_146/B sky130_fd_sc_hs__nor3_1_37/A
+ VSS VDD sky130_fd_sc_hs__nand4bb_1
Xsky130_fd_sc_hs__a21oi_1_160 VDD VSS sky130_fd_sc_hs__o22ai_1_6/A1 sky130_fd_sc_hs__a31oi_1_13/B1
+ sky130_fd_sc_hs__nand4_1_6/D sky130_fd_sc_hs__nor2b_1_39/Y VSS VDD sky130_fd_sc_hs__a21oi_1
Xsky130_fd_sc_hs__a21oi_1_171 VDD VSS sky130_fd_sc_hs__nor2_1_82/Y sky130_fd_sc_hs__dfrtp_1_810/D
+ sky130_fd_sc_hs__o21ai_1_115/Y sky130_fd_sc_hs__nor2_1_82/B VSS VDD sky130_fd_sc_hs__a21oi_1
Xsky130_fd_sc_hs__a21oi_1_182 VDD VSS sky130_fd_sc_hs__and2_1_38/X sky130_fd_sc_hs__o21ai_1_85/A1
+ sky130_fd_sc_hs__or2_1_28/B sky130_fd_sc_hs__or2_1_28/A VSS VDD sky130_fd_sc_hs__a21oi_1
Xsky130_fd_sc_hs__a21oi_1_193 VDD VSS sky130_fd_sc_hs__o21ai_1_96/Y sky130_fd_sc_hs__o21ai_1_98/A1
+ sky130_fd_sc_hs__xnor2_1_135/Y sky130_fd_sc_hs__buf_8_36/X VSS VDD sky130_fd_sc_hs__a21oi_1
Xsky130_fd_sc_hs__nor3_1_13 VDD VSS sky130_fd_sc_hs__nor3_1_13/Y sky130_fd_sc_hs__nor3_1_13/C
+ sky130_fd_sc_hs__nor3_1_13/B sky130_fd_sc_hs__or2_1_8/A VSS VDD sky130_fd_sc_hs__nor3_1
Xsky130_fd_sc_hs__nor3_1_24 VDD VSS sky130_fd_sc_hs__nor3_1_24/Y sky130_fd_sc_hs__nor3_1_24/C
+ sky130_fd_sc_hs__nor2_2_2/A sky130_fd_sc_hs__nor3_1_26/A VSS VDD sky130_fd_sc_hs__nor3_1
Xsky130_fd_sc_hs__nor3_1_35 VDD VSS sky130_fd_sc_hs__nor4b_1_1/A sky130_fd_sc_hs__nor3_1_35/C
+ sky130_fd_sc_hs__or2_1_22/A sky130_fd_sc_hs__nor3_1_36/B VSS VDD sky130_fd_sc_hs__nor3_1
Xsky130_fd_sc_hs__nor3_1_46 VDD VSS sky130_fd_sc_hs__nor3_1_46/Y sky130_fd_sc_hs__nor3_1_48/C
+ sky130_fd_sc_hs__nor3_1_46/B sky130_fd_sc_hs__nor3_1_48/A VSS VDD sky130_fd_sc_hs__nor3_1
Xsky130_fd_sc_hs__dfrtp_1_104 sky130_fd_sc_hs__buf_8_38/X VDD VSS sky130_fd_sc_hs__mux2_1_100/A0
+ sky130_fd_sc_hs__clkinv_1_19/A sky130_fd_sc_hs__mux2_1_100/X VSS VDD sky130_fd_sc_hs__dfrtp_1
Xsky130_fd_sc_hs__dfrtp_1_115 sky130_fd_sc_hs__clkbuf_4_2/X VDD VSS sky130_fd_sc_hs__mux2_1_111/A0
+ sky130_fd_sc_hs__clkinv_1_29/A sky130_fd_sc_hs__mux2_1_111/X VSS VDD sky130_fd_sc_hs__dfrtp_1
Xsky130_fd_sc_hs__dfrtp_1_126 sky130_fd_sc_hs__buf_8_1/X VDD VSS sky130_fd_sc_hs__maj3_1_1/A
+ sky130_fd_sc_hs__clkbuf_2_31/X sky130_fd_sc_hs__nand2_1_27/Y VSS VDD sky130_fd_sc_hs__dfrtp_1
Xsky130_fd_sc_hs__dfrtp_1_137 sky130_fd_sc_hs__clkbuf_4_3/A VDD VSS sky130_fd_sc_hs__mux2_1_127/A0
+ sky130_fd_sc_hs__clkinv_1_34/A sky130_fd_sc_hs__mux2_1_127/X VSS VDD sky130_fd_sc_hs__dfrtp_1
Xsky130_fd_sc_hs__dfrtp_1_148 sky130_fd_sc_hs__clkbuf_4_3/X VDD VSS sky130_fd_sc_hs__a222o_1_1/C2
+ sky130_fd_sc_hs__clkinv_1_34/A sky130_fd_sc_hs__mux2_1_180/X VSS VDD sky130_fd_sc_hs__dfrtp_1
Xsky130_fd_sc_hs__dfrtp_1_159 sky130_fd_sc_hs__clkbuf_4_5/X VDD VSS sky130_fd_sc_hs__nand2_1_52/A
+ sky130_fd_sc_hs__clkinv_1_39/A sky130_fd_sc_hs__mux2_1_148/X VSS VDD sky130_fd_sc_hs__dfrtp_1
Xsky130_fd_sc_hs__buf_8_6 VDD VSS sky130_fd_sc_hs__buf_8_6/X sky130_fd_sc_hs__buf_8_6/A
+ VSS VDD sky130_fd_sc_hs__buf_8
Xsky130_fd_sc_hs__clkinv_1_110 VDD VSS sky130_fd_sc_hs__clkinv_1_110/A sky130_fd_sc_hs__clkinv_1_110/Y
+ VSS VDD sky130_fd_sc_hs__clkinv_1
Xsky130_fd_sc_hs__clkinv_1_121 VDD VSS sky130_fd_sc_hs__clkinv_1_121/A sky130_fd_sc_hs__clkinv_1_121/Y
+ VSS VDD sky130_fd_sc_hs__clkinv_1
Xsky130_fd_sc_hs__clkinv_1_132 VDD VSS sky130_fd_sc_hs__clkinv_1_132/A sky130_fd_sc_hs__clkinv_1_132/Y
+ VSS VDD sky130_fd_sc_hs__clkinv_1
Xsky130_fd_sc_hs__clkinv_1_143 VDD VSS sky130_fd_sc_hs__clkinv_1_143/A sky130_fd_sc_hs__clkinv_1_143/Y
+ VSS VDD sky130_fd_sc_hs__clkinv_1
Xsky130_fd_sc_hs__clkinv_1_154 VDD VSS sky130_fd_sc_hs__clkinv_1_154/A sky130_fd_sc_hs__clkinv_1_154/Y
+ VSS VDD sky130_fd_sc_hs__clkinv_1
Xsky130_fd_sc_hs__o311ai_1_17 VDD VSS sky130_fd_sc_hs__or2_1_24/B sky130_fd_sc_hs__or3_1_1/X
+ sky130_fd_sc_hs__buf_1_135/A sky130_fd_sc_hs__o31a_1_5/B1 sky130_fd_sc_hs__o311ai_1_17/Y
+ sky130_fd_sc_hs__or2_1_26/A VSS VDD sky130_fd_sc_hs__o311ai_1
Xsky130_fd_sc_hs__dfrtp_1_660 sky130_fd_sc_hs__clkbuf_4_33/X VDD VSS sky130_fd_sc_hs__mux2_1_363/A0
+ sky130_fd_sc_hs__clkbuf_2_201/X sky130_fd_sc_hs__mux2_1_363/X VSS VDD sky130_fd_sc_hs__dfrtp_1
Xsky130_fd_sc_hs__nor2_1_102 VDD VSS sky130_fd_sc_hs__nor2_1_103/Y sky130_fd_sc_hs__o21a_1_20/A1
+ sky130_fd_sc_hs__and2_1_28/X VSS VDD sky130_fd_sc_hs__nor2_1
Xsky130_fd_sc_hs__dfrtp_1_671 sky130_fd_sc_hs__clkbuf_4_35/X VDD VSS sky130_fd_sc_hs__mux2_1_373/A0
+ sky130_fd_sc_hs__clkbuf_2_210/X sky130_fd_sc_hs__mux2_1_373/X VSS VDD sky130_fd_sc_hs__dfrtp_1
Xsky130_fd_sc_hs__nor2_1_113 VDD VSS sky130_fd_sc_hs__buf_8_21/X sky130_fd_sc_hs__nor2_1_113/Y
+ sky130_fd_sc_hs__xor2_1_78/A VSS VDD sky130_fd_sc_hs__nor2_1
Xsky130_fd_sc_hs__dfrtp_1_682 sky130_fd_sc_hs__clkbuf_4_33/X VDD VSS sky130_fd_sc_hs__mux2_1_398/A0
+ sky130_fd_sc_hs__clkinv_1_156/A sky130_fd_sc_hs__mux2_1_398/X VSS VDD sky130_fd_sc_hs__dfrtp_1
Xsky130_fd_sc_hs__nor2_1_124 VDD VSS sky130_fd_sc_hs__nor2_1_124/B sky130_fd_sc_hs__nor2_1_124/Y
+ sky130_fd_sc_hs__nor2_1_124/A VSS VDD sky130_fd_sc_hs__nor2_1
Xsky130_fd_sc_hs__dfrtp_1_1 sky130_fd_sc_hs__clkbuf_4_4/X VDD VSS sky130_fd_sc_hs__dfrtp_1_1/Q
+ sky130_fd_sc_hs__clkinv_1_0/A sky130_fd_sc_hs__mux2_1_38/X VSS VDD sky130_fd_sc_hs__dfrtp_1
Xsky130_fd_sc_hs__dfrtp_1_693 sky130_fd_sc_hs__clkbuf_4_35/X VDD VSS sky130_fd_sc_hs__mux2_1_380/A0
+ sky130_fd_sc_hs__clkbuf_2_209/X sky130_fd_sc_hs__mux2_1_380/X VSS VDD sky130_fd_sc_hs__dfrtp_1
Xsky130_fd_sc_hs__nor2_1_135 VDD VSS sky130_fd_sc_hs__o21a_1_26/A2 sky130_fd_sc_hs__nor2_1_135/Y
+ sky130_fd_sc_hs__xor2_1_75/A VSS VDD sky130_fd_sc_hs__nor2_1
Xsky130_fd_sc_hs__a22oi_1_11 VDD VSS sky130_fd_sc_hs__mux2_1_20/A0 sky130_fd_sc_hs__nand3_1_3/C
+ sky130_fd_sc_hs__a22oi_1_7/B1 sky130_fd_sc_hs__a22oi_1_5/A2 sky130_fd_sc_hs__mux2_1_23/A0
+ VSS VDD sky130_fd_sc_hs__a22oi_1
Xsky130_fd_sc_hs__nor2_1_146 VDD VSS sky130_fd_sc_hs__nor2_1_146/B sky130_fd_sc_hs__mux2i_1_6/S
+ sky130_fd_sc_hs__nor2_1_146/A VSS VDD sky130_fd_sc_hs__nor2_1
Xsky130_fd_sc_hs__a22oi_1_22 VDD VSS sky130_fd_sc_hs__mux2_1_184/A1 sky130_fd_sc_hs__nand2_1_25/A
+ sky130_fd_sc_hs__buf_16_8/X sky130_fd_sc_hs__nand2_1_33/B sky130_fd_sc_hs__dfrtp_1_63/Q
+ VSS VDD sky130_fd_sc_hs__a22oi_1
Xsky130_fd_sc_hs__nor2_1_157 VDD VSS sky130_fd_sc_hs__nor3_1_26/B sky130_fd_sc_hs__nor2_1_157/Y
+ sky130_fd_sc_hs__nor3_1_26/A VSS VDD sky130_fd_sc_hs__nor2_1
Xsky130_fd_sc_hs__a22oi_1_33 VDD VSS sky130_fd_sc_hs__mux2_1_99/A1 sky130_fd_sc_hs__nand2_1_24/A
+ sky130_fd_sc_hs__buf_16_9/X sky130_fd_sc_hs__buf_16_7/X sky130_fd_sc_hs__mux2_1_204/A0
+ VSS VDD sky130_fd_sc_hs__a22oi_1
Xsky130_fd_sc_hs__nor2_1_168 VDD VSS sky130_fd_sc_hs__maj3_1_52/B sky130_fd_sc_hs__nor3_1_25/A
+ sky130_fd_sc_hs__maj3_1_52/A VSS VDD sky130_fd_sc_hs__nor2_1
Xsky130_fd_sc_hs__a22oi_1_44 VDD VSS sky130_fd_sc_hs__a21oi_1_45/Y sky130_fd_sc_hs__o31ai_1_9/A2
+ sky130_fd_sc_hs__or2_1_7/X sky130_fd_sc_hs__o21a_1_10/X sky130_fd_sc_hs__o311ai_1_5/Y
+ VSS VDD sky130_fd_sc_hs__a22oi_1
Xsky130_fd_sc_hs__nor2_1_179 VDD VSS sky130_fd_sc_hs__or3b_1_1/B sky130_fd_sc_hs__nor2_1_179/Y
+ sky130_fd_sc_hs__or3b_1_1/A VSS VDD sky130_fd_sc_hs__nor2_1
Xsky130_fd_sc_hs__a22oi_1_55 VDD VSS sky130_fd_sc_hs__mux2_1_70/A1 sky130_fd_sc_hs__nand2_1_17/B
+ sky130_fd_sc_hs__a22oi_1_6/A2 sky130_fd_sc_hs__a222o_1_2/A2 sky130_fd_sc_hs__mux2_1_90/A0
+ VSS VDD sky130_fd_sc_hs__a22oi_1
Xsky130_fd_sc_hs__a22oi_1_66 VDD VSS sky130_fd_sc_hs__nand2_1_156/A sky130_fd_sc_hs__a22oi_1_66/Y
+ sky130_fd_sc_hs__nor2b_1_51/Y sky130_fd_sc_hs__nor2_1_176/Y sky130_fd_sc_hs__o21ai_1_63/B1
+ VSS VDD sky130_fd_sc_hs__a22oi_1
Xsky130_fd_sc_hs__a22oi_1_77 VDD VSS sky130_fd_sc_hs__mux2_1_305/A1 sky130_fd_sc_hs__and4_1_6/B
+ sky130_fd_sc_hs__buf_16_8/X sky130_fd_sc_hs__a22o_1_8/B1 sky130_fd_sc_hs__and2_1_9/A
+ VSS VDD sky130_fd_sc_hs__a22oi_1
Xsky130_fd_sc_hs__a22oi_1_88 VDD VSS sky130_fd_sc_hs__mux2_1_333/A1 sky130_fd_sc_hs__a22oi_1_88/Y
+ sky130_fd_sc_hs__clkbuf_8_14/X sky130_fd_sc_hs__clkbuf_8_15/X sky130_fd_sc_hs__mux2_1_338/A0
+ VSS VDD sky130_fd_sc_hs__a22oi_1
Xsky130_fd_sc_hs__a22oi_1_99 VDD VSS sky130_fd_sc_hs__mux2_1_402/A0 sky130_fd_sc_hs__nand3_1_43/B
+ sky130_fd_sc_hs__nand2_1_33/B sky130_fd_sc_hs__a22oi_1_6/A2 sky130_fd_sc_hs__mux2_1_401/A1
+ VSS VDD sky130_fd_sc_hs__a22oi_1
Xsky130_fd_sc_hs__nor2_1_90 VDD VSS sky130_fd_sc_hs__buf_8_21/A sky130_fd_sc_hs__nor2_1_90/Y
+ sky130_fd_sc_hs__xor2_1_63/A VSS VDD sky130_fd_sc_hs__nor2_1
Xsky130_fd_sc_hs__mux2_1_108 VDD VSS sky130_fd_sc_hs__mux2_1_108/X sky130_fd_sc_hs__buf_16_3/A
+ sky130_fd_sc_hs__a22o_1_64/B2 sky130_fd_sc_hs__mux2_1_108/A1 VSS VDD sky130_fd_sc_hs__mux2_1
Xsky130_fd_sc_hs__mux2_1_119 VDD VSS sky130_fd_sc_hs__mux2_1_119/X sky130_fd_sc_hs__buf_16_0/X
+ sky130_fd_sc_hs__maj3_1_1/C sky130_fd_sc_hs__mux2_1_96/A0 VSS VDD sky130_fd_sc_hs__mux2_1
Xsky130_fd_sc_hs__or3_1_9 VDD VSS sky130_fd_sc_hs__or3_1_9/A sky130_fd_sc_hs__or3_1_9/B
+ sky130_fd_sc_hs__or3_1_9/C sky130_fd_sc_hs__or3_1_9/X VSS VDD sky130_fd_sc_hs__or3_1
Xsky130_fd_sc_hs__a31o_1_4 VDD VSS sky130_fd_sc_hs__or2_1_11/B sky130_fd_sc_hs__a31o_1_4/A3
+ sky130_fd_sc_hs__a31o_1_5/A2 sky130_fd_sc_hs__a31o_1_5/A1 sky130_fd_sc_hs__a31o_1_4/B1
+ VSS VDD sky130_fd_sc_hs__a31o_1
Xsky130_fd_sc_hs__dfrtp_1_490 sky130_fd_sc_hs__clkbuf_4_23/X VDD VSS sky130_fd_sc_hs__o22ai_1_2/A1
+ sky130_fd_sc_hs__clkbuf_2_155/X sky130_fd_sc_hs__dfrtp_1_490/D VSS VDD sky130_fd_sc_hs__dfrtp_1
Xsky130_fd_sc_hs__o21a_1_14 VDD VSS sky130_fd_sc_hs__o21a_1_14/X sky130_fd_sc_hs__nor3_1_20/C
+ sky130_fd_sc_hs__nor3_1_20/B sky130_fd_sc_hs__nor3_1_20/A VSS VDD sky130_fd_sc_hs__o21a_1
Xsky130_fd_sc_hs__clkbuf_2_208 VDD VSS sky130_fd_sc_hs__clkinv_1_157/A sky130_fd_sc_hs__inv_8_1/A
+ VSS VDD sky130_fd_sc_hs__clkbuf_2
Xsky130_fd_sc_hs__o21a_1_25 VDD VSS sky130_fd_sc_hs__o21a_1_25/X sky130_fd_sc_hs__o21a_1_26/A2
+ sky130_fd_sc_hs__o221ai_1_3/Y sky130_fd_sc_hs__nor3_1_37/A VSS VDD sky130_fd_sc_hs__o21a_1
Xsky130_fd_sc_hs__clkbuf_2_219 VDD VSS sky130_fd_sc_hs__clkbuf_2_219/X sky130_fd_sc_hs__clkbuf_8_17/A
+ VSS VDD sky130_fd_sc_hs__clkbuf_2
Xsky130_fd_sc_hs__nand2_1_208 VDD VSS sky130_fd_sc_hs__a211o_1_2/X sky130_fd_sc_hs__o21ai_1_95/B1
+ sky130_fd_sc_hs__xor2_1_89/A VSS VDD sky130_fd_sc_hs__nand2_1
Xsky130_fd_sc_hs__nand2_1_219 VDD VSS sky130_fd_sc_hs__a22o_1_8/A2 sky130_fd_sc_hs__nand3_1_44/A
+ sky130_fd_sc_hs__nand2_1_219/A VSS VDD sky130_fd_sc_hs__nand2_1
Xsky130_fd_sc_hs__and2_1_15 VDD VSS sky130_fd_sc_hs__and2_1_15/A sky130_fd_sc_hs__and3_1_7/X
+ sky130_fd_sc_hs__and2_1_15/X VSS VDD sky130_fd_sc_hs__and2_1
Xsky130_fd_sc_hs__and2_1_26 VDD VSS sky130_fd_sc_hs__and2_1_26/A sky130_fd_sc_hs__and2_1_26/B
+ sky130_fd_sc_hs__and2_1_26/X VSS VDD sky130_fd_sc_hs__and2_1
Xsky130_fd_sc_hs__and2_1_37 VDD VSS sky130_fd_sc_hs__or2_1_30/A sky130_fd_sc_hs__nor3_1_32/B
+ sky130_fd_sc_hs__and2_1_37/X VSS VDD sky130_fd_sc_hs__and2_1
Xsky130_fd_sc_hs__and2_1_48 VDD VSS sky130_fd_sc_hs__maj3_1_56/A sky130_fd_sc_hs__xor2_1_83/A
+ sky130_fd_sc_hs__and2_1_48/X VSS VDD sky130_fd_sc_hs__and2_1
Xsky130_fd_sc_hs__a211oi_1_10 VDD VSS sky130_fd_sc_hs__and2_1_45/X sky130_fd_sc_hs__or3_1_8/C
+ sky130_fd_sc_hs__nor2_1_170/A sky130_fd_sc_hs__and2_1_46/B sky130_fd_sc_hs__and2_1_46/A
+ VSS VDD sky130_fd_sc_hs__a211oi_1
Xsky130_fd_sc_hs__mux2_1_450 VDD VSS sky130_fd_sc_hs__mux2_1_450/X sky130_fd_sc_hs__buf_16_4/A
+ sky130_fd_sc_hs__mux2_1_450/A0 sky130_fd_sc_hs__a22o_1_91/B2 VSS VDD sky130_fd_sc_hs__mux2_1
Xsky130_fd_sc_hs__mux2_1_461 VDD VSS sky130_fd_sc_hs__mux2_1_461/X sky130_fd_sc_hs__buf_16_12/A
+ sky130_fd_sc_hs__mux2_1_461/A0 sky130_fd_sc_hs__a22o_1_92/B2 VSS VDD sky130_fd_sc_hs__mux2_1
Xsky130_fd_sc_hs__mux2_1_472 VDD VSS sky130_fd_sc_hs__mux2_1_472/X sky130_fd_sc_hs__or2_1_25/X
+ sky130_fd_sc_hs__dfrtp_2_3/Q sky130_fd_sc_hs__mux2_1_472/A1 VSS VDD sky130_fd_sc_hs__mux2_1
Xsky130_fd_sc_hs__mux2_1_483 VDD VSS sky130_fd_sc_hs__mux2_1_483/X sky130_fd_sc_hs__mux2_1_5/S
+ sky130_fd_sc_hs__mux2_1_483/A0 sky130_fd_sc_hs__a22o_1_64/B2 VSS VDD sky130_fd_sc_hs__mux2_1
Xsky130_fd_sc_hs__buf_4_0 VDD VSS sky130_fd_sc_hs__buf_4_0/A sky130_fd_sc_hs__buf_4_0/X
+ VSS VDD sky130_fd_sc_hs__buf_4
Xsky130_fd_sc_hs__nand3_1_17 VDD VSS sky130_fd_sc_hs__and3_1_5/C sky130_fd_sc_hs__nand3_1_17/Y
+ sky130_fd_sc_hs__and3_1_5/B sky130_fd_sc_hs__and3_1_5/A VSS VDD sky130_fd_sc_hs__nand3_1
Xsky130_fd_sc_hs__nand3_1_28 VDD VSS sky130_fd_sc_hs__nand4_1_7/D sky130_fd_sc_hs__nand3_1_28/Y
+ sky130_fd_sc_hs__nor3_1_39/C sky130_fd_sc_hs__nor3_1_37/C VSS VDD sky130_fd_sc_hs__nand3_1
Xsky130_fd_sc_hs__nand3_1_39 VDD VSS sky130_fd_sc_hs__a32o_1_9/A3 sky130_fd_sc_hs__nand3_1_39/Y
+ sky130_fd_sc_hs__nor2_1_176/Y sky130_fd_sc_hs__nand4b_1_2/B VSS VDD sky130_fd_sc_hs__nand3_1
Xsky130_fd_sc_hs__o2bb2ai_1_9 VDD VSS sky130_fd_sc_hs__o2bb2ai_1_9/Y sky130_fd_sc_hs__xor2_1_22/X
+ sky130_fd_sc_hs__a22o_1_21/B2 sky130_fd_sc_hs__nand3_1_18/Y sky130_fd_sc_hs__nor2_1_45/B
+ VSS VDD sky130_fd_sc_hs__o2bb2ai_1
Xsky130_fd_sc_hs__mux2i_1_14 VDD VSS sky130_fd_sc_hs__nor2_1_143/Y sky130_fd_sc_hs__or2_1_22/B
+ sky130_fd_sc_hs__mux2i_1_14/A0 sky130_fd_sc_hs__mux2i_1_14/Y VSS VDD sky130_fd_sc_hs__mux2i_1
Xsky130_fd_sc_hs__buf_1_14 VDD VSS sky130_fd_sc_hs__buf_1_14/A srm_residue_o[0] VSS
+ VDD sky130_fd_sc_hs__buf_1
Xsky130_fd_sc_hs__buf_1_25 VDD VSS sky130_fd_sc_hs__buf_1_25/A w_wr_data[18] VSS VDD
+ sky130_fd_sc_hs__buf_1
Xsky130_fd_sc_hs__buf_1_36 VDD VSS sky130_fd_sc_hs__buf_1_36/A raw_code_o[0] VSS VDD
+ sky130_fd_sc_hs__buf_1
Xsky130_fd_sc_hs__buf_1_47 VDD VSS sky130_fd_sc_hs__buf_1_47/A calib_overrange_bits[19]
+ VSS VDD sky130_fd_sc_hs__buf_1
Xsky130_fd_sc_hs__buf_1_58 VDD VSS sky130_fd_sc_hs__buf_1_58/A w_wr_addr[1] VSS VDD
+ sky130_fd_sc_hs__buf_1
Xsky130_fd_sc_hs__buf_1_69 VDD VSS sky130_fd_sc_hs__buf_1_69/A sky130_fd_sc_hs__buf_1_69/X
+ VSS VDD sky130_fd_sc_hs__buf_1
Xsky130_fd_sc_hs__a22o_1_50 VDD VSS sky130_fd_sc_hs__a22o_1_50/X sky130_fd_sc_hs__a22o_1_50/B2
+ sky130_fd_sc_hs__a22o_1_93/B1 sky130_fd_sc_hs__a22o_1_93/A2 sky130_fd_sc_hs__maj3_1_23/C
+ VSS VDD sky130_fd_sc_hs__a22o_1
Xsky130_fd_sc_hs__a22o_1_61 VDD VSS sky130_fd_sc_hs__a22o_1_61/X sky130_fd_sc_hs__a22o_1_61/B2
+ sky130_fd_sc_hs__buf_8_17/X sky130_fd_sc_hs__buf_8_15/X sky130_fd_sc_hs__a22o_1_66/B2
+ VSS VDD sky130_fd_sc_hs__a22o_1
Xsky130_fd_sc_hs__a22o_1_72 VDD VSS sky130_fd_sc_hs__a22o_1_72/X sky130_fd_sc_hs__mux2_1_96/A0
+ sky130_fd_sc_hs__buf_8_17/X sky130_fd_sc_hs__buf_8_15/X sky130_fd_sc_hs__a22o_1_72/A1
+ VSS VDD sky130_fd_sc_hs__a22o_1
Xsky130_fd_sc_hs__a22o_1_83 VDD VSS sky130_fd_sc_hs__a22o_1_83/X sky130_fd_sc_hs__a22o_1_97/A1
+ sky130_fd_sc_hs__a22o_1_93/B1 sky130_fd_sc_hs__a22o_1_93/A2 sky130_fd_sc_hs__maj3_1_49/C
+ VSS VDD sky130_fd_sc_hs__a22o_1
Xsky130_fd_sc_hs__a22o_1_94 VDD VSS sky130_fd_sc_hs__a22o_1_94/X sky130_fd_sc_hs__a22o_1_94/B2
+ sky130_fd_sc_hs__buf_8_17/X sky130_fd_sc_hs__buf_8_15/A sky130_fd_sc_hs__a22o_1_94/A1
+ VSS VDD sky130_fd_sc_hs__a22o_1
Xsky130_fd_sc_hs__clkbuf_2_50 VDD VSS sky130_fd_sc_hs__clkbuf_4_4/A sky130_fd_sc_hs__buf_8_38/X
+ VSS VDD sky130_fd_sc_hs__clkbuf_2
Xsky130_fd_sc_hs__clkbuf_2_61 VDD VSS sky130_fd_sc_hs__clkbuf_2_61/X sky130_fd_sc_hs__buf_8_38/A
+ VSS VDD sky130_fd_sc_hs__clkbuf_2
Xsky130_fd_sc_hs__clkbuf_2_72 VDD VSS sky130_fd_sc_hs__clkbuf_2_72/X sky130_fd_sc_hs__clkinv_4_2/A
+ VSS VDD sky130_fd_sc_hs__clkbuf_2
Xsky130_fd_sc_hs__a21o_1_3 VDD VSS sky130_fd_sc_hs__a21o_1_3/X sky130_fd_sc_hs__a21o_1_3/A1
+ sky130_fd_sc_hs__maj3_1_27/X sky130_fd_sc_hs__or2_1_12/X VSS VDD sky130_fd_sc_hs__a21o_1
Xsky130_fd_sc_hs__clkbuf_2_83 VDD VSS sky130_fd_sc_hs__clkinv_1_54/A sky130_fd_sc_hs__clkinv_4_3/A
+ VSS VDD sky130_fd_sc_hs__clkbuf_2
Xsky130_fd_sc_hs__nand4_1_0 VDD VSS sky130_fd_sc_hs__nand4_1_0/C sky130_fd_sc_hs__nor2_1_31/B
+ sky130_fd_sc_hs__nand4_1_0/D sky130_fd_sc_hs__and4_1_3/X sky130_fd_sc_hs__nand4_1_0/A
+ VSS VDD sky130_fd_sc_hs__nand4_1
Xsky130_fd_sc_hs__clkbuf_2_94 VDD VSS sky130_fd_sc_hs__clkbuf_2_94/X sky130_fd_sc_hs__clkinv_4_4/A
+ VSS VDD sky130_fd_sc_hs__clkbuf_2
Xsky130_fd_sc_hs__maj3_1_12 VDD VSS sky130_fd_sc_hs__xor2_1_25/A sky130_fd_sc_hs__xor2_1_25/B
+ sky130_fd_sc_hs__maj3_1_12/X sky130_fd_sc_hs__maj3_1_12/C VSS VDD sky130_fd_sc_hs__maj3_1
Xsky130_fd_sc_hs__maj3_1_23 VDD VSS sky130_fd_sc_hs__xor2_1_42/A sky130_fd_sc_hs__xor2_1_42/B
+ sky130_fd_sc_hs__xor2_1_36/A sky130_fd_sc_hs__maj3_1_23/C VSS VDD sky130_fd_sc_hs__maj3_1
Xsky130_fd_sc_hs__maj3_1_34 VDD VSS sky130_fd_sc_hs__maj3_1_34/A sky130_fd_sc_hs__xor2_1_65/A
+ sky130_fd_sc_hs__maj3_1_34/X sky130_fd_sc_hs__xor2_1_65/B VSS VDD sky130_fd_sc_hs__maj3_1
Xsky130_fd_sc_hs__maj3_1_45 VDD VSS sky130_fd_sc_hs__xor3_1_0/A sky130_fd_sc_hs__xor3_1_0/B
+ sky130_fd_sc_hs__maj3_1_45/X sky130_fd_sc_hs__xor3_1_0/C VSS VDD sky130_fd_sc_hs__maj3_1
Xsky130_fd_sc_hs__maj3_1_56 VDD VSS sky130_fd_sc_hs__maj3_1_56/A sky130_fd_sc_hs__xor2_1_83/A
+ sky130_fd_sc_hs__maj3_1_68/B sky130_fd_sc_hs__xor2_1_83/B VSS VDD sky130_fd_sc_hs__maj3_1
Xsky130_fd_sc_hs__maj3_1_67 VDD VSS sky130_fd_sc_hs__xnor3_1_1/A sky130_fd_sc_hs__xnor3_1_1/B
+ sky130_fd_sc_hs__xnor3_1_2/B sky130_fd_sc_hs__xnor3_1_1/C VSS VDD sky130_fd_sc_hs__maj3_1
Xsky130_fd_sc_hs__nand2_1_50 VDD VSS sky130_fd_sc_hs__maj3_1_7/B sky130_fd_sc_hs__nand2_1_50/Y
+ sky130_fd_sc_hs__maj3_1_7/A VSS VDD sky130_fd_sc_hs__nand2_1
Xsky130_fd_sc_hs__mux2_1_280 VDD VSS sky130_fd_sc_hs__mux2_1_280/X sky130_fd_sc_hs__o31ai_2_0/B1
+ sky130_fd_sc_hs__buf_1_150/A sky130_fd_sc_hs__a22o_1_92/B2 VSS VDD sky130_fd_sc_hs__mux2_1
Xsky130_fd_sc_hs__nand2_1_61 VDD VSS sky130_fd_sc_hs__and3_1_7/X sky130_fd_sc_hs__nor3_1_15/A
+ sky130_fd_sc_hs__and2_1_15/A VSS VDD sky130_fd_sc_hs__nand2_1
Xsky130_fd_sc_hs__nand2_1_72 VDD VSS sky130_fd_sc_hs__a31o_1_3/A2 sky130_fd_sc_hs__nand2_1_72/Y
+ sky130_fd_sc_hs__nand2_1_73/A VSS VDD sky130_fd_sc_hs__nand2_1
Xsky130_fd_sc_hs__mux2_1_291 VDD VSS sky130_fd_sc_hs__mux2_1_291/X sky130_fd_sc_hs__o31ai_2_0/B1
+ sky130_fd_sc_hs__buf_1_164/A sky130_fd_sc_hs__a22o_1_94/B2 VSS VDD sky130_fd_sc_hs__mux2_1
Xsky130_fd_sc_hs__nand2_1_83 VDD VSS sky130_fd_sc_hs__xor2_1_45/X sky130_fd_sc_hs__a21o_1_8/A1
+ sky130_fd_sc_hs__nand2_1_85/Y VSS VDD sky130_fd_sc_hs__nand2_1
Xsky130_fd_sc_hs__a222oi_1_13 VDD VSS sky130_fd_sc_hs__mux2_1_275/A0 sky130_fd_sc_hs__nand2_1_51/B
+ sky130_fd_sc_hs__buf_4_4/X sky130_fd_sc_hs__a222o_1_2/A2 sky130_fd_sc_hs__mux2_1_278/A0
+ sky130_fd_sc_hs__nand3_1_33/A sky130_fd_sc_hs__xor2_1_91/B VSS VDD sky130_fd_sc_hs__a222oi_1
Xsky130_fd_sc_hs__nand2_1_94 VDD VSS sky130_fd_sc_hs__or2_1_15/X sky130_fd_sc_hs__xnor2_1_83/B
+ sky130_fd_sc_hs__nand2_1_98/Y VSS VDD sky130_fd_sc_hs__nand2_1
Xsky130_fd_sc_hs__a222oi_1_24 VDD VSS sky130_fd_sc_hs__mux2_1_394/A1 sky130_fd_sc_hs__a222o_1_3/C2
+ sky130_fd_sc_hs__nand2_1_51/B sky130_fd_sc_hs__a22o_1_8/A2 sky130_fd_sc_hs__mux2_1_392/A0
+ sky130_fd_sc_hs__a41o_1_0/A4 sky130_fd_sc_hs__mux2_1_395/A0 VSS VDD sky130_fd_sc_hs__a222oi_1
Xsky130_fd_sc_hs__o31ai_1_16 VDD VSS sky130_fd_sc_hs__or2_1_25/A sky130_fd_sc_hs__o41ai_1_3/A2
+ sky130_fd_sc_hs__o21ai_1_70/Y sky130_fd_sc_hs__or3_1_5/B sky130_fd_sc_hs__o31ai_1_16/Y
+ VSS VDD sky130_fd_sc_hs__o31ai_1
Xsky130_fd_sc_hs__clkbuf_16_7 VDD VSS sky130_fd_sc_hs__clkinv_4_2/A sky130_fd_sc_hs__clkbuf_8_19/X
+ VSS VDD sky130_fd_sc_hs__clkbuf_16
Xsky130_fd_sc_hs__a21oi_1_18 VDD VSS sky130_fd_sc_hs__o31ai_1_4/A1 sky130_fd_sc_hs__o21ai_1_3/B1
+ sky130_fd_sc_hs__nor2_1_11/Y sky130_fd_sc_hs__o21ai_1_3/A1 VSS VDD sky130_fd_sc_hs__a21oi_1
Xsky130_fd_sc_hs__a21oi_1_29 VDD VSS sky130_fd_sc_hs__a21oi_1_28/Y sky130_fd_sc_hs__nor2_1_17/B
+ sky130_fd_sc_hs__xnor2_1_14/Y sky130_fd_sc_hs__o21ai_1_7/B1 VSS VDD sky130_fd_sc_hs__a21oi_1
Xsky130_fd_sc_hs__dfrtp_1_16 sky130_fd_sc_hs__clkbuf_4_4/X VDD VSS sky130_fd_sc_hs__mux2_1_8/A0
+ sky130_fd_sc_hs__clkbuf_2_5/X sky130_fd_sc_hs__mux2_1_8/X VSS VDD sky130_fd_sc_hs__dfrtp_1
Xsky130_fd_sc_hs__a22oi_1_104 VDD VSS sky130_fd_sc_hs__mux2_1_424/A1 sky130_fd_sc_hs__nand2_1_222/B
+ sky130_fd_sc_hs__a222o_1_3/C2 sky130_fd_sc_hs__a22oi_1_6/B1 sky130_fd_sc_hs__xor2_1_82/B
+ VSS VDD sky130_fd_sc_hs__a22oi_1
Xsky130_fd_sc_hs__dfrtp_1_27 sky130_fd_sc_hs__clkbuf_4_3/A VDD VSS sky130_fd_sc_hs__mux2_1_34/A0
+ sky130_fd_sc_hs__clkbuf_2_9/X sky130_fd_sc_hs__mux2_1_34/X VSS VDD sky130_fd_sc_hs__dfrtp_1
Xsky130_fd_sc_hs__a22oi_1_115 VDD VSS sky130_fd_sc_hs__mux2_1_427/A0 sky130_fd_sc_hs__nand3_1_44/C
+ sky130_fd_sc_hs__nand2_1_51/B sky130_fd_sc_hs__a22o_1_8/B1 sky130_fd_sc_hs__xor2_1_89/B
+ VSS VDD sky130_fd_sc_hs__a22oi_1
Xsky130_fd_sc_hs__dfrtp_1_38 sky130_fd_sc_hs__clkbuf_4_3/X VDD VSS sky130_fd_sc_hs__mux2_1_40/A1
+ sky130_fd_sc_hs__clkbuf_2_12/X sky130_fd_sc_hs__mux2_1_40/X VSS VDD sky130_fd_sc_hs__dfrtp_1
Xsky130_fd_sc_hs__dfrtp_1_49 sky130_fd_sc_hs__clkbuf_4_12/A VDD VSS sky130_fd_sc_hs__buf_1_14/A
+ sky130_fd_sc_hs__clkbuf_2_15/X sky130_fd_sc_hs__a22o_1_2/X VSS VDD sky130_fd_sc_hs__dfrtp_1
Xsky130_fd_sc_hs__and3b_1_0 VDD VSS sky130_fd_sc_hs__and3b_1_0/X sky130_fd_sc_hs__or3b_1_0/B
+ sky130_fd_sc_hs__or2_1_29/A sky130_fd_sc_hs__or3b_1_0/A VSS VDD sky130_fd_sc_hs__and3b_1
Xsky130_fd_sc_hs__a311o_1_3 VDD VSS sky130_fd_sc_hs__a311o_1_3/X sky130_fd_sc_hs__and2_1_6/X
+ sky130_fd_sc_hs__o21a_1_2/A1 sky130_fd_sc_hs__and3_1_1/C sky130_fd_sc_hs__and3_1_1/B
+ sky130_fd_sc_hs__and3_1_1/A VSS VDD sky130_fd_sc_hs__a311o_1
Xsky130_fd_sc_hs__a22o_1_106 VDD VSS sky130_fd_sc_hs__buf_1_99/A sky130_fd_sc_hs__nor2_1_153/Y
+ sky130_fd_sc_hs__nand2_1_125/Y sky130_fd_sc_hs__nor2_2_2/Y sky130_fd_sc_hs__nor3_1_33/A
+ VSS VDD sky130_fd_sc_hs__a22o_1
Xsky130_fd_sc_hs__a22o_1_117 VDD VSS sky130_fd_sc_hs__a22o_1_117/X sky130_fd_sc_hs__nor2b_1_45/A
+ sky130_fd_sc_hs__buf_8_16/X sky130_fd_sc_hs__buf_8_18/X sky130_fd_sc_hs__or2_1_30/B
+ VSS VDD sky130_fd_sc_hs__a22o_1
Xsky130_fd_sc_hs__a22o_1_128 VDD VSS sky130_fd_sc_hs__nor3_1_51/C sky130_fd_sc_hs__mux2_1_377/A0
+ sky130_fd_sc_hs__buf_16_7/A sky130_fd_sc_hs__a22oi_1_6/A2 sky130_fd_sc_hs__mux2_1_379/A1
+ VSS VDD sky130_fd_sc_hs__a22o_1
Xsky130_fd_sc_hs__a22o_1_139 VDD VSS sky130_fd_sc_hs__a22o_1_139/X sky130_fd_sc_hs__mux2_1_477/A1
+ sky130_fd_sc_hs__a22o_1_75/B1 sky130_fd_sc_hs__nor2_1_92/Y sky130_fd_sc_hs__a22o_1_55/B2
+ VSS VDD sky130_fd_sc_hs__a22o_1
Xsky130_fd_sc_hs__nor3_4_8 VDD VSS sky130_fd_sc_hs__or3b_1_0/B sky130_fd_sc_hs__nor3_4_8/B
+ sky130_fd_sc_hs__nor3_4_8/C sky130_fd_sc_hs__nor3_4_8/Y VSS VDD sky130_fd_sc_hs__nor3_4
Xsky130_fd_sc_hs__dfstp_1_3 sky130_fd_sc_hs__buf_8_25/X VDD VSS sky130_fd_sc_hs__or2_1_21/B
+ sky130_fd_sc_hs__dfstp_1_3/D sky130_fd_sc_hs__dfstp_1_3/CLK VSS VDD sky130_fd_sc_hs__dfstp_1
Xsky130_fd_sc_hs__nand4b_1_2 VDD VSS sky130_fd_sc_hs__or3b_1_1/B sky130_fd_sc_hs__or2_1_29/X
+ sky130_fd_sc_hs__nand4b_1_2/Y sky130_fd_sc_hs__nor3_4_8/B sky130_fd_sc_hs__nand4b_1_2/B
+ VSS VDD sky130_fd_sc_hs__nand4b_1
Xsky130_fd_sc_hs__o21ai_1_40 VDD VSS sky130_fd_sc_hs__o21ai_1_40/Y sky130_fd_sc_hs__buf_8_10/X
+ sky130_fd_sc_hs__nor2_1_73/Y sky130_fd_sc_hs__a21oi_1_87/Y VSS VDD sky130_fd_sc_hs__o21ai_1
Xsky130_fd_sc_hs__o21ai_1_51 VDD VSS sky130_fd_sc_hs__o21ai_1_51/Y sky130_fd_sc_hs__o31a_1_3/A1
+ sky130_fd_sc_hs__or3_1_9/A sky130_fd_sc_hs__o31a_1_3/A2 VSS VDD sky130_fd_sc_hs__o21ai_1
Xsky130_fd_sc_hs__o21ai_1_62 VDD VSS sky130_fd_sc_hs__o32ai_1_0/B1 sky130_fd_sc_hs__nor2_1_121/Y
+ sky130_fd_sc_hs__or2_1_30/B sky130_fd_sc_hs__or2_1_21/B VSS VDD sky130_fd_sc_hs__o21ai_1
Xsky130_fd_sc_hs__o21ai_1_73 VDD VSS sky130_fd_sc_hs__o21ai_1_73/Y sky130_fd_sc_hs__o311ai_1_18/Y
+ sky130_fd_sc_hs__nand4_1_8/Y sky130_fd_sc_hs__or2_1_25/A VSS VDD sky130_fd_sc_hs__o21ai_1
Xsky130_fd_sc_hs__o21ai_1_84 VDD VSS sky130_fd_sc_hs__o21ai_1_84/Y sky130_fd_sc_hs__o21a_1_29/B1
+ sky130_fd_sc_hs__o21ai_1_84/A2 sky130_fd_sc_hs__nand4_1_9/D VSS VDD sky130_fd_sc_hs__o21ai_1
Xsky130_fd_sc_hs__o21ai_1_95 VDD VSS sky130_fd_sc_hs__o21ai_1_95/Y sky130_fd_sc_hs__o21ai_1_95/B1
+ sky130_fd_sc_hs__xnor2_1_131/Y sky130_fd_sc_hs__o21a_1_31/X VSS VDD sky130_fd_sc_hs__o21ai_1
Xsky130_fd_sc_hs__dfrtp_1_308 sky130_fd_sc_hs__clkbuf_4_13/X VDD VSS sky130_fd_sc_hs__buf_1_41/A
+ sky130_fd_sc_hs__clkbuf_2_84/X sky130_fd_sc_hs__buf_1_70/X VSS VDD sky130_fd_sc_hs__dfrtp_1
Xsky130_fd_sc_hs__dfrtp_1_319 sky130_fd_sc_hs__clkbuf_4_13/X VDD VSS sky130_fd_sc_hs__xor2_1_29/A
+ sky130_fd_sc_hs__clkinv_2_5/A sky130_fd_sc_hs__a21oi_1_74/Y VSS VDD sky130_fd_sc_hs__dfrtp_1
Xsky130_fd_sc_hs__buf_16_3 sky130_fd_sc_hs__buf_16_3/X VDD VSS sky130_fd_sc_hs__buf_16_3/A
+ VSS VDD sky130_fd_sc_hs__buf_16
Xsky130_fd_sc_hs__dfrtp_1_820 sky130_fd_sc_hs__buf_8_9/X VDD VSS sky130_fd_sc_hs__mux2_1_477/A1
+ sky130_fd_sc_hs__clkbuf_2_112/X sky130_fd_sc_hs__a22o_1_139/X VSS VDD sky130_fd_sc_hs__dfrtp_1
Xsky130_fd_sc_hs__dfrtp_1_831 sky130_fd_sc_hs__clkbuf_4_19/X VDD VSS sky130_fd_sc_hs__or2_1_15/A
+ sky130_fd_sc_hs__clkbuf_2_239/X sky130_fd_sc_hs__nand2_1_100/Y VSS VDD sky130_fd_sc_hs__dfrtp_1
Xsky130_fd_sc_hs__and2_1_9 VDD VSS sky130_fd_sc_hs__and2_1_9/A sky130_fd_sc_hs__and2_1_9/B
+ sky130_fd_sc_hs__and2_1_9/X VSS VDD sky130_fd_sc_hs__and2_1
Xsky130_fd_sc_hs__clkbuf_4_18 VDD VSS sky130_fd_sc_hs__buf_1_85/A sky130_fd_sc_hs__nor2_1_82/B
+ VSS VDD sky130_fd_sc_hs__clkbuf_4
Xsky130_fd_sc_hs__clkbuf_4_29 VDD VSS sky130_fd_sc_hs__nor2_2_6/Y sky130_fd_sc_hs__buf_16_6/A
+ VSS VDD sky130_fd_sc_hs__clkbuf_4
Xsky130_fd_sc_hs__clkbuf_8_5 VDD VSS sky130_fd_sc_hs__mux2_1_464/S sky130_fd_sc_hs__or3_1_6/X
+ VSS VDD sky130_fd_sc_hs__clkbuf_8
Xsky130_fd_sc_hs__a21oi_1_150 VDD VSS sky130_fd_sc_hs__or3b_1_0/B sky130_fd_sc_hs__o31ai_4_0/A2
+ sky130_fd_sc_hs__nor2_1_124/Y sky130_fd_sc_hs__a21oi_1_147/Y VSS VDD sky130_fd_sc_hs__a21oi_1
Xsky130_fd_sc_hs__a21oi_1_161 VDD VSS sky130_fd_sc_hs__o22ai_1_9/A1 sky130_fd_sc_hs__a31oi_1_12/B1
+ sky130_fd_sc_hs__nand4_1_7/D sky130_fd_sc_hs__nor2b_1_40/Y VSS VDD sky130_fd_sc_hs__a21oi_1
Xsky130_fd_sc_hs__a21oi_1_172 VDD VSS sky130_fd_sc_hs__nor3_1_23/Y sky130_fd_sc_hs__dfstp_1_1/D
+ sky130_fd_sc_hs__buf_8_16/X sky130_fd_sc_hs__nor3_1_46/B VSS VDD sky130_fd_sc_hs__a21oi_1
Xsky130_fd_sc_hs__a21oi_1_183 VDD VSS sky130_fd_sc_hs__a31o_1_14/A1 sky130_fd_sc_hs__a21oi_1_183/Y
+ sky130_fd_sc_hs__nor2_1_99/B sky130_fd_sc_hs__nor2_1_99/A VSS VDD sky130_fd_sc_hs__a21oi_1
Xsky130_fd_sc_hs__a21oi_1_194 VDD VSS sky130_fd_sc_hs__o21ai_1_97/Y sky130_fd_sc_hs__o21ai_1_98/A2
+ sky130_fd_sc_hs__a21o_1_7/A2 sky130_fd_sc_hs__maj3_1_59/X VSS VDD sky130_fd_sc_hs__a21oi_1
Xsky130_fd_sc_hs__nor3_1_14 VDD VSS sky130_fd_sc_hs__nor3_1_14/Y sky130_fd_sc_hs__and3_1_5/C
+ sky130_fd_sc_hs__and3_1_5/B sky130_fd_sc_hs__and3_1_5/A VSS VDD sky130_fd_sc_hs__nor3_1
Xsky130_fd_sc_hs__nor3_1_25 VDD VSS sky130_fd_sc_hs__nor3_1_45/B sky130_fd_sc_hs__nor3_1_25/C
+ sky130_fd_sc_hs__nor3_1_25/B sky130_fd_sc_hs__nor3_1_25/A VSS VDD sky130_fd_sc_hs__nor3_1
Xsky130_fd_sc_hs__nor3_1_36 VDD VSS sky130_fd_sc_hs__nor3_1_36/Y sky130_fd_sc_hs__or3_1_4/X
+ sky130_fd_sc_hs__nor3_1_36/B sky130_fd_sc_hs__nor3_1_36/A VSS VDD sky130_fd_sc_hs__nor3_1
Xsky130_fd_sc_hs__nor3_1_47 VDD VSS sky130_fd_sc_hs__nor3_1_47/Y sky130_fd_sc_hs__nor3_1_47/C
+ sky130_fd_sc_hs__nor3_1_47/B sky130_fd_sc_hs__or3_1_6/A VSS VDD sky130_fd_sc_hs__nor3_1
Xsky130_fd_sc_hs__dfrtp_1_105 sky130_fd_sc_hs__clkbuf_4_1/X VDD VSS sky130_fd_sc_hs__mux2_1_99/A1
+ sky130_fd_sc_hs__clkinv_1_24/A sky130_fd_sc_hs__mux2_1_99/X VSS VDD sky130_fd_sc_hs__dfrtp_1
Xsky130_fd_sc_hs__dfrtp_1_116 sky130_fd_sc_hs__clkbuf_4_2/X VDD VSS sky130_fd_sc_hs__mux2_1_112/A0
+ sky130_fd_sc_hs__clkbuf_2_40/X sky130_fd_sc_hs__mux2_1_112/X VSS VDD sky130_fd_sc_hs__dfrtp_1
Xsky130_fd_sc_hs__dfrtp_1_127 sky130_fd_sc_hs__buf_8_1/X VDD VSS sky130_fd_sc_hs__mux2_1_118/A1
+ sky130_fd_sc_hs__clkinv_1_28/A sky130_fd_sc_hs__mux2_1_118/X VSS VDD sky130_fd_sc_hs__dfrtp_1
Xsky130_fd_sc_hs__dfrtp_1_138 sky130_fd_sc_hs__clkbuf_4_10/X VDD VSS sky130_fd_sc_hs__mux2_1_178/A1
+ sky130_fd_sc_hs__clkinv_1_33/A sky130_fd_sc_hs__mux2_1_178/X VSS VDD sky130_fd_sc_hs__dfrtp_1
Xsky130_fd_sc_hs__dfrtp_1_149 sky130_fd_sc_hs__clkbuf_4_3/A VDD VSS sky130_fd_sc_hs__mux2_1_126/A1
+ sky130_fd_sc_hs__clkinv_1_34/A sky130_fd_sc_hs__mux2_1_126/X VSS VDD sky130_fd_sc_hs__dfrtp_1
Xsky130_fd_sc_hs__buf_8_7 VDD VSS sky130_fd_sc_hs__buf_8_7/X sky130_fd_sc_hs__buf_8_7/A
+ VSS VDD sky130_fd_sc_hs__buf_8
Xsky130_fd_sc_hs__clkinv_1_100 VDD VSS sky130_fd_sc_hs__maj3_1_45/X sky130_fd_sc_hs__maj3_1_43/B
+ VSS VDD sky130_fd_sc_hs__clkinv_1
Xsky130_fd_sc_hs__clkinv_1_111 VDD VSS sky130_fd_sc_hs__clkinv_1_111/A sky130_fd_sc_hs__clkinv_1_111/Y
+ VSS VDD sky130_fd_sc_hs__clkinv_1
Xsky130_fd_sc_hs__clkinv_1_122 VDD VSS sky130_fd_sc_hs__or2_1_30/B sky130_fd_sc_hs__nor3_1_34/C
+ VSS VDD sky130_fd_sc_hs__clkinv_1
Xsky130_fd_sc_hs__clkinv_1_133 VDD VSS sky130_fd_sc_hs__clkinv_1_133/A sky130_fd_sc_hs__clkinv_1_133/Y
+ VSS VDD sky130_fd_sc_hs__clkinv_1
Xsky130_fd_sc_hs__clkinv_1_144 VDD VSS sky130_fd_sc_hs__clkinv_1_144/A sky130_fd_sc_hs__clkinv_1_144/Y
+ VSS VDD sky130_fd_sc_hs__clkinv_1
Xsky130_fd_sc_hs__clkinv_1_155 VDD VSS sky130_fd_sc_hs__clkinv_1_155/A sky130_fd_sc_hs__clkinv_1_155/Y
+ VSS VDD sky130_fd_sc_hs__clkinv_1
Xsky130_fd_sc_hs__o311ai_1_18 VDD VSS sky130_fd_sc_hs__or2_1_24/B sky130_fd_sc_hs__or3_1_1/X
+ sky130_fd_sc_hs__buf_1_138/A sky130_fd_sc_hs__o31a_1_5/B1 sky130_fd_sc_hs__o311ai_1_18/Y
+ sky130_fd_sc_hs__nor2_2_7/B VSS VDD sky130_fd_sc_hs__o311ai_1
Xsky130_fd_sc_hs__dfrtp_1_650 sky130_fd_sc_hs__clkbuf_4_2/X VDD VSS sky130_fd_sc_hs__mux2_1_475/A1
+ sky130_fd_sc_hs__clkinv_1_129/A sky130_fd_sc_hs__mux2_1_475/X VSS VDD sky130_fd_sc_hs__dfrtp_1
Xsky130_fd_sc_hs__dfrtp_1_661 sky130_fd_sc_hs__clkbuf_4_33/X VDD VSS sky130_fd_sc_hs__mux2_1_365/A0
+ sky130_fd_sc_hs__clkbuf_2_200/X sky130_fd_sc_hs__mux2_1_365/X VSS VDD sky130_fd_sc_hs__dfrtp_1
Xsky130_fd_sc_hs__nor2_1_103 VDD VSS sky130_fd_sc_hs__xor2_1_65/A sky130_fd_sc_hs__nor2_1_103/Y
+ sky130_fd_sc_hs__maj3_1_34/A VSS VDD sky130_fd_sc_hs__nor2_1
Xsky130_fd_sc_hs__nor2_1_114 VDD VSS sky130_fd_sc_hs__buf_8_11/A sky130_fd_sc_hs__nor2_1_114/Y
+ sky130_fd_sc_hs__xor2_1_78/B VSS VDD sky130_fd_sc_hs__nor2_1
Xsky130_fd_sc_hs__dfrtp_1_672 sky130_fd_sc_hs__clkbuf_4_35/X VDD VSS sky130_fd_sc_hs__xor2_1_90/A
+ sky130_fd_sc_hs__clkinv_1_156/A sky130_fd_sc_hs__mux2_1_372/X VSS VDD sky130_fd_sc_hs__dfrtp_1
Xsky130_fd_sc_hs__dfrtp_1_683 sky130_fd_sc_hs__clkbuf_4_35/X VDD VSS sky130_fd_sc_hs__xor2_1_87/B
+ sky130_fd_sc_hs__clkinv_1_150/A sky130_fd_sc_hs__mux2_1_387/X VSS VDD sky130_fd_sc_hs__dfrtp_1
Xsky130_fd_sc_hs__nor2_1_125 VDD VSS sky130_fd_sc_hs__or2_1_30/A sky130_fd_sc_hs__nor2_1_125/Y
+ sky130_fd_sc_hs__nor3_1_44/B VSS VDD sky130_fd_sc_hs__nor2_1
Xsky130_fd_sc_hs__dfrtp_1_2 sky130_fd_sc_hs__clkbuf_4_4/X VDD VSS sky130_fd_sc_hs__mux2_1_2/A0
+ sky130_fd_sc_hs__clkinv_1_4/A sky130_fd_sc_hs__mux2_1_2/X VSS VDD sky130_fd_sc_hs__dfrtp_1
Xsky130_fd_sc_hs__nor2_1_136 VDD VSS sky130_fd_sc_hs__nor3_1_37/B sky130_fd_sc_hs__nor2_1_136/Y
+ sky130_fd_sc_hs__nor3_1_37/A VSS VDD sky130_fd_sc_hs__nor2_1
Xsky130_fd_sc_hs__dfrtp_1_694 sky130_fd_sc_hs__clkbuf_4_33/X VDD VSS sky130_fd_sc_hs__xor2_1_83/B
+ sky130_fd_sc_hs__clkbuf_2_202/X sky130_fd_sc_hs__mux2_1_370/X VSS VDD sky130_fd_sc_hs__dfrtp_1
Xsky130_fd_sc_hs__a22oi_1_12 VDD VSS sky130_fd_sc_hs__mux2_1_6/A1 sky130_fd_sc_hs__and4_1_0/D
+ sky130_fd_sc_hs__buf_16_8/X sky130_fd_sc_hs__a22oi_1_5/A2 sky130_fd_sc_hs__mux2_1_26/A0
+ VSS VDD sky130_fd_sc_hs__a22oi_1
Xsky130_fd_sc_hs__nor2_1_147 VDD VSS sky130_fd_sc_hs__buf_8_36/A sky130_fd_sc_hs__o22ai_1_5/B1
+ sky130_fd_sc_hs__nor2_1_147/A VSS VDD sky130_fd_sc_hs__nor2_1
Xsky130_fd_sc_hs__a22oi_1_23 VDD VSS sky130_fd_sc_hs__mux2_1_61/A1 sky130_fd_sc_hs__and4_1_1/A
+ sky130_fd_sc_hs__buf_16_8/X sky130_fd_sc_hs__a22oi_1_6/A2 sky130_fd_sc_hs__mux2_1_49/A1
+ VSS VDD sky130_fd_sc_hs__a22oi_1
Xsky130_fd_sc_hs__nor2_1_158 VDD VSS sky130_fd_sc_hs__nor2_1_66/B sky130_fd_sc_hs__nor2_1_158/Y
+ sky130_fd_sc_hs__xor2_1_76/B VSS VDD sky130_fd_sc_hs__nor2_1
Xsky130_fd_sc_hs__a22oi_1_34 VDD VSS sky130_fd_sc_hs__mux2_1_102/A1 sky130_fd_sc_hs__nand2_1_26/A
+ sky130_fd_sc_hs__a22o_1_9/A2 sky130_fd_sc_hs__a22o_1_8/B1 sky130_fd_sc_hs__or2_1_1/B
+ VSS VDD sky130_fd_sc_hs__a22oi_1
Xsky130_fd_sc_hs__nor2_1_169 VDD VSS sky130_fd_sc_hs__nor3_1_25/A sky130_fd_sc_hs__o21a_1_30/A2
+ sky130_fd_sc_hs__and2_1_44/X VSS VDD sky130_fd_sc_hs__nor2_1
Xsky130_fd_sc_hs__a22oi_1_45 VDD VSS sky130_fd_sc_hs__mux2_1_139/A0 sky130_fd_sc_hs__and4_1_4/C
+ sky130_fd_sc_hs__a22oi_1_7/B1 sky130_fd_sc_hs__a22o_1_8/A2 sky130_fd_sc_hs__mux2_1_141/A0
+ VSS VDD sky130_fd_sc_hs__a22oi_1
Xsky130_fd_sc_hs__a22oi_1_56 VDD VSS sky130_fd_sc_hs__mux2_1_480/A0 sky130_fd_sc_hs__nand2_1_25/B
+ sky130_fd_sc_hs__a22oi_1_7/B1 sky130_fd_sc_hs__a22o_1_8/A2 sky130_fd_sc_hs__mux2_1_98/A0
+ VSS VDD sky130_fd_sc_hs__a22oi_1
Xsky130_fd_sc_hs__a22oi_1_67 VDD VSS sky130_fd_sc_hs__nor3_1_41/A sky130_fd_sc_hs__a22oi_1_67/Y
+ sky130_fd_sc_hs__nor2_1_154/Y sky130_fd_sc_hs__a22oi_1_67/A2 sky130_fd_sc_hs__dfrtp_1_500/Q
+ VSS VDD sky130_fd_sc_hs__a22oi_1
Xsky130_fd_sc_hs__a22oi_1_78 VDD VSS sky130_fd_sc_hs__mux2_1_294/A1 sky130_fd_sc_hs__and4_1_6/C
+ sky130_fd_sc_hs__a22o_1_9/A2 sky130_fd_sc_hs__a22oi_1_6/A2 sky130_fd_sc_hs__mux2_1_306/A1
+ VSS VDD sky130_fd_sc_hs__a22oi_1
Xsky130_fd_sc_hs__a22oi_1_89 VDD VSS sky130_fd_sc_hs__mux2_1_352/A1 sky130_fd_sc_hs__a22oi_1_89/Y
+ sky130_fd_sc_hs__buf_16_8/X sky130_fd_sc_hs__a222o_1_7/B1 sky130_fd_sc_hs__maj3_1_52/B
+ VSS VDD sky130_fd_sc_hs__a22oi_1
Xsky130_fd_sc_hs__nor2_1_80 VDD VSS sky130_fd_sc_hs__nor2_1_80/B sky130_fd_sc_hs__nor2_1_80/Y
+ sky130_fd_sc_hs__buf_8_19/X VSS VDD sky130_fd_sc_hs__nor2_1
Xsky130_fd_sc_hs__nor2_1_91 VDD VSS sky130_fd_sc_hs__nor2_1_91/B sky130_fd_sc_hs__nor2_1_91/Y
+ sky130_fd_sc_hs__buf_8_19/X VSS VDD sky130_fd_sc_hs__nor2_1
Xsky130_fd_sc_hs__mux2_1_109 VDD VSS sky130_fd_sc_hs__mux2_1_109/X sky130_fd_sc_hs__mux2_1_9/S
+ sky130_fd_sc_hs__nand2_1_33/A sky130_fd_sc_hs__a22o_1_64/B2 VSS VDD sky130_fd_sc_hs__mux2_1
Xsky130_fd_sc_hs__xnor2_1_0 VDD VSS sky130_fd_sc_hs__maj3_1_0/B sky130_fd_sc_hs__xnor2_1_2/B
+ sky130_fd_sc_hs__maj3_1_0/C VSS VDD sky130_fd_sc_hs__xnor2_1
Xsky130_fd_sc_hs__a31o_1_5 VDD VSS sky130_fd_sc_hs__a31o_1_5/X sky130_fd_sc_hs__xor2_1_36/X
+ sky130_fd_sc_hs__a31o_1_5/A2 sky130_fd_sc_hs__a31o_1_5/A1 sky130_fd_sc_hs__buf_8_12/X
+ VSS VDD sky130_fd_sc_hs__a31o_1
Xsky130_fd_sc_hs__dfrtp_1_480 sky130_fd_sc_hs__clkbuf_4_23/A VDD VSS sky130_fd_sc_hs__or3b_1_1/A
+ sky130_fd_sc_hs__clkbuf_2_147/A sky130_fd_sc_hs__o21a_1_23/X VSS VDD sky130_fd_sc_hs__dfrtp_1
Xsky130_fd_sc_hs__dfrtp_1_491 sky130_fd_sc_hs__clkbuf_4_23/X VDD VSS sky130_fd_sc_hs__mux2i_1_9/A1
+ sky130_fd_sc_hs__clkbuf_2_157/A sky130_fd_sc_hs__dfrtp_1_491/D VSS VDD sky130_fd_sc_hs__dfrtp_1
Xsky130_fd_sc_hs__o21a_1_15 VDD VSS sky130_fd_sc_hs__o21a_1_15/X sky130_fd_sc_hs__nor3_1_21/Y
+ sky130_fd_sc_hs__o21a_1_4/B1 sky130_fd_sc_hs__o21a_1_15/A1 VSS VDD sky130_fd_sc_hs__o21a_1
Xsky130_fd_sc_hs__clkbuf_2_209 VDD VSS sky130_fd_sc_hs__clkbuf_2_209/X sky130_fd_sc_hs__clkinv_2_11/A
+ VSS VDD sky130_fd_sc_hs__clkbuf_2
Xsky130_fd_sc_hs__o21a_1_26 VDD VSS sky130_fd_sc_hs__o21a_1_26/X sky130_fd_sc_hs__o21a_1_26/A2
+ sky130_fd_sc_hs__o21ai_1_65/Y sky130_fd_sc_hs__nor3_1_37/C VSS VDD sky130_fd_sc_hs__o21a_1
Xsky130_fd_sc_hs__nand2_1_209 VDD VSS sky130_fd_sc_hs__o21ai_1_94/Y sky130_fd_sc_hs__nand2_1_209/Y
+ sky130_fd_sc_hs__nand2_1_210/Y VSS VDD sky130_fd_sc_hs__nand2_1
Xsky130_fd_sc_hs__and2_1_16 VDD VSS sky130_fd_sc_hs__or2_1_9/A sky130_fd_sc_hs__or2_1_9/B
+ sky130_fd_sc_hs__and2_1_16/X VSS VDD sky130_fd_sc_hs__and2_1
Xsky130_fd_sc_hs__and2_1_27 VDD VSS sky130_fd_sc_hs__or2_1_18/X sky130_fd_sc_hs__and2_1_27/B
+ sky130_fd_sc_hs__and2_1_27/X VSS VDD sky130_fd_sc_hs__and2_1
Xsky130_fd_sc_hs__and2_1_38 VDD VSS sky130_fd_sc_hs__xor2_1_53/A sky130_fd_sc_hs__and2_1_38/B
+ sky130_fd_sc_hs__and2_1_38/X VSS VDD sky130_fd_sc_hs__and2_1
Xsky130_fd_sc_hs__and2_1_49 VDD VSS sky130_fd_sc_hs__or3b_1_1/A sky130_fd_sc_hs__or3b_1_1/B
+ sky130_fd_sc_hs__and2_1_49/X VSS VDD sky130_fd_sc_hs__and2_1
Xsky130_fd_sc_hs__mux2_1_440 VDD VSS sky130_fd_sc_hs__mux2_1_440/X sky130_fd_sc_hs__buf_16_2/A
+ sky130_fd_sc_hs__a22o_1_91/B2 sky130_fd_sc_hs__mux2_1_440/A1 VSS VDD sky130_fd_sc_hs__mux2_1
Xsky130_fd_sc_hs__mux2_1_451 VDD VSS sky130_fd_sc_hs__mux2_1_451/X sky130_fd_sc_hs__buf_16_5/A
+ sky130_fd_sc_hs__mux2_1_451/A0 sky130_fd_sc_hs__a22o_1_91/B2 VSS VDD sky130_fd_sc_hs__mux2_1
Xsky130_fd_sc_hs__mux2_1_462 VDD VSS sky130_fd_sc_hs__mux2_1_462/X sky130_fd_sc_hs__buf_4_0/X
+ sky130_fd_sc_hs__mux2_1_462/A0 sky130_fd_sc_hs__a22o_1_62/B2 VSS VDD sky130_fd_sc_hs__mux2_1
Xsky130_fd_sc_hs__mux2_1_473 VDD VSS sky130_fd_sc_hs__mux2_1_473/X sky130_fd_sc_hs__buf_16_0/A
+ sky130_fd_sc_hs__and2_1_9/B sky130_fd_sc_hs__mux2_1_473/A1 VSS VDD sky130_fd_sc_hs__mux2_1
Xsky130_fd_sc_hs__mux2_1_484 VDD VSS sky130_fd_sc_hs__mux2_1_484/X sky130_fd_sc_hs__mux2_1_1/S
+ sky130_fd_sc_hs__a22o_1_61/B2 sky130_fd_sc_hs__mux2_1_484/A1 VSS VDD sky130_fd_sc_hs__mux2_1
Xsky130_fd_sc_hs__buf_4_1 VDD VSS sky130_fd_sc_hs__buf_4_1/A sky130_fd_sc_hs__buf_4_1/X
+ VSS VDD sky130_fd_sc_hs__buf_4
Xsky130_fd_sc_hs__nand3_1_18 VDD VSS sky130_fd_sc_hs__nand3_1_18/C sky130_fd_sc_hs__nand3_1_18/Y
+ sky130_fd_sc_hs__o32a_1_0/A3 sky130_fd_sc_hs__o32a_1_0/A1 VSS VDD sky130_fd_sc_hs__nand3_1
Xsky130_fd_sc_hs__nand3_1_29 VDD VSS sky130_fd_sc_hs__nor3_1_39/C sky130_fd_sc_hs__mux2i_1_9/S
+ sky130_fd_sc_hs__nand4_1_6/D sky130_fd_sc_hs__nor3_1_37/C VSS VDD sky130_fd_sc_hs__nand3_1
Xsky130_fd_sc_hs__nand2b_2_0 VDD VSS sky130_fd_sc_hs__o21a_1_4/B1 sky130_fd_sc_hs__o31ai_1_4/A1
+ sky130_fd_sc_hs__nor2_4_3/B VSS VDD sky130_fd_sc_hs__nand2b_2
Xsky130_fd_sc_hs__mux2i_1_15 VDD VSS sky130_fd_sc_hs__nand3_1_27/Y sky130_fd_sc_hs__o32ai_1_0/B2
+ sky130_fd_sc_hs__or2_1_22/B sky130_fd_sc_hs__mux2i_1_15/Y VSS VDD sky130_fd_sc_hs__mux2i_1
Xsky130_fd_sc_hs__buf_1_15 VDD VSS sky130_fd_sc_hs__buf_1_15/A srm_residue_o[4] VSS
+ VDD sky130_fd_sc_hs__buf_1
Xsky130_fd_sc_hs__buf_1_26 VDD VSS sky130_fd_sc_hs__buf_1_26/A w_wr_data[15] VSS VDD
+ sky130_fd_sc_hs__buf_1
Xsky130_fd_sc_hs__buf_1_37 VDD VSS sky130_fd_sc_hs__buf_1_37/A raw_code_o[9] VSS VDD
+ sky130_fd_sc_hs__buf_1
Xsky130_fd_sc_hs__buf_1_48 VDD VSS sky130_fd_sc_hs__buf_1_48/A calib_overrange_bits[1]
+ VSS VDD sky130_fd_sc_hs__buf_1
Xsky130_fd_sc_hs__buf_1_59 VDD VSS sky130_fd_sc_hs__buf_1_59/A w_wr_data[13] VSS VDD
+ sky130_fd_sc_hs__buf_1
Xsky130_fd_sc_hs__a22o_1_40 VDD VSS sky130_fd_sc_hs__a22o_1_40/X sky130_fd_sc_hs__a22o_1_40/B2
+ sky130_fd_sc_hs__buf_8_17/X sky130_fd_sc_hs__buf_8_15/X sky130_fd_sc_hs__a22o_1_42/B2
+ VSS VDD sky130_fd_sc_hs__a22o_1
Xsky130_fd_sc_hs__a22o_1_51 VDD VSS sky130_fd_sc_hs__a22o_1_51/X sky130_fd_sc_hs__a31oi_1_6/Y
+ sky130_fd_sc_hs__a31o_1_9/A2 sky130_fd_sc_hs__a32o_1_7/B1 sky130_fd_sc_hs__xor2_1_43/A
+ VSS VDD sky130_fd_sc_hs__a22o_1
Xsky130_fd_sc_hs__a22o_1_62 VDD VSS sky130_fd_sc_hs__a22o_1_62/X sky130_fd_sc_hs__a22o_1_62/B2
+ sky130_fd_sc_hs__buf_8_17/X sky130_fd_sc_hs__buf_8_15/X sky130_fd_sc_hs__a22o_1_62/A1
+ VSS VDD sky130_fd_sc_hs__a22o_1
Xsky130_fd_sc_hs__a22o_1_73 VDD VSS sky130_fd_sc_hs__dfrtp_2_1/D sky130_fd_sc_hs__dfrtp_2_1/Q
+ sky130_fd_sc_hs__a22o_1_75/B1 sky130_fd_sc_hs__nor2_1_92/Y sky130_fd_sc_hs__a22o_1_78/B2
+ VSS VDD sky130_fd_sc_hs__a22o_1
Xsky130_fd_sc_hs__a22o_1_84 VDD VSS sky130_fd_sc_hs__a22o_1_84/X sky130_fd_sc_hs__a22o_1_84/B2
+ sky130_fd_sc_hs__buf_8_17/X sky130_fd_sc_hs__buf_8_15/X sky130_fd_sc_hs__a22o_1_84/A1
+ VSS VDD sky130_fd_sc_hs__a22o_1
Xsky130_fd_sc_hs__clkbuf_2_40 VDD VSS sky130_fd_sc_hs__clkbuf_2_40/X sky130_fd_sc_hs__clkinv_4_4/A
+ VSS VDD sky130_fd_sc_hs__clkbuf_2
Xsky130_fd_sc_hs__clkbuf_2_51 VDD VSS sky130_fd_sc_hs__dfrtp_1_8/CLK sky130_fd_sc_hs__clkinv_4_0/A
+ VSS VDD sky130_fd_sc_hs__clkbuf_2
Xsky130_fd_sc_hs__a22o_1_95 VDD VSS sky130_fd_sc_hs__a22o_1_95/X sky130_fd_sc_hs__a22o_1_95/B2
+ sky130_fd_sc_hs__buf_8_17/X sky130_fd_sc_hs__buf_8_15/X sky130_fd_sc_hs__a22o_1_95/A1
+ VSS VDD sky130_fd_sc_hs__a22o_1
Xsky130_fd_sc_hs__clkbuf_2_62 VDD VSS sky130_fd_sc_hs__clkbuf_2_62/X sky130_fd_sc_hs__clkinv_4_1/A
+ VSS VDD sky130_fd_sc_hs__clkbuf_2
Xsky130_fd_sc_hs__a21o_1_4 VDD VSS sky130_fd_sc_hs__a21o_1_4/X sky130_fd_sc_hs__a21o_1_4/A1
+ sky130_fd_sc_hs__a21o_1_4/B1 sky130_fd_sc_hs__a32o_1_7/A3 VSS VDD sky130_fd_sc_hs__a21o_1
Xsky130_fd_sc_hs__clkbuf_2_73 VDD VSS sky130_fd_sc_hs__clkbuf_2_73/X sky130_fd_sc_hs__clkinv_4_2/A
+ VSS VDD sky130_fd_sc_hs__clkbuf_2
Xsky130_fd_sc_hs__clkbuf_2_84 VDD VSS sky130_fd_sc_hs__clkbuf_2_84/X sky130_fd_sc_hs__clkinv_4_3/A
+ VSS VDD sky130_fd_sc_hs__clkbuf_2
Xsky130_fd_sc_hs__clkbuf_2_95 VDD VSS sky130_fd_sc_hs__clkbuf_2_95/X sky130_fd_sc_hs__clkinv_4_2/A
+ VSS VDD sky130_fd_sc_hs__clkbuf_2
Xsky130_fd_sc_hs__nand4_1_1 VDD VSS sky130_fd_sc_hs__nand4_1_1/C sky130_fd_sc_hs__nor2_1_27/B
+ sky130_fd_sc_hs__nand4_1_1/D sky130_fd_sc_hs__and4_1_4/X sky130_fd_sc_hs__nand4_1_1/A
+ VSS VDD sky130_fd_sc_hs__nand4_1
Xsky130_fd_sc_hs__maj3_1_13 VDD VSS sky130_fd_sc_hs__xor2_1_32/A sky130_fd_sc_hs__xor2_1_32/B
+ sky130_fd_sc_hs__maj3_1_13/X sky130_fd_sc_hs__maj3_1_13/C VSS VDD sky130_fd_sc_hs__maj3_1
Xsky130_fd_sc_hs__maj3_1_24 VDD VSS sky130_fd_sc_hs__xor2_1_41/A sky130_fd_sc_hs__xor2_1_41/B
+ sky130_fd_sc_hs__xor2_1_40/A sky130_fd_sc_hs__maj3_1_24/C VSS VDD sky130_fd_sc_hs__maj3_1
Xsky130_fd_sc_hs__maj3_1_35 VDD VSS sky130_fd_sc_hs__or2_1_18/A sky130_fd_sc_hs__or2_1_18/B
+ sky130_fd_sc_hs__xor2_1_64/A sky130_fd_sc_hs__maj3_1_35/C VSS VDD sky130_fd_sc_hs__maj3_1
Xsky130_fd_sc_hs__maj3_1_46 VDD VSS sky130_fd_sc_hs__xor2_1_77/A sky130_fd_sc_hs__xor2_1_77/B
+ sky130_fd_sc_hs__maj3_1_46/X sky130_fd_sc_hs__maj3_1_46/C VSS VDD sky130_fd_sc_hs__maj3_1
Xsky130_fd_sc_hs__maj3_1_57 VDD VSS sky130_fd_sc_hs__maj3_1_64/X sky130_fd_sc_hs__maj3_1_58/X
+ sky130_fd_sc_hs__maj3_1_68/A sky130_fd_sc_hs__maj3_1_57/C VSS VDD sky130_fd_sc_hs__maj3_1
Xsky130_fd_sc_hs__maj3_1_68 VDD VSS sky130_fd_sc_hs__maj3_1_68/A sky130_fd_sc_hs__maj3_1_68/B
+ sky130_fd_sc_hs__maj3_1_68/X sky130_fd_sc_hs__maj3_1_68/C VSS VDD sky130_fd_sc_hs__maj3_1
Xsky130_fd_sc_hs__nand2_1_40 VDD VSS sky130_fd_sc_hs__maj3_1_2/B sky130_fd_sc_hs__o31ai_1_3/B1
+ sky130_fd_sc_hs__maj3_1_2/A VSS VDD sky130_fd_sc_hs__nand2_1
Xsky130_fd_sc_hs__nand2_1_51 VDD VSS sky130_fd_sc_hs__nand2_1_51/B sky130_fd_sc_hs__nand4_1_0/A
+ sky130_fd_sc_hs__nand2_1_51/A VSS VDD sky130_fd_sc_hs__nand2_1
Xsky130_fd_sc_hs__mux2_1_270 VDD VSS sky130_fd_sc_hs__mux2_1_270/X sky130_fd_sc_hs__nor2_2_5/Y
+ sky130_fd_sc_hs__a222o_1_5/B2 sky130_fd_sc_hs__mux2_1_477/A1 VSS VDD sky130_fd_sc_hs__mux2_1
Xsky130_fd_sc_hs__nand2_1_62 VDD VSS sky130_fd_sc_hs__o21ai_1_33/Y sky130_fd_sc_hs__nand2_1_62/Y
+ sky130_fd_sc_hs__nand2_1_69/Y VSS VDD sky130_fd_sc_hs__nand2_1
Xsky130_fd_sc_hs__mux2_1_281 VDD VSS sky130_fd_sc_hs__mux2_1_281/X sky130_fd_sc_hs__nor3_4_0/Y
+ sky130_fd_sc_hs__mux2_1_281/A0 sky130_fd_sc_hs__mux2_1_473/A1 VSS VDD sky130_fd_sc_hs__mux2_1
Xsky130_fd_sc_hs__nand2_1_73 VDD VSS sky130_fd_sc_hs__or3_1_9/X sky130_fd_sc_hs__a31o_1_3/A1
+ sky130_fd_sc_hs__nand2_1_73/A VSS VDD sky130_fd_sc_hs__nand2_1
Xsky130_fd_sc_hs__mux2_1_292 VDD VSS sky130_fd_sc_hs__mux2_1_292/X sky130_fd_sc_hs__buf_16_13/A
+ sky130_fd_sc_hs__and2_1_9/A sky130_fd_sc_hs__mux2_1_473/A1 VSS VDD sky130_fd_sc_hs__mux2_1
Xsky130_fd_sc_hs__nand2_1_84 VDD VSS sky130_fd_sc_hs__or2_1_12/B sky130_fd_sc_hs__nand2_1_85/B
+ sky130_fd_sc_hs__xor2_1_44/A VSS VDD sky130_fd_sc_hs__nand2_1
Xsky130_fd_sc_hs__a222oi_1_14 VDD VSS sky130_fd_sc_hs__buf_8_31/X sky130_fd_sc_hs__mux2_1_282/A0
+ sky130_fd_sc_hs__buf_4_3/A sky130_fd_sc_hs__clkbuf_8_15/X sky130_fd_sc_hs__mux2_1_281/A0
+ sky130_fd_sc_hs__nand2_1_230/B sky130_fd_sc_hs__mux2_1_404/A0 VSS VDD sky130_fd_sc_hs__a222oi_1
Xsky130_fd_sc_hs__nand2_1_95 VDD VSS sky130_fd_sc_hs__or3_1_3/X sky130_fd_sc_hs__o31ai_1_9/B1
+ sky130_fd_sc_hs__nor2_1_81/B VSS VDD sky130_fd_sc_hs__nand2_1
Xsky130_fd_sc_hs__a222oi_1_25 VDD VSS sky130_fd_sc_hs__mux2_1_415/A1 sky130_fd_sc_hs__a222o_1_3/C2
+ sky130_fd_sc_hs__a22oi_1_7/B1 sky130_fd_sc_hs__a222o_1_2/A2 sky130_fd_sc_hs__mux2_1_399/A0
+ sky130_fd_sc_hs__nand3_1_43/A sky130_fd_sc_hs__mux2_1_400/A0 VSS VDD sky130_fd_sc_hs__a222oi_1
Xsky130_fd_sc_hs__o31ai_1_17 VDD VSS sky130_fd_sc_hs__nor2_2_3/B sky130_fd_sc_hs__nor2_2_3/A
+ sky130_fd_sc_hs__o31ai_1_17/B1 sky130_fd_sc_hs__o41ai_1_3/A2 sky130_fd_sc_hs__o31ai_1_17/Y
+ VSS VDD sky130_fd_sc_hs__o31ai_1
Xsky130_fd_sc_hs__clkbuf_16_8 VDD VSS sky130_fd_sc_hs__clkbuf_2_92/A sky130_fd_sc_hs__clkbuf_8_19/X
+ VSS VDD sky130_fd_sc_hs__clkbuf_16
Xsky130_fd_sc_hs__a21oi_1_19 VDD VSS sky130_fd_sc_hs__buf_8_19/X sky130_fd_sc_hs__a21oi_1_19/Y
+ sky130_fd_sc_hs__nand2_1_20/Y sky130_fd_sc_hs__o21ai_1_27/Y VSS VDD sky130_fd_sc_hs__a21oi_1
Xsky130_fd_sc_hs__dfrtp_1_17 sky130_fd_sc_hs__clkbuf_4_4/X VDD VSS sky130_fd_sc_hs__mux2_1_19/A1
+ sky130_fd_sc_hs__clkbuf_2_4/X sky130_fd_sc_hs__mux2_1_19/X VSS VDD sky130_fd_sc_hs__dfrtp_1
Xsky130_fd_sc_hs__dfrtp_1_28 sky130_fd_sc_hs__clkbuf_4_3/A VDD VSS sky130_fd_sc_hs__mux2_1_33/A0
+ sky130_fd_sc_hs__clkbuf_2_9/X sky130_fd_sc_hs__mux2_1_33/X VSS VDD sky130_fd_sc_hs__dfrtp_1
Xsky130_fd_sc_hs__a22oi_1_105 VDD VSS sky130_fd_sc_hs__mux2_1_431/A0 sky130_fd_sc_hs__nand2_1_222/A
+ sky130_fd_sc_hs__a22oi_1_7/B1 sky130_fd_sc_hs__a22o_1_8/A2 sky130_fd_sc_hs__mux2_1_428/A0
+ VSS VDD sky130_fd_sc_hs__a22oi_1
Xsky130_fd_sc_hs__a22oi_1_116 VDD VSS sky130_fd_sc_hs__maj3_1_66/C sky130_fd_sc_hs__nand4_1_14/C
+ sky130_fd_sc_hs__a22oi_1_6/B1 sky130_fd_sc_hs__a22oi_1_5/A2 sky130_fd_sc_hs__mux2_1_458/A0
+ VSS VDD sky130_fd_sc_hs__a22oi_1
Xsky130_fd_sc_hs__dfrtp_1_39 sky130_fd_sc_hs__clkbuf_4_3/A VDD VSS sky130_fd_sc_hs__mux2_1_39/A0
+ sky130_fd_sc_hs__clkbuf_2_8/X sky130_fd_sc_hs__mux2_1_39/X VSS VDD sky130_fd_sc_hs__dfrtp_1
Xsky130_fd_sc_hs__a311o_1_4 VDD VSS sky130_fd_sc_hs__a31o_1_5/A2 sky130_fd_sc_hs__xor2_1_37/X
+ sky130_fd_sc_hs__a31o_1_6/B1 sky130_fd_sc_hs__a31o_1_6/A3 sky130_fd_sc_hs__a32o_1_5/A3
+ sky130_fd_sc_hs__a31o_1_6/A1 VSS VDD sky130_fd_sc_hs__a311o_1
Xsky130_fd_sc_hs__a22o_1_107 VDD VSS sky130_fd_sc_hs__buf_1_103/A sky130_fd_sc_hs__nor2_1_149/Y
+ sky130_fd_sc_hs__nand2_1_125/Y sky130_fd_sc_hs__nor2_2_2/Y sky130_fd_sc_hs__mux2i_1_5/A1
+ VSS VDD sky130_fd_sc_hs__a22o_1
Xsky130_fd_sc_hs__a22o_1_118 VDD VSS sky130_fd_sc_hs__a22o_1_118/X sky130_fd_sc_hs__mux2_1_310/A0
+ sky130_fd_sc_hs__nand2_1_51/B sky130_fd_sc_hs__a22oi_1_6/A2 sky130_fd_sc_hs__mux2_1_475/A1
+ VSS VDD sky130_fd_sc_hs__a22o_1
Xsky130_fd_sc_hs__a22o_1_129 VDD VSS sky130_fd_sc_hs__buf_1_172/A sky130_fd_sc_hs__buf_8_20/X
+ sky130_fd_sc_hs__nor3b_1_3/Y sky130_fd_sc_hs__nand2_1_125/Y sky130_fd_sc_hs__o32ai_1_0/B2
+ VSS VDD sky130_fd_sc_hs__a22o_1
Xsky130_fd_sc_hs__nor3_4_9 VDD VSS sky130_fd_sc_hs__or3b_1_0/B sky130_fd_sc_hs__or2_1_29/X
+ sky130_fd_sc_hs__nor3_4_9/C sky130_fd_sc_hs__nor3_4_9/Y VSS VDD sky130_fd_sc_hs__nor3_4
Xsky130_fd_sc_hs__dfstp_1_4 sky130_fd_sc_hs__clkbuf_4_50/X VDD VSS sky130_fd_sc_hs__nor3_1_44/B
+ sky130_fd_sc_hs__dfstp_1_4/D sky130_fd_sc_hs__dfstp_1_4/CLK VSS VDD sky130_fd_sc_hs__dfstp_1
Xsky130_fd_sc_hs__nand4b_1_3 VDD VSS sky130_fd_sc_hs__or3b_1_1/A sky130_fd_sc_hs__and3b_1_0/X
+ sky130_fd_sc_hs__nand4b_1_3/Y sky130_fd_sc_hs__nand4b_1_3/C sky130_fd_sc_hs__or3b_1_1/B
+ VSS VDD sky130_fd_sc_hs__nand4b_1
Xsky130_fd_sc_hs__o21ai_1_30 VDD VSS sky130_fd_sc_hs__nor2_1_42/A sky130_fd_sc_hs__or2_1_0/B
+ sky130_fd_sc_hs__nor3_1_14/Y sky130_fd_sc_hs__o41ai_1_0/A4 VSS VDD sky130_fd_sc_hs__o21ai_1
Xsky130_fd_sc_hs__o21ai_1_41 VDD VSS sky130_fd_sc_hs__o21ai_1_41/Y sky130_fd_sc_hs__buf_8_2/X
+ sky130_fd_sc_hs__buf_8_10/X sky130_fd_sc_hs__and2_1_6/A VSS VDD sky130_fd_sc_hs__o21ai_1
Xsky130_fd_sc_hs__o21ai_1_52 VDD VSS sky130_fd_sc_hs__a32o_1_8/A2 sky130_fd_sc_hs__or3_1_2/B
+ sky130_fd_sc_hs__or3_1_2/C sky130_fd_sc_hs__or3_1_2/A VSS VDD sky130_fd_sc_hs__o21ai_1
Xsky130_fd_sc_hs__o21ai_1_63 VDD VSS sky130_fd_sc_hs__o21ai_1_63/Y sky130_fd_sc_hs__o21ai_1_63/B1
+ sky130_fd_sc_hs__nor2_1_130/Y sky130_fd_sc_hs__or2_1_23/X VSS VDD sky130_fd_sc_hs__o21ai_1
Xsky130_fd_sc_hs__o21ai_1_74 VDD VSS sky130_fd_sc_hs__o21ai_1_74/Y sky130_fd_sc_hs__o21ai_1_74/B1
+ sky130_fd_sc_hs__nor2_2_3/B sky130_fd_sc_hs__nand4_1_9/Y VSS VDD sky130_fd_sc_hs__o21ai_1
Xsky130_fd_sc_hs__o21ai_1_85 VDD VSS sky130_fd_sc_hs__o21ai_1_85/Y sky130_fd_sc_hs__o21ai_1_85/B1
+ sky130_fd_sc_hs__or2_1_27/X sky130_fd_sc_hs__o21ai_1_85/A1 VSS VDD sky130_fd_sc_hs__o21ai_1
Xsky130_fd_sc_hs__dfrtp_1_309 sky130_fd_sc_hs__clkbuf_4_13/X VDD VSS sky130_fd_sc_hs__buf_1_132/A
+ sky130_fd_sc_hs__clkinv_1_55/A sky130_fd_sc_hs__buf_1_80/X VSS VDD sky130_fd_sc_hs__dfrtp_1
Xsky130_fd_sc_hs__o21ai_1_96 VDD VSS sky130_fd_sc_hs__o21ai_1_96/Y sky130_fd_sc_hs__buf_8_37/X
+ sky130_fd_sc_hs__buf_8_36/X sky130_fd_sc_hs__maj3_1_56/A VSS VDD sky130_fd_sc_hs__o21ai_1
Xsky130_fd_sc_hs__buf_16_4 sky130_fd_sc_hs__mux2_1_8/S VDD VSS sky130_fd_sc_hs__buf_16_4/A
+ VSS VDD sky130_fd_sc_hs__buf_16
Xsky130_fd_sc_hs__dfrtp_1_810 sky130_fd_sc_hs__clkbuf_4_13/X VDD VSS sky130_fd_sc_hs__xor2_1_76/A
+ sky130_fd_sc_hs__clkinv_1_76/A sky130_fd_sc_hs__dfrtp_1_810/D VSS VDD sky130_fd_sc_hs__dfrtp_1
Xsky130_fd_sc_hs__dfrtp_1_821 sky130_fd_sc_hs__clkbuf_4_56/X VDD VSS sky130_fd_sc_hs__mux2_1_355/A1
+ sky130_fd_sc_hs__clkbuf_2_241/X sky130_fd_sc_hs__a22o_1_143/X VSS VDD sky130_fd_sc_hs__dfrtp_1
Xsky130_fd_sc_hs__dfrtp_1_832 sky130_fd_sc_hs__clkbuf_4_12/A VDD VSS sky130_fd_sc_hs__buf_1_15/A
+ sky130_fd_sc_hs__clkbuf_2_18/X sky130_fd_sc_hs__o2bb2ai_1_1/Y VSS VDD sky130_fd_sc_hs__dfrtp_1
Xsky130_fd_sc_hs__clkbuf_4_19 VDD VSS sky130_fd_sc_hs__clkbuf_4_23/A sky130_fd_sc_hs__clkbuf_4_19/X
+ VSS VDD sky130_fd_sc_hs__clkbuf_4
Xsky130_fd_sc_hs__clkbuf_8_6 VDD VSS sky130_fd_sc_hs__mux2_1_341/S sky130_fd_sc_hs__or2_1_25/X
+ VSS VDD sky130_fd_sc_hs__clkbuf_8
Xsky130_fd_sc_hs__a21oi_1_140 VDD VSS sky130_fd_sc_hs__nor3_1_34/C sky130_fd_sc_hs__nor2_1_129/A
+ sky130_fd_sc_hs__nor2_1_127/Y sky130_fd_sc_hs__nor2_1_125/Y VSS VDD sky130_fd_sc_hs__a21oi_1
Xsky130_fd_sc_hs__a21oi_1_151 VDD VSS sky130_fd_sc_hs__nor3_4_7/C sky130_fd_sc_hs__nor2_1_124/B
+ sky130_fd_sc_hs__a22oi_1_59/Y sky130_fd_sc_hs__a22oi_1_64/Y VSS VDD sky130_fd_sc_hs__a21oi_1
Xsky130_fd_sc_hs__a21oi_1_162 VDD VSS sky130_fd_sc_hs__or2_1_30/X sky130_fd_sc_hs__nor2_1_150/B
+ sky130_fd_sc_hs__or2_1_21/X sky130_fd_sc_hs__nor3_1_44/B VSS VDD sky130_fd_sc_hs__a21oi_1
Xsky130_fd_sc_hs__a21oi_1_173 VDD VSS sky130_fd_sc_hs__a311oi_1_13/Y sky130_fd_sc_hs__dfrtp_1_563/D
+ sky130_fd_sc_hs__nand4_1_4/Y sky130_fd_sc_hs__nor3_1_34/C VSS VDD sky130_fd_sc_hs__a21oi_1
Xsky130_fd_sc_hs__a21oi_1_184 VDD VSS sky130_fd_sc_hs__and3_1_12/A sky130_fd_sc_hs__o31a_1_7/A2
+ sky130_fd_sc_hs__and3_1_12/C sky130_fd_sc_hs__and3_1_12/B VSS VDD sky130_fd_sc_hs__a21oi_1
Xsky130_fd_sc_hs__a21oi_1_195 VDD VSS sky130_fd_sc_hs__nand2_1_213/Y sky130_fd_sc_hs__and3_1_12/B
+ sky130_fd_sc_hs__buf_8_33/X sky130_fd_sc_hs__mux2_1_368/A0 VSS VDD sky130_fd_sc_hs__a21oi_1
Xsky130_fd_sc_hs__nor3_1_15 VDD VSS sky130_fd_sc_hs__nor3_1_15/Y sky130_fd_sc_hs__nor3_1_15/C
+ sky130_fd_sc_hs__or2_1_9/B sky130_fd_sc_hs__nor3_1_15/A VSS VDD sky130_fd_sc_hs__nor3_1
Xsky130_fd_sc_hs__nor3_1_26 VDD VSS sky130_fd_sc_hs__nor3_1_26/Y sky130_fd_sc_hs__nor3_1_26/C
+ sky130_fd_sc_hs__nor3_1_26/B sky130_fd_sc_hs__nor3_1_26/A VSS VDD sky130_fd_sc_hs__nor3_1
Xsky130_fd_sc_hs__nor3_1_37 VDD VSS sky130_fd_sc_hs__xor2_1_75/B sky130_fd_sc_hs__nor3_1_37/C
+ sky130_fd_sc_hs__nor3_1_37/B sky130_fd_sc_hs__nor3_1_37/A VSS VDD sky130_fd_sc_hs__nor3_1
Xsky130_fd_sc_hs__nor3_1_48 VDD VSS sky130_fd_sc_hs__xor2_1_79/B sky130_fd_sc_hs__nor3_1_48/C
+ sky130_fd_sc_hs__nor3_1_48/B sky130_fd_sc_hs__nor3_1_48/A VSS VDD sky130_fd_sc_hs__nor3_1
Xsky130_fd_sc_hs__dfrtp_1_106 sky130_fd_sc_hs__clkbuf_4_2/X VDD VSS sky130_fd_sc_hs__mux2_1_101/A1
+ sky130_fd_sc_hs__clkbuf_2_37/X sky130_fd_sc_hs__mux2_1_101/X VSS VDD sky130_fd_sc_hs__dfrtp_1
Xsky130_fd_sc_hs__dfrtp_1_117 sky130_fd_sc_hs__clkbuf_4_2/X VDD VSS sky130_fd_sc_hs__nand2_1_33/A
+ sky130_fd_sc_hs__clkbuf_2_40/X sky130_fd_sc_hs__mux2_1_109/X VSS VDD sky130_fd_sc_hs__dfrtp_1
Xsky130_fd_sc_hs__dfrtp_1_128 sky130_fd_sc_hs__buf_8_1/X VDD VSS sky130_fd_sc_hs__mux2_1_120/A0
+ sky130_fd_sc_hs__clkinv_1_28/A sky130_fd_sc_hs__mux2_1_120/X VSS VDD sky130_fd_sc_hs__dfrtp_1
Xsky130_fd_sc_hs__dfrtp_1_139 sky130_fd_sc_hs__clkbuf_4_10/X VDD VSS sky130_fd_sc_hs__mux2_1_170/A0
+ sky130_fd_sc_hs__clkinv_1_35/A sky130_fd_sc_hs__mux2_1_170/X VSS VDD sky130_fd_sc_hs__dfrtp_1
Xsky130_fd_sc_hs__buf_8_8 VDD VSS sky130_fd_sc_hs__buf_8_8/X sky130_fd_sc_hs__buf_8_8/A
+ VSS VDD sky130_fd_sc_hs__buf_8
Xsky130_fd_sc_hs__clkinv_1_101 VDD VSS sky130_fd_sc_hs__clkinv_1_101/A sky130_fd_sc_hs__clkinv_1_101/Y
+ VSS VDD sky130_fd_sc_hs__clkinv_1
Xsky130_fd_sc_hs__clkinv_1_112 VDD VSS sky130_fd_sc_hs__clkinv_1_112/A sky130_fd_sc_hs__clkinv_1_112/Y
+ VSS VDD sky130_fd_sc_hs__clkinv_1
Xsky130_fd_sc_hs__clkinv_1_123 VDD VSS sky130_fd_sc_hs__clkinv_1_123/A sky130_fd_sc_hs__clkinv_1_123/Y
+ VSS VDD sky130_fd_sc_hs__clkinv_1
Xsky130_fd_sc_hs__clkinv_1_134 VDD VSS sky130_fd_sc_hs__o31a_1_6/A3 sky130_fd_sc_hs__and2_1_40/A
+ VSS VDD sky130_fd_sc_hs__clkinv_1
Xsky130_fd_sc_hs__clkinv_1_145 VDD VSS sky130_fd_sc_hs__clkinv_1_145/A sky130_fd_sc_hs__clkinv_1_145/Y
+ VSS VDD sky130_fd_sc_hs__clkinv_1
Xsky130_fd_sc_hs__clkinv_1_156 VDD VSS sky130_fd_sc_hs__clkinv_1_156/A sky130_fd_sc_hs__clkinv_1_156/Y
+ VSS VDD sky130_fd_sc_hs__clkinv_1
Xsky130_fd_sc_hs__o311ai_1_19 VDD VSS sky130_fd_sc_hs__nor3_4_1/C sky130_fd_sc_hs__or3_1_1/X
+ sky130_fd_sc_hs__buf_1_181/A sky130_fd_sc_hs__o31a_1_5/B1 sky130_fd_sc_hs__o311ai_1_19/Y
+ sky130_fd_sc_hs__or3_1_6/C VSS VDD sky130_fd_sc_hs__o311ai_1
Xsky130_fd_sc_hs__dfrtp_1_640 sky130_fd_sc_hs__buf_8_30/X VDD VSS sky130_fd_sc_hs__mux2_1_348/A0
+ sky130_fd_sc_hs__clkinv_1_145/A sky130_fd_sc_hs__mux2_1_348/X VSS VDD sky130_fd_sc_hs__dfrtp_1
Xsky130_fd_sc_hs__dfrtp_1_651 sky130_fd_sc_hs__clkbuf_4_30/X VDD VSS sky130_fd_sc_hs__mux2_1_297/A0
+ sky130_fd_sc_hs__clkinv_1_142/A sky130_fd_sc_hs__mux2_1_297/X VSS VDD sky130_fd_sc_hs__dfrtp_1
Xsky130_fd_sc_hs__dfrtp_1_662 sky130_fd_sc_hs__clkbuf_4_33/X VDD VSS sky130_fd_sc_hs__mux2_1_361/A1
+ sky130_fd_sc_hs__clkinv_1_150/A sky130_fd_sc_hs__mux2_1_361/X VSS VDD sky130_fd_sc_hs__dfrtp_1
Xsky130_fd_sc_hs__nor2_1_104 VDD VSS sky130_fd_sc_hs__buf_8_11/X sky130_fd_sc_hs__nor2_1_104/Y
+ sky130_fd_sc_hs__xor2_1_68/B VSS VDD sky130_fd_sc_hs__nor2_1
Xsky130_fd_sc_hs__dfrtp_1_673 sky130_fd_sc_hs__clkbuf_4_35/X VDD VSS sky130_fd_sc_hs__nand4_1_11/B
+ sky130_fd_sc_hs__clkinv_1_157/A sky130_fd_sc_hs__mux2_1_375/X VSS VDD sky130_fd_sc_hs__dfrtp_1
Xsky130_fd_sc_hs__nor2_1_115 VDD VSS sky130_fd_sc_hs__xor2_1_74/X sky130_fd_sc_hs__nor2_1_115/Y
+ sky130_fd_sc_hs__maj3_1_48/C VSS VDD sky130_fd_sc_hs__nor2_1
Xsky130_fd_sc_hs__dfrtp_1_684 sky130_fd_sc_hs__clkbuf_4_33/X VDD VSS sky130_fd_sc_hs__mux2_1_388/A0
+ sky130_fd_sc_hs__clkbuf_2_213/X sky130_fd_sc_hs__mux2_1_388/X VSS VDD sky130_fd_sc_hs__dfrtp_1
Xsky130_fd_sc_hs__dfrtp_1_3 sky130_fd_sc_hs__clkbuf_4_4/X VDD VSS sky130_fd_sc_hs__mux2_1_0/A1
+ sky130_fd_sc_hs__clkinv_1_0/A sky130_fd_sc_hs__mux2_1_0/X VSS VDD sky130_fd_sc_hs__dfrtp_1
Xsky130_fd_sc_hs__nor2_1_126 VDD VSS sky130_fd_sc_hs__nor2_1_149/A sky130_fd_sc_hs__nor2_1_126/Y
+ sky130_fd_sc_hs__nor2_4_2/B VSS VDD sky130_fd_sc_hs__nor2_1
Xsky130_fd_sc_hs__dfrtp_1_695 sky130_fd_sc_hs__clkbuf_4_35/X VDD VSS sky130_fd_sc_hs__mux2_1_384/A1
+ sky130_fd_sc_hs__clkbuf_2_210/X sky130_fd_sc_hs__mux2_1_384/X VSS VDD sky130_fd_sc_hs__dfrtp_1
Xsky130_fd_sc_hs__nor2_1_137 VDD VSS sky130_fd_sc_hs__buf_8_11/A sky130_fd_sc_hs__nor2_1_137/Y
+ sky130_fd_sc_hs__xor2_1_77/B VSS VDD sky130_fd_sc_hs__nor2_1
Xsky130_fd_sc_hs__a22oi_1_13 VDD VSS sky130_fd_sc_hs__mux2_1_36/A1 sky130_fd_sc_hs__nand3_1_3/B
+ sky130_fd_sc_hs__a22o_1_9/A2 sky130_fd_sc_hs__a222o_1_2/A2 sky130_fd_sc_hs__mux2_1_35/A0
+ VSS VDD sky130_fd_sc_hs__a22oi_1
Xsky130_fd_sc_hs__nor2_1_148 VDD VSS sky130_fd_sc_hs__nor3b_1_3/B sky130_fd_sc_hs__nor2_1_148/Y
+ sky130_fd_sc_hs__nor2_4_2/A VSS VDD sky130_fd_sc_hs__nor2_1
Xsky130_fd_sc_hs__a22oi_1_24 VDD VSS sky130_fd_sc_hs__mux2_1_80/A0 sky130_fd_sc_hs__nand2_1_14/B
+ sky130_fd_sc_hs__nand2_1_51/B sky130_fd_sc_hs__a222o_1_3/C2 sky130_fd_sc_hs__mux2_1_62/A1
+ VSS VDD sky130_fd_sc_hs__a22oi_1
Xsky130_fd_sc_hs__nor2_1_159 VDD VSS sky130_fd_sc_hs__nor2_1_159/B sky130_fd_sc_hs__nor2_1_159/Y
+ sky130_fd_sc_hs__or3_1_6/A VSS VDD sky130_fd_sc_hs__nor2_1
Xsky130_fd_sc_hs__a22oi_1_35 VDD VSS sky130_fd_sc_hs__mux2_1_479/A0 sky130_fd_sc_hs__nand2_1_24/B
+ sky130_fd_sc_hs__a22oi_1_7/B1 sky130_fd_sc_hs__a22o_1_8/B1 sky130_fd_sc_hs__xor2_1_46/A
+ VSS VDD sky130_fd_sc_hs__a22oi_1
Xsky130_fd_sc_hs__a22oi_1_46 VDD VSS sky130_fd_sc_hs__mux2_1_175/A1 sky130_fd_sc_hs__and4_1_4/B
+ sky130_fd_sc_hs__buf_16_8/X sky130_fd_sc_hs__a222o_1_2/A2 sky130_fd_sc_hs__mux2_1_145/A0
+ VSS VDD sky130_fd_sc_hs__a22oi_1
Xsky130_fd_sc_hs__a22oi_1_57 VDD VSS sky130_fd_sc_hs__mux2_1_39/A0 sky130_fd_sc_hs__nand3_1_4/B
+ sky130_fd_sc_hs__nand2_1_51/B sky130_fd_sc_hs__a22o_1_8/A2 sky130_fd_sc_hs__mux2_1_28/A0
+ VSS VDD sky130_fd_sc_hs__a22oi_1
Xsky130_fd_sc_hs__a22oi_1_68 VDD VSS sky130_fd_sc_hs__o32ai_1_0/A1 sky130_fd_sc_hs__a22oi_1_68/Y
+ sky130_fd_sc_hs__nor2b_1_49/Y sky130_fd_sc_hs__nor2b_1_51/Y sky130_fd_sc_hs__dfrtp_1_500/Q
+ VSS VDD sky130_fd_sc_hs__a22oi_1
Xsky130_fd_sc_hs__a22oi_1_79 VDD VSS sky130_fd_sc_hs__mux2_1_307/A1 sky130_fd_sc_hs__and4_1_7/B
+ sky130_fd_sc_hs__buf_8_32/X sky130_fd_sc_hs__buf_4_7/X sky130_fd_sc_hs__mux2_1_309/A0
+ VSS VDD sky130_fd_sc_hs__a22oi_1
Xsky130_fd_sc_hs__nor2_1_70 VDD VSS sky130_fd_sc_hs__nor3_1_20/A sky130_fd_sc_hs__nor2_1_70/Y
+ sky130_fd_sc_hs__nor2_1_70/A VSS VDD sky130_fd_sc_hs__nor2_1
Xsky130_fd_sc_hs__nor2_1_81 VDD VSS sky130_fd_sc_hs__nor2_1_81/B sky130_fd_sc_hs__nor2_1_81/Y
+ sky130_fd_sc_hs__nor2_1_81/A VSS VDD sky130_fd_sc_hs__nor2_1
Xsky130_fd_sc_hs__nor2_1_92 VDD VSS sky130_fd_sc_hs__nor2_1_92/B sky130_fd_sc_hs__nor2_1_92/Y
+ sky130_fd_sc_hs__nor2_4_0/B VSS VDD sky130_fd_sc_hs__nor2_1
Xsky130_fd_sc_hs__xnor2_1_1 VDD VSS sky130_fd_sc_hs__xor2_1_9/A sky130_fd_sc_hs__xnor2_1_1/Y
+ sky130_fd_sc_hs__nor3_1_0/Y VSS VDD sky130_fd_sc_hs__xnor2_1
Xsky130_fd_sc_hs__a31o_1_6 VDD VSS sky130_fd_sc_hs__a31o_1_6/X sky130_fd_sc_hs__a31o_1_6/A3
+ sky130_fd_sc_hs__a32o_1_5/A3 sky130_fd_sc_hs__a31o_1_6/A1 sky130_fd_sc_hs__a31o_1_6/B1
+ VSS VDD sky130_fd_sc_hs__a31o_1
Xsky130_fd_sc_hs__or2_1_0 VDD VSS sky130_fd_sc_hs__or2_1_0/B sky130_fd_sc_hs__or2_1_0/A
+ sky130_fd_sc_hs__or2_1_0/X VSS VDD sky130_fd_sc_hs__or2_1
Xsky130_fd_sc_hs__dfrtp_1_470 sky130_fd_sc_hs__clkbuf_4_22/A VDD VSS sky130_fd_sc_hs__maj3_1_44/C
+ sky130_fd_sc_hs__clkbuf_2_142/X sky130_fd_sc_hs__a22o_1_101/X VSS VDD sky130_fd_sc_hs__dfrtp_1
Xsky130_fd_sc_hs__dfrtp_1_481 sky130_fd_sc_hs__clkbuf_4_23/A VDD VSS sky130_fd_sc_hs__nand2_1_123/A
+ sky130_fd_sc_hs__clkbuf_2_149/X sky130_fd_sc_hs__o31ai_1_13/Y VSS VDD sky130_fd_sc_hs__dfrtp_1
Xsky130_fd_sc_hs__dfrtp_1_492 sky130_fd_sc_hs__clkbuf_4_23/X VDD VSS sky130_fd_sc_hs__o32ai_1_0/B2
+ sky130_fd_sc_hs__clkbuf_2_155/X sky130_fd_sc_hs__dfrtp_1_492/D VSS VDD sky130_fd_sc_hs__dfrtp_1
Xsky130_fd_sc_hs__clkbuf_4_0 VDD VSS sky130_fd_sc_hs__buf_8_38/X sky130_fd_sc_hs__clkbuf_4_0/X
+ VSS VDD sky130_fd_sc_hs__clkbuf_4
Xsky130_fd_sc_hs__o21a_1_16 VDD VSS sky130_fd_sc_hs__o21a_1_16/X sky130_fd_sc_hs__nor2_1_57/Y
+ sky130_fd_sc_hs__o21a_1_16/B1 sky130_fd_sc_hs__o21a_1_16/A1 VSS VDD sky130_fd_sc_hs__o21a_1
Xsky130_fd_sc_hs__o21a_1_27 VDD VSS sky130_fd_sc_hs__o22a_1_0/B1 sky130_fd_sc_hs__o21a_1_27/A2
+ sky130_fd_sc_hs__o21a_1_27/B1 sky130_fd_sc_hs__or2_1_22/B VSS VDD sky130_fd_sc_hs__o21a_1
Xsky130_fd_sc_hs__and2_1_17 VDD VSS sky130_fd_sc_hs__nor2_1_52/A sky130_fd_sc_hs__and3_1_9/X
+ sky130_fd_sc_hs__nor3_1_16/B VSS VDD sky130_fd_sc_hs__and2_1
Xsky130_fd_sc_hs__and2_1_28 VDD VSS sky130_fd_sc_hs__maj3_1_34/A sky130_fd_sc_hs__xor2_1_65/A
+ sky130_fd_sc_hs__and2_1_28/X VSS VDD sky130_fd_sc_hs__and2_1
Xsky130_fd_sc_hs__and2_1_39 VDD VSS sky130_fd_sc_hs__or2_1_15/A sky130_fd_sc_hs__and2_1_39/B
+ sky130_fd_sc_hs__or2_1_27/A VSS VDD sky130_fd_sc_hs__and2_1
Xsky130_fd_sc_hs__clkinv_4_0 VDD VSS sky130_fd_sc_hs__clkinv_4_0/Y sky130_fd_sc_hs__clkinv_4_0/A
+ VSS VDD sky130_fd_sc_hs__clkinv_4
Xsky130_fd_sc_hs__nor4b_1_0 VDD VSS sky130_fd_sc_hs__nor4b_1_0/Y sky130_fd_sc_hs__and3_1_6/A
+ sky130_fd_sc_hs__and3_1_6/B sky130_fd_sc_hs__or2_1_9/A sky130_fd_sc_hs__nor4b_1_0/C
+ VSS VDD sky130_fd_sc_hs__nor4b_1
Xsky130_fd_sc_hs__mux2_1_430 VDD VSS sky130_fd_sc_hs__mux2_1_430/X sky130_fd_sc_hs__buf_16_1/X
+ sky130_fd_sc_hs__mux2_1_430/A0 sky130_fd_sc_hs__a22o_1_84/B2 VSS VDD sky130_fd_sc_hs__mux2_1
Xsky130_fd_sc_hs__mux2_1_441 VDD VSS sky130_fd_sc_hs__mux2_1_441/X sky130_fd_sc_hs__buf_16_6/A
+ sky130_fd_sc_hs__mux2_1_441/A0 sky130_fd_sc_hs__a22o_1_91/B2 VSS VDD sky130_fd_sc_hs__mux2_1
Xsky130_fd_sc_hs__mux2_1_452 VDD VSS sky130_fd_sc_hs__mux2_1_452/X sky130_fd_sc_hs__buf_16_10/A
+ sky130_fd_sc_hs__mux2_1_452/A0 sky130_fd_sc_hs__a22o_1_91/B2 VSS VDD sky130_fd_sc_hs__mux2_1
Xsky130_fd_sc_hs__mux2_1_463 VDD VSS sky130_fd_sc_hs__mux2_1_463/X sky130_fd_sc_hs__buf_16_5/X
+ sky130_fd_sc_hs__mux2_1_463/A0 sky130_fd_sc_hs__a22o_1_95/B2 VSS VDD sky130_fd_sc_hs__mux2_1
Xsky130_fd_sc_hs__mux2_1_474 VDD VSS sky130_fd_sc_hs__mux2_1_474/X sky130_fd_sc_hs__buf_16_1/X
+ sky130_fd_sc_hs__mux2_1_474/A0 sky130_fd_sc_hs__a22o_1_62/B2 VSS VDD sky130_fd_sc_hs__mux2_1
Xsky130_fd_sc_hs__mux2_1_485 VDD VSS sky130_fd_sc_hs__mux2_1_485/X sky130_fd_sc_hs__or2_1_29/A
+ sky130_fd_sc_hs__or3_1_3/C sky130_fd_sc_hs__o21ai_1_58/Y VSS VDD sky130_fd_sc_hs__mux2_1
Xsky130_fd_sc_hs__buf_4_2 VDD VSS sky130_fd_sc_hs__buf_4_2/A sky130_fd_sc_hs__buf_4_2/X
+ VSS VDD sky130_fd_sc_hs__buf_4
Xsky130_fd_sc_hs__nand3_1_19 VDD VSS sky130_fd_sc_hs__or2_1_12/X sky130_fd_sc_hs__a31o_1_7/A2
+ sky130_fd_sc_hs__a21o_1_3/A1 sky130_fd_sc_hs__maj3_1_27/X VSS VDD sky130_fd_sc_hs__nand3_1
Xsky130_fd_sc_hs__mux2i_1_16 VDD VSS sky130_fd_sc_hs__mux2i_1_16/S sky130_fd_sc_hs__and2_1_34/B
+ sky130_fd_sc_hs__and2_1_34/A sky130_fd_sc_hs__mux2i_1_16/Y VSS VDD sky130_fd_sc_hs__mux2i_1
Xsky130_fd_sc_hs__buf_1_16 VDD VSS sky130_fd_sc_hs__buf_1_16/A srm_total_count[2]
+ VSS VDD sky130_fd_sc_hs__buf_1
Xsky130_fd_sc_hs__buf_1_27 VDD VSS sky130_fd_sc_hs__buf_1_27/A w_wr_data[17] VSS VDD
+ sky130_fd_sc_hs__buf_1
Xsky130_fd_sc_hs__buf_1_38 VDD VSS sky130_fd_sc_hs__buf_1_38/A w_wr_data[26] VSS VDD
+ sky130_fd_sc_hs__buf_1
Xsky130_fd_sc_hs__buf_1_49 VDD VSS sky130_fd_sc_hs__buf_1_49/A w_wr_data[5] VSS VDD
+ sky130_fd_sc_hs__buf_1
Xsky130_fd_sc_hs__a22o_1_30 VDD VSS sky130_fd_sc_hs__a22o_1_30/X sky130_fd_sc_hs__a22o_1_69/A1
+ sky130_fd_sc_hs__a22o_1_93/B1 sky130_fd_sc_hs__a22o_1_93/A2 sky130_fd_sc_hs__maj3_1_14/C
+ VSS VDD sky130_fd_sc_hs__a22o_1
Xsky130_fd_sc_hs__a22o_1_41 VDD VSS sky130_fd_sc_hs__a22o_1_41/X sky130_fd_sc_hs__buf_8_14/X
+ sky130_fd_sc_hs__xnor2_1_73/Y sky130_fd_sc_hs__a32o_1_7/B1 sky130_fd_sc_hs__maj3_1_19/C
+ VSS VDD sky130_fd_sc_hs__a22o_1
Xsky130_fd_sc_hs__a22o_1_52 VDD VSS sky130_fd_sc_hs__a22o_1_52/X sky130_fd_sc_hs__a22o_1_68/A1
+ sky130_fd_sc_hs__a22o_1_93/B1 sky130_fd_sc_hs__a22o_1_93/A2 sky130_fd_sc_hs__xor2_1_44/A
+ VSS VDD sky130_fd_sc_hs__a22o_1
Xsky130_fd_sc_hs__a22o_1_63 VDD VSS sky130_fd_sc_hs__a22o_1_63/X sky130_fd_sc_hs__mux2_1_7/A1
+ sky130_fd_sc_hs__buf_8_17/X sky130_fd_sc_hs__buf_8_15/X sky130_fd_sc_hs__a22o_1_63/A1
+ VSS VDD sky130_fd_sc_hs__a22o_1
Xsky130_fd_sc_hs__a22o_1_74 VDD VSS sky130_fd_sc_hs__dfrtp_2_2/D sky130_fd_sc_hs__dfrtp_2_2/Q
+ sky130_fd_sc_hs__buf_8_17/X sky130_fd_sc_hs__buf_8_15/X sky130_fd_sc_hs__a22o_1_82/B2
+ VSS VDD sky130_fd_sc_hs__a22o_1
Xsky130_fd_sc_hs__clkbuf_2_30 VDD VSS sky130_fd_sc_hs__clkinv_1_13/A sky130_fd_sc_hs__clkbuf_2_3/A
+ VSS VDD sky130_fd_sc_hs__clkbuf_2
Xsky130_fd_sc_hs__a22o_1_85 VDD VSS sky130_fd_sc_hs__a22o_1_85/X sky130_fd_sc_hs__a22o_1_94/A1
+ sky130_fd_sc_hs__a22o_1_90/B1 sky130_fd_sc_hs__a22o_1_90/A2 sky130_fd_sc_hs__maj3_1_33/C
+ VSS VDD sky130_fd_sc_hs__a22o_1
Xsky130_fd_sc_hs__clkbuf_2_41 VDD VSS sky130_fd_sc_hs__clkinv_1_28/A sky130_fd_sc_hs__inv_8_0/A
+ VSS VDD sky130_fd_sc_hs__clkbuf_2
Xsky130_fd_sc_hs__a22o_1_96 VDD VSS sky130_fd_sc_hs__a22o_1_96/X sky130_fd_sc_hs__o31a_1_2/X
+ sky130_fd_sc_hs__o21ai_1_48/Y sky130_fd_sc_hs__buf_8_13/A sky130_fd_sc_hs__maj3_1_31/C
+ VSS VDD sky130_fd_sc_hs__a22o_1
Xsky130_fd_sc_hs__clkbuf_2_52 VDD VSS sky130_fd_sc_hs__clkinv_2_1/A sky130_fd_sc_hs__clkinv_4_1/A
+ VSS VDD sky130_fd_sc_hs__clkbuf_2
Xsky130_fd_sc_hs__clkbuf_2_63 VDD VSS sky130_fd_sc_hs__clkinv_1_44/A sky130_fd_sc_hs__inv_8_0/A
+ VSS VDD sky130_fd_sc_hs__clkbuf_2
Xsky130_fd_sc_hs__a21o_1_5 VDD VSS sky130_fd_sc_hs__a21o_1_5/X sky130_fd_sc_hs__and3_1_6/C
+ sky130_fd_sc_hs__nor3_1_15/Y sky130_fd_sc_hs__nor2_1_48/Y VSS VDD sky130_fd_sc_hs__a21o_1
Xsky130_fd_sc_hs__clkbuf_2_74 VDD VSS sky130_fd_sc_hs__clkbuf_2_74/X sky130_fd_sc_hs__clkinv_4_2/A
+ VSS VDD sky130_fd_sc_hs__clkbuf_2
Xsky130_fd_sc_hs__nand4_1_2 VDD VSS sky130_fd_sc_hs__and3_1_7/A sky130_fd_sc_hs__nor4b_1_0/C
+ sky130_fd_sc_hs__buf_1_65/X sky130_fd_sc_hs__nand4_1_2/B sky130_fd_sc_hs__and3_1_6/C
+ VSS VDD sky130_fd_sc_hs__nand4_1
Xsky130_fd_sc_hs__clkbuf_2_85 VDD VSS sky130_fd_sc_hs__clkinv_1_55/A sky130_fd_sc_hs__clkinv_4_3/A
+ VSS VDD sky130_fd_sc_hs__clkbuf_2
Xsky130_fd_sc_hs__clkbuf_2_96 VDD VSS sky130_fd_sc_hs__clkinv_1_63/A sky130_fd_sc_hs__clkinv_4_2/A
+ VSS VDD sky130_fd_sc_hs__clkbuf_2
Xsky130_fd_sc_hs__maj3_1_14 VDD VSS sky130_fd_sc_hs__xor2_1_24/A sky130_fd_sc_hs__xor2_1_24/B
+ sky130_fd_sc_hs__maj3_1_14/X sky130_fd_sc_hs__maj3_1_14/C VSS VDD sky130_fd_sc_hs__maj3_1
Xsky130_fd_sc_hs__maj3_1_25 VDD VSS sky130_fd_sc_hs__and2_1_7/A sky130_fd_sc_hs__xor2_1_46/A
+ sky130_fd_sc_hs__maj3_1_25/X sky130_fd_sc_hs__xor2_1_46/B VSS VDD sky130_fd_sc_hs__maj3_1
Xsky130_fd_sc_hs__maj3_1_36 VDD VSS sky130_fd_sc_hs__xor2_1_67/A sky130_fd_sc_hs__xor2_1_67/B
+ sky130_fd_sc_hs__xor2_1_93/A sky130_fd_sc_hs__maj3_1_36/C VSS VDD sky130_fd_sc_hs__maj3_1
Xsky130_fd_sc_hs__maj3_1_47 VDD VSS sky130_fd_sc_hs__xor2_1_78/A sky130_fd_sc_hs__xor2_1_78/B
+ sky130_fd_sc_hs__xor2_1_72/A sky130_fd_sc_hs__maj3_1_47/C VSS VDD sky130_fd_sc_hs__maj3_1
Xsky130_fd_sc_hs__maj3_1_58 VDD VSS sky130_fd_sc_hs__xor2_1_85/A sky130_fd_sc_hs__xor2_1_90/A
+ sky130_fd_sc_hs__maj3_1_58/X sky130_fd_sc_hs__xor2_1_90/B VSS VDD sky130_fd_sc_hs__maj3_1
Xsky130_fd_sc_hs__nand2_1_30 VDD VSS sky130_fd_sc_hs__a311o_1_3/X sky130_fd_sc_hs__nand2_1_30/Y
+ sky130_fd_sc_hs__nand3_1_11/A VSS VDD sky130_fd_sc_hs__nand2_1
Xsky130_fd_sc_hs__nand2_1_41 VDD VSS sky130_fd_sc_hs__o21ai_1_17/Y sky130_fd_sc_hs__nand2b_1_7/B
+ sky130_fd_sc_hs__nand3b_1_1/Y VSS VDD sky130_fd_sc_hs__nand2_1
Xsky130_fd_sc_hs__mux2_1_260 VDD VSS sky130_fd_sc_hs__mux2_1_260/X sky130_fd_sc_hs__buf_16_5/X
+ sky130_fd_sc_hs__mux2_1_260/A0 sky130_fd_sc_hs__a22o_1_62/B2 VSS VDD sky130_fd_sc_hs__mux2_1
Xsky130_fd_sc_hs__mux2_1_271 VDD VSS sky130_fd_sc_hs__mux2_1_271/X sky130_fd_sc_hs__buf_4_1/A
+ sky130_fd_sc_hs__mux2_1_477/A1 sky130_fd_sc_hs__a222o_1_5/A1 VSS VDD sky130_fd_sc_hs__mux2_1
Xsky130_fd_sc_hs__nand2_1_52 VDD VSS sky130_fd_sc_hs__buf_16_9/X sky130_fd_sc_hs__nand4_1_1/A
+ sky130_fd_sc_hs__nand2_1_52/A VSS VDD sky130_fd_sc_hs__nand2_1
Xsky130_fd_sc_hs__nand2_1_63 VDD VSS sky130_fd_sc_hs__and3_1_7/X sky130_fd_sc_hs__nor2_1_57/A
+ sky130_fd_sc_hs__buf_1_66/X VSS VDD sky130_fd_sc_hs__nand2_1
Xsky130_fd_sc_hs__mux2_1_282 VDD VSS sky130_fd_sc_hs__mux2_1_282/X sky130_fd_sc_hs__nor2_2_5/Y
+ sky130_fd_sc_hs__mux2_1_282/A0 sky130_fd_sc_hs__mux2_1_473/A1 VSS VDD sky130_fd_sc_hs__mux2_1
Xsky130_fd_sc_hs__nand2_1_74 VDD VSS sky130_fd_sc_hs__nand2_1_74/B sky130_fd_sc_hs__nand2_1_74/Y
+ sky130_fd_sc_hs__a31o_1_6/A3 VSS VDD sky130_fd_sc_hs__nand2_1
Xsky130_fd_sc_hs__mux2_1_293 VDD VSS sky130_fd_sc_hs__mux2_1_293/X sky130_fd_sc_hs__buf_4_0/X
+ sky130_fd_sc_hs__mux2_1_293/A0 sky130_fd_sc_hs__a22o_1_61/B2 VSS VDD sky130_fd_sc_hs__mux2_1
Xsky130_fd_sc_hs__nand2_1_85 VDD VSS sky130_fd_sc_hs__nand2_1_85/B sky130_fd_sc_hs__nand2_1_85/Y
+ sky130_fd_sc_hs__nand2_1_85/A VSS VDD sky130_fd_sc_hs__nand2_1
Xsky130_fd_sc_hs__a222oi_1_15 VDD VSS sky130_fd_sc_hs__a22o_1_9/A2 sky130_fd_sc_hs__mux2_1_312/A1
+ sky130_fd_sc_hs__buf_8_33/X sky130_fd_sc_hs__a22o_1_8/B1 sky130_fd_sc_hs__or2_1_15/B
+ sky130_fd_sc_hs__nand3_1_36/B sky130_fd_sc_hs__mux2_1_320/A0 VSS VDD sky130_fd_sc_hs__a222oi_1
Xsky130_fd_sc_hs__nand2_1_96 VDD VSS sky130_fd_sc_hs__nand2_1_96/B sky130_fd_sc_hs__nand2_1_96/Y
+ sky130_fd_sc_hs__nor2_1_81/A VSS VDD sky130_fd_sc_hs__nand2_1
Xsky130_fd_sc_hs__a222oi_1_26 VDD VSS sky130_fd_sc_hs__a222o_1_3/C2 sky130_fd_sc_hs__mux2_1_412/A1
+ sky130_fd_sc_hs__buf_16_8/X sky130_fd_sc_hs__a22oi_1_6/A2 sky130_fd_sc_hs__mux2_1_409/A1
+ sky130_fd_sc_hs__nand4_1_14/B sky130_fd_sc_hs__mux2_1_414/A1 VSS VDD sky130_fd_sc_hs__a222oi_1
Xsky130_fd_sc_hs__o31ai_1_18 VDD VSS sky130_fd_sc_hs__nor2_2_5/B sky130_fd_sc_hs__o41ai_1_3/A2
+ sky130_fd_sc_hs__o21ai_1_75/Y sky130_fd_sc_hs__or3_1_5/B sky130_fd_sc_hs__o31ai_1_18/Y
+ VSS VDD sky130_fd_sc_hs__o31ai_1
Xsky130_fd_sc_hs__clkbuf_16_9 VDD VSS sky130_fd_sc_hs__clkinv_4_4/A sky130_fd_sc_hs__clkbuf_8_19/X
+ VSS VDD sky130_fd_sc_hs__clkbuf_16
Xsky130_fd_sc_hs__dfrtp_1_18 sky130_fd_sc_hs__clkbuf_4_3/X VDD VSS sky130_fd_sc_hs__mux2_1_20/A0
+ sky130_fd_sc_hs__clkbuf_2_10/X sky130_fd_sc_hs__mux2_1_20/X VSS VDD sky130_fd_sc_hs__dfrtp_1
Xsky130_fd_sc_hs__a22oi_1_106 VDD VSS sky130_fd_sc_hs__mux2_1_422/A1 sky130_fd_sc_hs__nand2_1_221/A
+ sky130_fd_sc_hs__clkbuf_8_14/X sky130_fd_sc_hs__nand2_1_33/B sky130_fd_sc_hs__mux2_1_418/A0
+ VSS VDD sky130_fd_sc_hs__a22oi_1
Xsky130_fd_sc_hs__dfrtp_1_29 sky130_fd_sc_hs__clkbuf_4_3/X VDD VSS sky130_fd_sc_hs__buf_1_24/A
+ sky130_fd_sc_hs__clkbuf_2_9/X sky130_fd_sc_hs__mux2_1_123/X VSS VDD sky130_fd_sc_hs__dfrtp_1
Xsky130_fd_sc_hs__a22oi_1_117 VDD VSS sky130_fd_sc_hs__mux2_1_472/A1 sky130_fd_sc_hs__nand2_1_205/B
+ sky130_fd_sc_hs__a22o_1_9/A2 sky130_fd_sc_hs__nand2_1_33/B sky130_fd_sc_hs__mux2_1_423/A0
+ VSS VDD sky130_fd_sc_hs__a22oi_1
Xsky130_fd_sc_hs__a311o_1_5 VDD VSS sky130_fd_sc_hs__a31o_1_9/A2 sky130_fd_sc_hs__xnor2_1_67/Y
+ sky130_fd_sc_hs__a311o_1_5/B1 sky130_fd_sc_hs__a31o_1_7/A2 sky130_fd_sc_hs__a32o_1_6/A3
+ sky130_fd_sc_hs__nand2_1_81/A VSS VDD sky130_fd_sc_hs__a311o_1
Xsky130_fd_sc_hs__a22o_1_108 VDD VSS sky130_fd_sc_hs__buf_1_109/A sky130_fd_sc_hs__nor2_2_2/Y
+ sky130_fd_sc_hs__nor2_1_153/Y sky130_fd_sc_hs__nand2_1_125/Y sky130_fd_sc_hs__nor3_1_33/A
+ VSS VDD sky130_fd_sc_hs__a22o_1
Xsky130_fd_sc_hs__a22o_1_119 VDD VSS sky130_fd_sc_hs__a22o_1_119/X sky130_fd_sc_hs__o31a_1_6/X
+ sky130_fd_sc_hs__o21ai_1_86/Y sky130_fd_sc_hs__o31ai_4_0/Y sky130_fd_sc_hs__nor2_1_77/A
+ VSS VDD sky130_fd_sc_hs__a22o_1
Xsky130_fd_sc_hs__dlygate4sd3_1_20 VSS VDD sky130_fd_sc_hs__buf_1_93/X sky130_fd_sc_hs__dfrtp_1_451/D
+ VSS VDD sky130_fd_sc_hs__dlygate4sd3_1
Xsky130_fd_sc_hs__o21ai_1_20 VDD VSS sky130_fd_sc_hs__xnor2_1_25/A sky130_fd_sc_hs__nand2b_1_4/Y
+ sky130_fd_sc_hs__or2_1_6/X sky130_fd_sc_hs__xor2_1_2/X VSS VDD sky130_fd_sc_hs__o21ai_1
Xsky130_fd_sc_hs__o21ai_1_31 VDD VSS sky130_fd_sc_hs__or2_1_0/B sky130_fd_sc_hs__nor2_2_0/A
+ sky130_fd_sc_hs__nor2_2_1/B sky130_fd_sc_hs__nor2_2_1/A VSS VDD sky130_fd_sc_hs__o21ai_1
Xsky130_fd_sc_hs__o21ai_1_42 VDD VSS sky130_fd_sc_hs__o21ai_1_42/Y sky130_fd_sc_hs__o21ai_1_7/B1
+ sky130_fd_sc_hs__and2_1_20/X sky130_fd_sc_hs__nor2_1_71/Y VSS VDD sky130_fd_sc_hs__o21ai_1
Xsky130_fd_sc_hs__o21ai_1_53 VDD VSS sky130_fd_sc_hs__o21ai_1_53/Y sky130_fd_sc_hs__o21ai_1_53/B1
+ sky130_fd_sc_hs__buf_8_12/A sky130_fd_sc_hs__and4_1_5/A VSS VDD sky130_fd_sc_hs__o21ai_1
Xsky130_fd_sc_hs__o21ai_1_64 VDD VSS sky130_fd_sc_hs__o21ai_1_64/Y sky130_fd_sc_hs__nor4b_1_1/B
+ sky130_fd_sc_hs__or3_1_4/B sky130_fd_sc_hs__or3_1_4/A VSS VDD sky130_fd_sc_hs__o21ai_1
Xsky130_fd_sc_hs__o21ai_1_75 VDD VSS sky130_fd_sc_hs__o21ai_1_75/Y sky130_fd_sc_hs__buf_1_168/A
+ sky130_fd_sc_hs__nor2_1_159/Y sky130_fd_sc_hs__o31a_1_5/X VSS VDD sky130_fd_sc_hs__o21ai_1
Xsky130_fd_sc_hs__o21ai_1_86 VDD VSS sky130_fd_sc_hs__o21ai_1_86/Y sky130_fd_sc_hs__o31a_1_6/A1
+ sky130_fd_sc_hs__o31a_1_6/A3 sky130_fd_sc_hs__o31a_1_6/A2 VSS VDD sky130_fd_sc_hs__o21ai_1
Xsky130_fd_sc_hs__o21ai_1_97 VDD VSS sky130_fd_sc_hs__o21ai_1_97/Y sky130_fd_sc_hs__nor2_4_2/Y
+ sky130_fd_sc_hs__a21o_1_7/A2 sky130_fd_sc_hs__maj3_1_59/X VSS VDD sky130_fd_sc_hs__o21ai_1
Xsky130_fd_sc_hs__buf_16_5 sky130_fd_sc_hs__buf_16_5/X VDD VSS sky130_fd_sc_hs__buf_16_5/A
+ VSS VDD sky130_fd_sc_hs__buf_16
Xsky130_fd_sc_hs__dfrtp_1_800 sky130_fd_sc_hs__buf_8_1/A VDD VSS sky130_fd_sc_hs__and2_1_9/B
+ sky130_fd_sc_hs__clkinv_1_128/A sky130_fd_sc_hs__mux2_1_473/X VSS VDD sky130_fd_sc_hs__dfrtp_1
Xsky130_fd_sc_hs__dfrtp_1_811 sky130_fd_sc_hs__clkbuf_4_13/X VDD VSS sky130_fd_sc_hs__xor2_1_67/A
+ sky130_fd_sc_hs__clkinv_1_89/A sky130_fd_sc_hs__mux2_1_487/X VSS VDD sky130_fd_sc_hs__dfrtp_1
Xsky130_fd_sc_hs__dfrtp_1_822 sky130_fd_sc_hs__clkbuf_16_5/X VDD VSS sky130_fd_sc_hs__mux2_1_486/A0
+ sky130_fd_sc_hs__clkinv_1_42/A sky130_fd_sc_hs__mux2_1_486/X VSS VDD sky130_fd_sc_hs__dfrtp_1
Xsky130_fd_sc_hs__dfrtp_1_833 sky130_fd_sc_hs__clkbuf_4_12/A VDD VSS sky130_fd_sc_hs__buf_1_19/A
+ sky130_fd_sc_hs__clkbuf_2_18/X sky130_fd_sc_hs__o2bb2ai_1_0/Y VSS VDD sky130_fd_sc_hs__dfrtp_1
Xsky130_fd_sc_hs__clkbuf_8_7 VDD VSS sky130_fd_sc_hs__nor2_1_93/B sky130_fd_sc_hs__nor2_2_5/Y
+ VSS VDD sky130_fd_sc_hs__clkbuf_8
Xsky130_fd_sc_hs__a21oi_1_130 VDD VSS sky130_fd_sc_hs__buf_8_12/A sky130_fd_sc_hs__o21ai_1_55/B1
+ sky130_fd_sc_hs__xor2_1_73/X sky130_fd_sc_hs__maj3_1_43/X VSS VDD sky130_fd_sc_hs__a21oi_1
Xsky130_fd_sc_hs__a21oi_1_141 VDD VSS sky130_fd_sc_hs__nor3_1_31/Y sky130_fd_sc_hs__o31ai_1_13/A3
+ sky130_fd_sc_hs__nor3_1_43/Y sky130_fd_sc_hs__a211oi_1_5/Y VSS VDD sky130_fd_sc_hs__a21oi_1
Xsky130_fd_sc_hs__a21oi_1_152 VDD VSS sky130_fd_sc_hs__o21bai_1_4/Y sky130_fd_sc_hs__a21oi_1_152/Y
+ sky130_fd_sc_hs__nor2_1_128/B sky130_fd_sc_hs__o21ai_1_61/Y VSS VDD sky130_fd_sc_hs__a21oi_1
Xsky130_fd_sc_hs__a21oi_1_163 VDD VSS sky130_fd_sc_hs__or2_1_30/B sky130_fd_sc_hs__nor3_1_41/C
+ sky130_fd_sc_hs__and2_1_36/X sky130_fd_sc_hs__nor3_1_44/B VSS VDD sky130_fd_sc_hs__a21oi_1
Xsky130_fd_sc_hs__a21oi_1_174 VDD VSS sky130_fd_sc_hs__buf_1_162/A sky130_fd_sc_hs__a21oi_1_174/Y
+ sky130_fd_sc_hs__buf_4_6/X sky130_fd_sc_hs__nand4_1_9/D VSS VDD sky130_fd_sc_hs__a21oi_1
Xsky130_fd_sc_hs__a21oi_1_185 VDD VSS sky130_fd_sc_hs__o21ai_1_90/Y sky130_fd_sc_hs__o21ai_1_91/A1
+ sky130_fd_sc_hs__xnor2_1_125/Y sky130_fd_sc_hs__buf_8_36/X VSS VDD sky130_fd_sc_hs__a21oi_1
Xsky130_fd_sc_hs__a21oi_1_196 VDD VSS sky130_fd_sc_hs__o21ai_1_99/Y sky130_fd_sc_hs__a21oi_1_196/Y
+ sky130_fd_sc_hs__xnor2_1_141/Y sky130_fd_sc_hs__buf_8_36/X VSS VDD sky130_fd_sc_hs__a21oi_1
Xsky130_fd_sc_hs__clkbuf_2_190 VDD VSS sky130_fd_sc_hs__clkbuf_2_190/X sky130_fd_sc_hs__clkbuf_2_193/X
+ VSS VDD sky130_fd_sc_hs__clkbuf_2
Xsky130_fd_sc_hs__nand2_1_190 VDD VSS sky130_fd_sc_hs__nor2b_1_46/Y sky130_fd_sc_hs__nor2_2_6/B
+ sky130_fd_sc_hs__nor2b_1_45/A VSS VDD sky130_fd_sc_hs__nand2_1
Xsky130_fd_sc_hs__nor3_1_16 VDD VSS sky130_fd_sc_hs__nor3_1_16/Y sky130_fd_sc_hs__nor3_1_16/C
+ sky130_fd_sc_hs__nor3_1_16/B sky130_fd_sc_hs__o32a_1_0/A2 VSS VDD sky130_fd_sc_hs__nor3_1
Xsky130_fd_sc_hs__nor3_1_27 VDD VSS sky130_fd_sc_hs__nor3_1_27/Y sky130_fd_sc_hs__or3_1_9/C
+ sky130_fd_sc_hs__or3_1_9/B sky130_fd_sc_hs__or3_1_9/A VSS VDD sky130_fd_sc_hs__nor3_1
Xsky130_fd_sc_hs__nor3_1_38 VDD VSS sky130_fd_sc_hs__nor3_1_38/Y sky130_fd_sc_hs__nor3_1_38/C
+ sky130_fd_sc_hs__nor3_1_38/B sky130_fd_sc_hs__xor2_1_75/A VSS VDD sky130_fd_sc_hs__nor3_1
Xsky130_fd_sc_hs__nor3_1_49 VDD VSS sky130_fd_sc_hs__nor3_1_49/Y sky130_fd_sc_hs__nor3_1_49/C
+ sky130_fd_sc_hs__nor3_1_49/B sky130_fd_sc_hs__nor3_1_49/A VSS VDD sky130_fd_sc_hs__nor3_1
Xsky130_fd_sc_hs__nand2_2_0 VDD VSS sky130_fd_sc_hs__or3_1_6/A sky130_fd_sc_hs__nor3_1_24/C
+ sky130_fd_sc_hs__nand2_2_1/B VSS VDD sky130_fd_sc_hs__nand2_2
Xsky130_fd_sc_hs__dfrtp_1_107 sky130_fd_sc_hs__clkbuf_4_2/X VDD VSS sky130_fd_sc_hs__mux2_1_102/A1
+ sky130_fd_sc_hs__clkbuf_2_37/X sky130_fd_sc_hs__mux2_1_102/X VSS VDD sky130_fd_sc_hs__dfrtp_1
Xsky130_fd_sc_hs__dfrtp_1_118 sky130_fd_sc_hs__clkbuf_4_2/X VDD VSS sky130_fd_sc_hs__mux2_1_110/A1
+ sky130_fd_sc_hs__clkinv_1_29/A sky130_fd_sc_hs__mux2_1_110/X VSS VDD sky130_fd_sc_hs__dfrtp_1
Xsky130_fd_sc_hs__dfrtp_1_129 sky130_fd_sc_hs__clkbuf_4_2/X VDD VSS sky130_fd_sc_hs__xor2_1_5/A
+ sky130_fd_sc_hs__clkinv_1_29/A sky130_fd_sc_hs__mux2_1_107/X VSS VDD sky130_fd_sc_hs__dfrtp_1
Xsky130_fd_sc_hs__buf_8_9 VDD VSS sky130_fd_sc_hs__buf_8_9/X sky130_fd_sc_hs__buf_8_9/A
+ VSS VDD sky130_fd_sc_hs__buf_8
Xsky130_fd_sc_hs__clkinv_1_102 VDD VSS sky130_fd_sc_hs__clkinv_1_102/A sky130_fd_sc_hs__clkinv_1_102/Y
+ VSS VDD sky130_fd_sc_hs__clkinv_1
Xsky130_fd_sc_hs__clkinv_1_113 VDD VSS sky130_fd_sc_hs__clkinv_1_113/A sky130_fd_sc_hs__clkinv_1_113/Y
+ VSS VDD sky130_fd_sc_hs__clkinv_1
Xsky130_fd_sc_hs__clkinv_1_124 VDD VSS sky130_fd_sc_hs__or3_1_6/A sky130_fd_sc_hs__mux2_1_289/S
+ VSS VDD sky130_fd_sc_hs__clkinv_1
Xsky130_fd_sc_hs__clkinv_1_135 VDD VSS sky130_fd_sc_hs__clkinv_1_135/A sky130_fd_sc_hs__clkinv_1_135/Y
+ VSS VDD sky130_fd_sc_hs__clkinv_1
Xsky130_fd_sc_hs__clkinv_1_146 VDD VSS sky130_fd_sc_hs__maj3_1_52/A sky130_fd_sc_hs__and3_1_13/A
+ VSS VDD sky130_fd_sc_hs__clkinv_1
Xsky130_fd_sc_hs__clkinv_1_157 VDD VSS sky130_fd_sc_hs__clkinv_1_157/A sky130_fd_sc_hs__clkinv_1_157/Y
+ VSS VDD sky130_fd_sc_hs__clkinv_1
Xsky130_fd_sc_hs__dfrtp_1_630 sky130_fd_sc_hs__buf_8_30/A VDD VSS sky130_fd_sc_hs__mux2_1_339/A0
+ sky130_fd_sc_hs__clkinv_1_143/A sky130_fd_sc_hs__mux2_1_339/X VSS VDD sky130_fd_sc_hs__dfrtp_1
Xsky130_fd_sc_hs__dfrtp_1_641 sky130_fd_sc_hs__buf_8_30/X VDD VSS sky130_fd_sc_hs__mux2_1_349/A1
+ sky130_fd_sc_hs__clkinv_1_141/A sky130_fd_sc_hs__mux2_1_349/X VSS VDD sky130_fd_sc_hs__dfrtp_1
Xsky130_fd_sc_hs__dfrtp_1_652 sky130_fd_sc_hs__clkbuf_4_31/X VDD VSS sky130_fd_sc_hs__mux2_1_315/A0
+ sky130_fd_sc_hs__clkinv_1_130/A sky130_fd_sc_hs__mux2_1_315/X VSS VDD sky130_fd_sc_hs__dfrtp_1
Xsky130_fd_sc_hs__dfrtp_1_663 sky130_fd_sc_hs__clkbuf_4_33/X VDD VSS sky130_fd_sc_hs__mux2_1_360/A0
+ sky130_fd_sc_hs__clkbuf_2_201/X sky130_fd_sc_hs__mux2_1_360/X VSS VDD sky130_fd_sc_hs__dfrtp_1
Xsky130_fd_sc_hs__nor2_1_105 VDD VSS sky130_fd_sc_hs__buf_8_21/X sky130_fd_sc_hs__nor2_1_105/Y
+ sky130_fd_sc_hs__xor2_1_68/A VSS VDD sky130_fd_sc_hs__nor2_1
Xsky130_fd_sc_hs__dfrtp_1_674 sky130_fd_sc_hs__clkbuf_4_35/X VDD VSS sky130_fd_sc_hs__mux2_1_377/A0
+ sky130_fd_sc_hs__clkinv_1_157/A sky130_fd_sc_hs__mux2_1_377/X VSS VDD sky130_fd_sc_hs__dfrtp_1
Xsky130_fd_sc_hs__nor2_1_116 VDD VSS sky130_fd_sc_hs__nor2_1_66/B sky130_fd_sc_hs__nor2_1_116/Y
+ sky130_fd_sc_hs__xor2_1_74/B VSS VDD sky130_fd_sc_hs__nor2_1
Xsky130_fd_sc_hs__dfrtp_1_685 sky130_fd_sc_hs__clkbuf_4_33/X VDD VSS sky130_fd_sc_hs__mux2_1_392/A0
+ sky130_fd_sc_hs__clkbuf_2_214/X sky130_fd_sc_hs__mux2_1_392/X VSS VDD sky130_fd_sc_hs__dfrtp_1
Xsky130_fd_sc_hs__nor2_1_127 VDD VSS sky130_fd_sc_hs__or2_1_21/B sky130_fd_sc_hs__nor2_1_127/Y
+ sky130_fd_sc_hs__or2_1_21/A VSS VDD sky130_fd_sc_hs__nor2_1
Xsky130_fd_sc_hs__dfrtp_1_4 sky130_fd_sc_hs__clkbuf_4_4/X VDD VSS sky130_fd_sc_hs__dfrtp_1_4/Q
+ sky130_fd_sc_hs__clkbuf_2_5/X sky130_fd_sc_hs__mux2_1_18/X VSS VDD sky130_fd_sc_hs__dfrtp_1
Xsky130_fd_sc_hs__dfrtp_1_696 sky130_fd_sc_hs__clkbuf_4_35/X VDD VSS sky130_fd_sc_hs__xor2_1_90/B
+ sky130_fd_sc_hs__clkinv_1_156/A sky130_fd_sc_hs__mux2_1_371/X VSS VDD sky130_fd_sc_hs__dfrtp_1
Xsky130_fd_sc_hs__nor2_1_138 VDD VSS sky130_fd_sc_hs__buf_8_21/X sky130_fd_sc_hs__nor2_1_138/Y
+ sky130_fd_sc_hs__xor2_1_77/A VSS VDD sky130_fd_sc_hs__nor2_1
Xsky130_fd_sc_hs__a22oi_1_14 VDD VSS sky130_fd_sc_hs__mux2_1_32/A1 sky130_fd_sc_hs__nand2_1_1/B
+ sky130_fd_sc_hs__buf_16_9/X sky130_fd_sc_hs__a22oi_1_7/B1 sky130_fd_sc_hs__mux2_1_31/A0
+ VSS VDD sky130_fd_sc_hs__a22oi_1
Xsky130_fd_sc_hs__nor2_1_149 VDD VSS sky130_fd_sc_hs__nor3b_1_3/B sky130_fd_sc_hs__nor2_1_149/Y
+ sky130_fd_sc_hs__nor2_1_149/A VSS VDD sky130_fd_sc_hs__nor2_1
Xsky130_fd_sc_hs__a22oi_1_25 VDD VSS sky130_fd_sc_hs__mux2_1_46/A1 sky130_fd_sc_hs__nand2_1_16/A
+ sky130_fd_sc_hs__buf_16_8/X sky130_fd_sc_hs__a222o_1_2/A2 sky130_fd_sc_hs__mux2_1_83/A0
+ VSS VDD sky130_fd_sc_hs__a22oi_1
Xsky130_fd_sc_hs__a22oi_1_36 VDD VSS sky130_fd_sc_hs__mux2_1_112/A0 sky130_fd_sc_hs__nand2_1_34/B
+ sky130_fd_sc_hs__a22oi_1_7/B1 sky130_fd_sc_hs__buf_16_8/X sky130_fd_sc_hs__mux2_1_113/A1
+ VSS VDD sky130_fd_sc_hs__a22oi_1
Xsky130_fd_sc_hs__a22oi_1_47 VDD VSS sky130_fd_sc_hs__mux2_1_146/A0 sky130_fd_sc_hs__and4_1_4/D
+ sky130_fd_sc_hs__nand2_1_51/B sky130_fd_sc_hs__buf_16_7/X sky130_fd_sc_hs__mux2_1_158/A0
+ VSS VDD sky130_fd_sc_hs__a22oi_1
Xsky130_fd_sc_hs__a22oi_1_58 VDD VSS sky130_fd_sc_hs__nor2b_1_41/Y sky130_fd_sc_hs__a22oi_1_58/Y
+ sky130_fd_sc_hs__nor2_1_119/Y sky130_fd_sc_hs__nor2_1_101/Y sky130_fd_sc_hs__nor2_1_157/Y
+ VSS VDD sky130_fd_sc_hs__a22oi_1
Xsky130_fd_sc_hs__a22oi_1_69 VDD VSS sky130_fd_sc_hs__mux2_1_258/A1 sky130_fd_sc_hs__and3_1_11/B
+ sky130_fd_sc_hs__a22o_1_9/A2 sky130_fd_sc_hs__buf_8_33/X sky130_fd_sc_hs__mux2_1_269/A0
+ VSS VDD sky130_fd_sc_hs__a22oi_1
Xsky130_fd_sc_hs__nor2_1_60 VDD VSS sky130_fd_sc_hs__nor2_1_66/B sky130_fd_sc_hs__nor2_1_60/Y
+ sky130_fd_sc_hs__xor2_1_29/B VSS VDD sky130_fd_sc_hs__nor2_1
Xsky130_fd_sc_hs__nor2_1_71 VDD VSS sky130_fd_sc_hs__nor2_1_72/Y sky130_fd_sc_hs__nor2_1_71/Y
+ sky130_fd_sc_hs__nor2_1_71/A VSS VDD sky130_fd_sc_hs__nor2_1
Xsky130_fd_sc_hs__nor2_1_82 VDD VSS sky130_fd_sc_hs__nor2_1_82/B sky130_fd_sc_hs__nor2_1_82/Y
+ sky130_fd_sc_hs__xor2_1_76/A VSS VDD sky130_fd_sc_hs__nor2_1
Xsky130_fd_sc_hs__nor2_1_93 VDD VSS sky130_fd_sc_hs__nor2_1_93/B sky130_fd_sc_hs__nor2_1_93/Y
+ sky130_fd_sc_hs__or3_1_1/A VSS VDD sky130_fd_sc_hs__nor2_1
Xsky130_fd_sc_hs__xnor2_1_2 VDD VSS sky130_fd_sc_hs__xnor2_1_2/A sky130_fd_sc_hs__xor2_1_10/B
+ sky130_fd_sc_hs__xnor2_1_2/B VSS VDD sky130_fd_sc_hs__xnor2_1
Xsky130_fd_sc_hs__a31o_1_7 VDD VSS sky130_fd_sc_hs__a31o_1_7/X sky130_fd_sc_hs__a21o_1_3/X
+ sky130_fd_sc_hs__a31o_1_7/A2 sky130_fd_sc_hs__a31o_1_7/A1 sky130_fd_sc_hs__buf_8_12/X
+ VSS VDD sky130_fd_sc_hs__a31o_1
Xsky130_fd_sc_hs__or2_1_1 VDD VSS sky130_fd_sc_hs__or2_1_1/B sky130_fd_sc_hs__or2_1_1/A
+ sky130_fd_sc_hs__or2_1_1/X VSS VDD sky130_fd_sc_hs__or2_1
Xsky130_fd_sc_hs__dfrtp_1_460 sky130_fd_sc_hs__clkbuf_4_22/A VDD VSS sky130_fd_sc_hs__and4_1_5/D
+ sky130_fd_sc_hs__clkinv_1_95/A sky130_fd_sc_hs__o31ai_1_12/Y VSS VDD sky130_fd_sc_hs__dfrtp_1
Xsky130_fd_sc_hs__dfrtp_1_471 sky130_fd_sc_hs__clkbuf_4_22/A VDD VSS sky130_fd_sc_hs__xor2_1_78/B
+ sky130_fd_sc_hs__clkbuf_2_144/X sky130_fd_sc_hs__dfrtp_1_471/D VSS VDD sky130_fd_sc_hs__dfrtp_1
Xsky130_fd_sc_hs__dfrtp_1_482 sky130_fd_sc_hs__clkbuf_4_23/X VDD VSS sky130_fd_sc_hs__nor3_1_36/B
+ sky130_fd_sc_hs__clkinv_1_102/A sky130_fd_sc_hs__dfrtp_1_482/D VSS VDD sky130_fd_sc_hs__dfrtp_1
Xsky130_fd_sc_hs__dfrtp_1_493 sky130_fd_sc_hs__clkbuf_4_23/X VDD VSS sky130_fd_sc_hs__nor2_1_147/A
+ sky130_fd_sc_hs__clkbuf_2_154/X sky130_fd_sc_hs__dfrtp_1_493/D VSS VDD sky130_fd_sc_hs__dfrtp_1
Xsky130_fd_sc_hs__clkbuf_4_1 VDD VSS sky130_fd_sc_hs__buf_8_38/X sky130_fd_sc_hs__clkbuf_4_1/X
+ VSS VDD sky130_fd_sc_hs__clkbuf_4
Xsky130_fd_sc_hs__o21a_1_17 VDD VSS sky130_fd_sc_hs__o21a_1_17/X sky130_fd_sc_hs__nor2_1_78/Y
+ sky130_fd_sc_hs__o21ai_1_7/B1 sky130_fd_sc_hs__xor2_1_53/X VSS VDD sky130_fd_sc_hs__o21a_1
Xsky130_fd_sc_hs__o21a_1_28 VDD VSS sky130_fd_sc_hs__o21a_1_28/X sky130_fd_sc_hs__nor3_1_25/C
+ sky130_fd_sc_hs__nor3_1_25/B sky130_fd_sc_hs__nor3_1_25/A VSS VDD sky130_fd_sc_hs__o21a_1
Xsky130_fd_sc_hs__and2_1_18 VDD VSS sky130_fd_sc_hs__nor2_1_68/A sky130_fd_sc_hs__or2_1_12/B
+ sky130_fd_sc_hs__or2_1_13/B VSS VDD sky130_fd_sc_hs__and2_1
Xsky130_fd_sc_hs__and2_1_29 VDD VSS sky130_fd_sc_hs__nor2_4_1/A sky130_fd_sc_hs__and2_1_29/B
+ sky130_fd_sc_hs__and2_1_29/X VSS VDD sky130_fd_sc_hs__and2_1
Xsky130_fd_sc_hs__clkinv_4_1 VDD VSS sky130_fd_sc_hs__clkinv_4_1/Y sky130_fd_sc_hs__clkinv_4_1/A
+ VSS VDD sky130_fd_sc_hs__clkinv_4
Xsky130_fd_sc_hs__nor4b_1_1 VDD VSS sky130_fd_sc_hs__nor4b_1_1/Y sky130_fd_sc_hs__or3_1_1/C
+ sky130_fd_sc_hs__nor4b_1_1/A sky130_fd_sc_hs__nor4b_1_1/B sky130_fd_sc_hs__o22ai_1_1/Y
+ VSS VDD sky130_fd_sc_hs__nor4b_1
Xsky130_fd_sc_hs__mux2_1_420 VDD VSS sky130_fd_sc_hs__mux2_1_420/X sky130_fd_sc_hs__nor3_4_2/Y
+ sky130_fd_sc_hs__xor2_1_91/A sky130_fd_sc_hs__a22o_1_84/B2 VSS VDD sky130_fd_sc_hs__mux2_1
Xsky130_fd_sc_hs__mux2_1_431 VDD VSS sky130_fd_sc_hs__mux2_1_431/X sky130_fd_sc_hs__buf_16_4/A
+ sky130_fd_sc_hs__mux2_1_431/A0 sky130_fd_sc_hs__a22o_1_94/B2 VSS VDD sky130_fd_sc_hs__mux2_1
Xsky130_fd_sc_hs__mux2_1_442 VDD VSS sky130_fd_sc_hs__mux2_1_442/X sky130_fd_sc_hs__buf_16_3/X
+ sky130_fd_sc_hs__a22o_1_91/B2 sky130_fd_sc_hs__mux2_1_442/A1 VSS VDD sky130_fd_sc_hs__mux2_1
Xsky130_fd_sc_hs__mux2_1_453 VDD VSS sky130_fd_sc_hs__mux2_1_453/X sky130_fd_sc_hs__buf_16_15/A
+ sky130_fd_sc_hs__a22o_1_92/B2 sky130_fd_sc_hs__mux2_1_453/A1 VSS VDD sky130_fd_sc_hs__mux2_1
Xsky130_fd_sc_hs__mux2_1_464 VDD VSS sky130_fd_sc_hs__mux2_1_464/X sky130_fd_sc_hs__mux2_1_464/S
+ sky130_fd_sc_hs__a22o_1_62/B2 sky130_fd_sc_hs__mux2_1_464/A1 VSS VDD sky130_fd_sc_hs__mux2_1
Xsky130_fd_sc_hs__mux2_1_475 VDD VSS sky130_fd_sc_hs__mux2_1_475/X sky130_fd_sc_hs__buf_16_2/X
+ sky130_fd_sc_hs__a22o_1_67/B2 sky130_fd_sc_hs__mux2_1_475/A1 VSS VDD sky130_fd_sc_hs__mux2_1
Xsky130_fd_sc_hs__mux2_1_486 VDD VSS sky130_fd_sc_hs__mux2_1_486/X sky130_fd_sc_hs__mux2_1_9/S
+ sky130_fd_sc_hs__mux2_1_486/A0 sky130_fd_sc_hs__a22o_1_75/B2 VSS VDD sky130_fd_sc_hs__mux2_1
Xsky130_fd_sc_hs__buf_4_3 VDD VSS sky130_fd_sc_hs__buf_4_3/A sky130_fd_sc_hs__buf_4_3/X
+ VSS VDD sky130_fd_sc_hs__buf_4
Xsky130_fd_sc_hs__dfrtp_1_290 sky130_fd_sc_hs__buf_2_0/A VDD VSS sky130_fd_sc_hs__xnor2_1_49/A
+ sky130_fd_sc_hs__clkbuf_2_73/X sky130_fd_sc_hs__dfrtp_1_290/D VSS VDD sky130_fd_sc_hs__dfrtp_1
Xsky130_fd_sc_hs__buf_1_17 VDD VSS sky130_fd_sc_hs__buf_1_17/A srm_ones_count[4] VSS
+ VDD sky130_fd_sc_hs__buf_1
Xsky130_fd_sc_hs__buf_1_28 VDD VSS sky130_fd_sc_hs__buf_1_28/A w_wr_data[20] VSS VDD
+ sky130_fd_sc_hs__buf_1
Xsky130_fd_sc_hs__buf_1_39 VDD VSS sky130_fd_sc_hs__buf_1_39/A w_wr_data[25] VSS VDD
+ sky130_fd_sc_hs__buf_1
Xsky130_fd_sc_hs__a22o_1_20 VDD VSS sky130_fd_sc_hs__a22o_1_20/X sky130_fd_sc_hs__a22o_1_20/B2
+ sky130_fd_sc_hs__a22o_1_6/B1 sky130_fd_sc_hs__nor2_2_0/Y sky130_fd_sc_hs__buf_1_9/A
+ VSS VDD sky130_fd_sc_hs__a22o_1
Xsky130_fd_sc_hs__a22o_1_31 VDD VSS sky130_fd_sc_hs__a22o_1_31/X sky130_fd_sc_hs__a22o_1_32/A1
+ sky130_fd_sc_hs__a22o_1_93/B1 sky130_fd_sc_hs__a22o_1_93/A2 sky130_fd_sc_hs__maj3_1_13/C
+ VSS VDD sky130_fd_sc_hs__a22o_1
Xsky130_fd_sc_hs__a22o_1_42 VDD VSS sky130_fd_sc_hs__a22o_1_42/X sky130_fd_sc_hs__a22o_1_42/B2
+ sky130_fd_sc_hs__a22o_1_93/B1 sky130_fd_sc_hs__a22o_1_93/A2 sky130_fd_sc_hs__maj3_1_19/C
+ VSS VDD sky130_fd_sc_hs__a22o_1
Xsky130_fd_sc_hs__a22o_1_53 VDD VSS sky130_fd_sc_hs__a22o_1_53/X sky130_fd_sc_hs__a22o_1_67/A1
+ sky130_fd_sc_hs__a22o_1_93/B1 sky130_fd_sc_hs__a22o_1_93/A2 sky130_fd_sc_hs__maj3_1_15/C
+ VSS VDD sky130_fd_sc_hs__a22o_1
Xsky130_fd_sc_hs__clkbuf_2_20 VDD VSS sky130_fd_sc_hs__clkinv_1_7/A sky130_fd_sc_hs__clkbuf_2_92/A
+ VSS VDD sky130_fd_sc_hs__clkbuf_2
Xsky130_fd_sc_hs__a22o_1_64 VDD VSS sky130_fd_sc_hs__a22o_1_64/X sky130_fd_sc_hs__a22o_1_64/B2
+ sky130_fd_sc_hs__buf_8_17/X sky130_fd_sc_hs__buf_8_15/X sky130_fd_sc_hs__a22o_1_64/A1
+ VSS VDD sky130_fd_sc_hs__a22o_1
Xsky130_fd_sc_hs__a22o_1_75 VDD VSS sky130_fd_sc_hs__a22o_1_75/X sky130_fd_sc_hs__a22o_1_75/B2
+ sky130_fd_sc_hs__a22o_1_75/B1 sky130_fd_sc_hs__nor2_1_92/Y sky130_fd_sc_hs__a22o_1_76/B2
+ VSS VDD sky130_fd_sc_hs__a22o_1
Xsky130_fd_sc_hs__clkbuf_2_31 VDD VSS sky130_fd_sc_hs__clkbuf_2_31/X sky130_fd_sc_hs__clkbuf_2_3/A
+ VSS VDD sky130_fd_sc_hs__clkbuf_2
Xsky130_fd_sc_hs__clkbuf_2_42 VDD VSS sky130_fd_sc_hs__clkinv_1_29/A sky130_fd_sc_hs__inv_8_0/A
+ VSS VDD sky130_fd_sc_hs__clkbuf_2
Xsky130_fd_sc_hs__a22o_1_86 VDD VSS sky130_fd_sc_hs__a22o_1_86/X sky130_fd_sc_hs__o21a_1_18/X
+ sky130_fd_sc_hs__a22o_1_86/B1 sky130_fd_sc_hs__buf_8_13/A sky130_fd_sc_hs__maj3_1_32/C
+ VSS VDD sky130_fd_sc_hs__a22o_1
Xsky130_fd_sc_hs__a22o_1_97 VDD VSS sky130_fd_sc_hs__dfrtp_2_3/D sky130_fd_sc_hs__dfrtp_2_3/Q
+ sky130_fd_sc_hs__buf_8_17/X sky130_fd_sc_hs__buf_8_15/X sky130_fd_sc_hs__a22o_1_97/A1
+ VSS VDD sky130_fd_sc_hs__a22o_1
Xsky130_fd_sc_hs__clkbuf_2_53 VDD VSS sky130_fd_sc_hs__clkinv_1_38/A sky130_fd_sc_hs__inv_8_0/A
+ VSS VDD sky130_fd_sc_hs__clkbuf_2
Xsky130_fd_sc_hs__clkbuf_2_64 VDD VSS sky130_fd_sc_hs__clkinv_1_46/A sky130_fd_sc_hs__clkbuf_2_92/A
+ VSS VDD sky130_fd_sc_hs__clkbuf_2
Xsky130_fd_sc_hs__a21o_1_6 VDD VSS sky130_fd_sc_hs__a21o_1_6/X sky130_fd_sc_hs__buf_1_154/A
+ sky130_fd_sc_hs__a21o_1_6/B1 sky130_fd_sc_hs__nand4_1_5/Y VSS VDD sky130_fd_sc_hs__a21o_1
Xsky130_fd_sc_hs__clkbuf_2_75 VDD VSS sky130_fd_sc_hs__clkinv_2_3/A sky130_fd_sc_hs__clkinv_4_2/A
+ VSS VDD sky130_fd_sc_hs__clkbuf_2
Xsky130_fd_sc_hs__clkbuf_2_86 VDD VSS sky130_fd_sc_hs__clkinv_1_56/A sky130_fd_sc_hs__clkinv_4_3/A
+ VSS VDD sky130_fd_sc_hs__clkbuf_2
Xsky130_fd_sc_hs__nand4_1_3 VDD VSS sky130_fd_sc_hs__nor3_1_22/Y sky130_fd_sc_hs__nand4_1_3/Y
+ sky130_fd_sc_hs__nand4_1_3/D sky130_fd_sc_hs__nand4_1_3/B sky130_fd_sc_hs__buf_4_2/X
+ VSS VDD sky130_fd_sc_hs__nand4_1
Xsky130_fd_sc_hs__clkbuf_2_97 VDD VSS sky130_fd_sc_hs__clkinv_1_64/A sky130_fd_sc_hs__clkinv_4_3/A
+ VSS VDD sky130_fd_sc_hs__clkbuf_2
Xsky130_fd_sc_hs__maj3_1_15 VDD VSS sky130_fd_sc_hs__xor2_1_26/A sky130_fd_sc_hs__xor2_1_26/B
+ sky130_fd_sc_hs__xor2_1_28/A sky130_fd_sc_hs__maj3_1_15/C VSS VDD sky130_fd_sc_hs__maj3_1
Xsky130_fd_sc_hs__maj3_1_26 VDD VSS sky130_fd_sc_hs__xor2_1_3/A sky130_fd_sc_hs__xor2_1_50/A
+ sky130_fd_sc_hs__maj3_1_26/X sky130_fd_sc_hs__xor2_1_50/B VSS VDD sky130_fd_sc_hs__maj3_1
Xsky130_fd_sc_hs__maj3_1_37 VDD VSS sky130_fd_sc_hs__xor2_1_76/A sky130_fd_sc_hs__xor2_1_76/B
+ sky130_fd_sc_hs__maj3_1_37/X sky130_fd_sc_hs__maj3_1_37/C VSS VDD sky130_fd_sc_hs__maj3_1
Xsky130_fd_sc_hs__maj3_1_48 VDD VSS sky130_fd_sc_hs__xor2_1_74/A sky130_fd_sc_hs__xor2_1_74/B
+ sky130_fd_sc_hs__maj3_1_48/X sky130_fd_sc_hs__maj3_1_48/C VSS VDD sky130_fd_sc_hs__maj3_1
Xsky130_fd_sc_hs__maj3_1_59 VDD VSS sky130_fd_sc_hs__xor2_1_85/A sky130_fd_sc_hs__xor2_1_90/A
+ sky130_fd_sc_hs__maj3_1_59/X sky130_fd_sc_hs__maj3_1_63/X VSS VDD sky130_fd_sc_hs__maj3_1
Xsky130_fd_sc_hs__nand2_1_20 VDD VSS sky130_fd_sc_hs__xnor2_1_10/Y sky130_fd_sc_hs__nand2_1_20/Y
+ sky130_fd_sc_hs__o21ai_1_7/B1 VSS VDD sky130_fd_sc_hs__nand2_1
Xsky130_fd_sc_hs__nand2_1_31 VDD VSS sky130_fd_sc_hs__xor2_1_3/B sky130_fd_sc_hs__nand2_1_32/A
+ sky130_fd_sc_hs__xor2_1_3/A VSS VDD sky130_fd_sc_hs__nand2_1
Xsky130_fd_sc_hs__mux2_1_250 VDD VSS sky130_fd_sc_hs__mux2_1_250/X sky130_fd_sc_hs__buf_8_11/X
+ sky130_fd_sc_hs__xor2_1_71/B sky130_fd_sc_hs__mux2_1_250/A1 VSS VDD sky130_fd_sc_hs__mux2_1
Xsky130_fd_sc_hs__nand2_1_42 VDD VSS sky130_fd_sc_hs__xnor2_1_21/B sky130_fd_sc_hs__nand2_1_45/A
+ sky130_fd_sc_hs__maj3_1_5/A VSS VDD sky130_fd_sc_hs__nand2_1
Xsky130_fd_sc_hs__mux2_1_261 VDD VSS sky130_fd_sc_hs__mux2_1_261/X sky130_fd_sc_hs__buf_4_1/X
+ sky130_fd_sc_hs__a22o_1_62/B2 sky130_fd_sc_hs__mux2_1_261/A1 VSS VDD sky130_fd_sc_hs__mux2_1
Xsky130_fd_sc_hs__nand2_1_53 VDD VSS sky130_fd_sc_hs__a32o_1_2/B1 sky130_fd_sc_hs__o31ai_1_4/B1
+ sky130_fd_sc_hs__xor2_1_18/A VSS VDD sky130_fd_sc_hs__nand2_1
Xsky130_fd_sc_hs__mux2_1_272 VDD VSS sky130_fd_sc_hs__mux2_1_272/X sky130_fd_sc_hs__buf_4_1/A
+ sky130_fd_sc_hs__a22o_1_95/B2 sky130_fd_sc_hs__mux2_1_272/A1 VSS VDD sky130_fd_sc_hs__mux2_1
Xsky130_fd_sc_hs__nand2_1_64 VDD VSS sky130_fd_sc_hs__and2_1_15/X sky130_fd_sc_hs__o31ai_1_6/A1
+ sky130_fd_sc_hs__buf_1_66/X VSS VDD sky130_fd_sc_hs__nand2_1
Xsky130_fd_sc_hs__mux2_1_283 VDD VSS sky130_fd_sc_hs__mux2_1_283/X sky130_fd_sc_hs__nor2_2_7/Y
+ sky130_fd_sc_hs__mux2_1_283/A0 sky130_fd_sc_hs__mux2_1_473/A1 VSS VDD sky130_fd_sc_hs__mux2_1
Xsky130_fd_sc_hs__nand2_1_75 VDD VSS sky130_fd_sc_hs__or2_1_11/X sky130_fd_sc_hs__xnor2_1_73/A
+ sky130_fd_sc_hs__nand2_1_75/A VSS VDD sky130_fd_sc_hs__nand2_1
Xsky130_fd_sc_hs__mux2_1_294 VDD VSS sky130_fd_sc_hs__mux2_1_294/X sky130_fd_sc_hs__buf_16_3/A
+ sky130_fd_sc_hs__mux2_1_473/A1 sky130_fd_sc_hs__mux2_1_294/A1 VSS VDD sky130_fd_sc_hs__mux2_1
Xsky130_fd_sc_hs__nand2_1_86 VDD VSS sky130_fd_sc_hs__xor2_1_44/X sky130_fd_sc_hs__a21o_1_4/A1
+ sky130_fd_sc_hs__or2_1_13/X VSS VDD sky130_fd_sc_hs__nand2_1
Xsky130_fd_sc_hs__nand2_1_97 VDD VSS sky130_fd_sc_hs__nor2_1_78/Y sky130_fd_sc_hs__nand2_1_99/B
+ sky130_fd_sc_hs__xor2_1_53/X VSS VDD sky130_fd_sc_hs__nand2_1
Xsky130_fd_sc_hs__a222oi_1_16 VDD VSS sky130_fd_sc_hs__mux2_1_483/A0 sky130_fd_sc_hs__nand2_1_51/B
+ sky130_fd_sc_hs__a22oi_1_6/B1 sky130_fd_sc_hs__a22oi_1_6/A2 sky130_fd_sc_hs__mux2_1_313/A1
+ sky130_fd_sc_hs__nand2_1_195/A sky130_fd_sc_hs__xor2_1_56/B VSS VDD sky130_fd_sc_hs__a222oi_1
Xsky130_fd_sc_hs__a222oi_1_27 VDD VSS sky130_fd_sc_hs__mux2_1_403/A1 sky130_fd_sc_hs__clkbuf_8_14/X
+ sky130_fd_sc_hs__nand2_1_198/B sky130_fd_sc_hs__buf_4_7/A sky130_fd_sc_hs__mux2_1_286/A0
+ sky130_fd_sc_hs__nand2_1_230/A sky130_fd_sc_hs__mux2_1_287/A1 VSS VDD sky130_fd_sc_hs__a222oi_1
Xsky130_fd_sc_hs__o31ai_1_19 VDD VSS sky130_fd_sc_hs__and3_1_14/X sky130_fd_sc_hs__o31ai_1_19/A2
+ sky130_fd_sc_hs__o31ai_1_19/B1 sky130_fd_sc_hs__o31ai_1_4/A1 sky130_fd_sc_hs__o31ai_1_19/Y
+ VSS VDD sky130_fd_sc_hs__o31ai_1
Xsky130_fd_sc_hs__buf_2_0 VDD VSS sky130_fd_sc_hs__buf_2_0/A sky130_fd_sc_hs__buf_8_4/A
+ VSS VDD sky130_fd_sc_hs__buf_2
Xsky130_fd_sc_hs__dfrtp_1_19 sky130_fd_sc_hs__clkbuf_4_3/X VDD VSS sky130_fd_sc_hs__mux2_1_22/A1
+ sky130_fd_sc_hs__clkinv_1_3/A sky130_fd_sc_hs__mux2_1_22/X VSS VDD sky130_fd_sc_hs__dfrtp_1
Xsky130_fd_sc_hs__a22oi_1_107 VDD VSS sky130_fd_sc_hs__mux2_1_437/A1 sky130_fd_sc_hs__nand2_1_225/B
+ sky130_fd_sc_hs__buf_16_9/X sky130_fd_sc_hs__a22oi_1_6/A2 sky130_fd_sc_hs__mux2_1_439/A1
+ VSS VDD sky130_fd_sc_hs__a22oi_1
Xsky130_fd_sc_hs__a22oi_1_118 VDD VSS sky130_fd_sc_hs__mux2_1_342/A1 sky130_fd_sc_hs__nand3_1_38/B
+ sky130_fd_sc_hs__buf_16_8/X sky130_fd_sc_hs__a22oi_1_6/A2 sky130_fd_sc_hs__mux2_1_347/A1
+ VSS VDD sky130_fd_sc_hs__a22oi_1
Xsky130_fd_sc_hs__a311o_1_6 VDD VSS sky130_fd_sc_hs__a32o_1_7/A3 sky130_fd_sc_hs__xnor2_1_68/Y
+ sky130_fd_sc_hs__a31o_1_8/B1 sky130_fd_sc_hs__a31o_1_8/A3 sky130_fd_sc_hs__a31o_1_9/A2
+ sky130_fd_sc_hs__a31o_1_9/A1 VSS VDD sky130_fd_sc_hs__a311o_1
Xsky130_fd_sc_hs__a22o_1_109 VDD VSS sky130_fd_sc_hs__buf_1_105/A sky130_fd_sc_hs__nor2b_1_33/A
+ sky130_fd_sc_hs__nand2_1_125/Y sky130_fd_sc_hs__nor2_2_2/Y sky130_fd_sc_hs__o21ai_1_63/B1
+ VSS VDD sky130_fd_sc_hs__a22o_1
Xsky130_fd_sc_hs__dlygate4sd3_1_10 VSS VDD raw_bits_i[2] sky130_fd_sc_hs__buf_1_70/A
+ VSS VDD sky130_fd_sc_hs__dlygate4sd3_1
Xsky130_fd_sc_hs__dlygate4sd3_1_21 VSS VDD calib_comp_out sky130_fd_sc_hs__dlygate4sd3_1_21/X
+ VSS VDD sky130_fd_sc_hs__dlygate4sd3_1
Xsky130_fd_sc_hs__o21ai_1_10 VDD VSS sky130_fd_sc_hs__a32o_1_2/A2 sky130_fd_sc_hs__or3_1_0/B
+ sky130_fd_sc_hs__or3_1_0/C sky130_fd_sc_hs__or3_1_0/A VSS VDD sky130_fd_sc_hs__o21ai_1
Xsky130_fd_sc_hs__o21ai_1_21 VDD VSS sky130_fd_sc_hs__o21ai_1_21/Y sky130_fd_sc_hs__nor2_4_3/Y
+ sky130_fd_sc_hs__a21oi_1_14/Y sky130_fd_sc_hs__xor2_1_20/X VSS VDD sky130_fd_sc_hs__o21ai_1
Xsky130_fd_sc_hs__o21ai_1_32 VDD VSS sky130_fd_sc_hs__o21ai_1_32/Y sky130_fd_sc_hs__nor2_2_1/A
+ sky130_fd_sc_hs__nor2_1_41/A sky130_fd_sc_hs__buf_1_63/X VSS VDD sky130_fd_sc_hs__o21ai_1
Xsky130_fd_sc_hs__o21ai_1_43 VDD VSS sky130_fd_sc_hs__o21ai_1_43/Y sky130_fd_sc_hs__buf_8_2/X
+ sky130_fd_sc_hs__buf_8_10/X sky130_fd_sc_hs__and2_1_7/A VSS VDD sky130_fd_sc_hs__o21ai_1
Xsky130_fd_sc_hs__o21ai_1_54 VDD VSS sky130_fd_sc_hs__o21ai_1_54/Y sky130_fd_sc_hs__o21ai_1_54/B1
+ sky130_fd_sc_hs__xnor2_1_103/Y sky130_fd_sc_hs__buf_8_12/A VSS VDD sky130_fd_sc_hs__o21ai_1
Xsky130_fd_sc_hs__o21ai_1_65 VDD VSS sky130_fd_sc_hs__o21ai_1_65/Y sky130_fd_sc_hs__o21ai_1_65/B1
+ sky130_fd_sc_hs__xnor2_1_109/Y sky130_fd_sc_hs__o21bai_1_4/Y VSS VDD sky130_fd_sc_hs__o21ai_1
Xsky130_fd_sc_hs__o21ai_1_76 VDD VSS sky130_fd_sc_hs__o21ai_1_76/Y sky130_fd_sc_hs__o21ai_1_72/Y
+ sky130_fd_sc_hs__o21ai_1_79/A1 sky130_fd_sc_hs__or2_1_25/A VSS VDD sky130_fd_sc_hs__o21ai_1
Xsky130_fd_sc_hs__o21ai_1_87 VDD VSS sky130_fd_sc_hs__o21ai_1_87/Y sky130_fd_sc_hs__or3_1_7/B
+ sky130_fd_sc_hs__or3_1_7/C sky130_fd_sc_hs__or3_1_7/A VSS VDD sky130_fd_sc_hs__o21ai_1
Xsky130_fd_sc_hs__o21ai_1_98 VDD VSS sky130_fd_sc_hs__o21ai_1_98/Y sky130_fd_sc_hs__o21a_1_4/B1
+ sky130_fd_sc_hs__o21ai_1_98/A2 sky130_fd_sc_hs__o21ai_1_98/A1 VSS VDD sky130_fd_sc_hs__o21ai_1
Xsky130_fd_sc_hs__o211ai_1_10 VDD VSS sky130_fd_sc_hs__nand4_1_4/C sky130_fd_sc_hs__or3_1_3/A
+ sky130_fd_sc_hs__or3_1_1/C sky130_fd_sc_hs__nand4_1_5/C sky130_fd_sc_hs__nor3_1_24/C
+ VSS VDD sky130_fd_sc_hs__o211ai_1
Xsky130_fd_sc_hs__buf_16_6 sky130_fd_sc_hs__mux2_1_5/S VDD VSS sky130_fd_sc_hs__buf_16_6/A
+ VSS VDD sky130_fd_sc_hs__buf_16
Xsky130_fd_sc_hs__nor2_4_0 VDD VSS sky130_fd_sc_hs__nor2_4_0/Y sky130_fd_sc_hs__nor2_4_0/A
+ sky130_fd_sc_hs__nor2_4_0/B VSS VDD sky130_fd_sc_hs__nor2_4
Xsky130_fd_sc_hs__dfrtp_1_801 sky130_fd_sc_hs__buf_8_8/X VDD VSS sky130_fd_sc_hs__xor2_1_50/B
+ sky130_fd_sc_hs__clkinv_1_53/A sky130_fd_sc_hs__mux2_1_226/X VSS VDD sky130_fd_sc_hs__dfrtp_1
Xsky130_fd_sc_hs__dfrtp_1_812 sky130_fd_sc_hs__clkbuf_4_15/X VDD VSS sky130_fd_sc_hs__mux2_1_488/A0
+ sky130_fd_sc_hs__clkinv_2_7/A sky130_fd_sc_hs__mux2_1_488/X VSS VDD sky130_fd_sc_hs__dfrtp_1
Xsky130_fd_sc_hs__dfrtp_1_823 sky130_fd_sc_hs__clkbuf_4_19/X VDD VSS sky130_fd_sc_hs__mux2_1_231/A1
+ sky130_fd_sc_hs__clkbuf_2_185/X sky130_fd_sc_hs__mux2_1_231/X VSS VDD sky130_fd_sc_hs__dfrtp_1
Xsky130_fd_sc_hs__dfrtp_1_834 sky130_fd_sc_hs__clkbuf_4_19/X VDD VSS sky130_fd_sc_hs__maj3_1_34/A
+ sky130_fd_sc_hs__clkbuf_2_193/X sky130_fd_sc_hs__a32o_1_12/X VSS VDD sky130_fd_sc_hs__dfrtp_1
Xsky130_fd_sc_hs__a21oi_1_120 VDD VSS sky130_fd_sc_hs__buf_8_12/A sky130_fd_sc_hs__nor2_1_107/B
+ sky130_fd_sc_hs__and4_1_5/B sky130_fd_sc_hs__and4_1_5/A VSS VDD sky130_fd_sc_hs__a21oi_1
Xsky130_fd_sc_hs__clkbuf_8_8 VDD VSS sky130_fd_sc_hs__mux2_1_328/S sky130_fd_sc_hs__nor2_2_6/Y
+ VSS VDD sky130_fd_sc_hs__clkbuf_8
Xsky130_fd_sc_hs__a21oi_1_131 VDD VSS sky130_fd_sc_hs__buf_8_12/A sky130_fd_sc_hs__a22o_1_102/B2
+ sky130_fd_sc_hs__or2_1_20/B sky130_fd_sc_hs__or2_1_20/A VSS VDD sky130_fd_sc_hs__a21oi_1
Xsky130_fd_sc_hs__a21oi_1_142 VDD VSS sky130_fd_sc_hs__nor3_1_41/B sky130_fd_sc_hs__nor4_1_0/D
+ sky130_fd_sc_hs__nand2b_1_48/Y sky130_fd_sc_hs__mux2i_1_4/A1 VSS VDD sky130_fd_sc_hs__a21oi_1
Xsky130_fd_sc_hs__a21oi_1_153 VDD VSS sky130_fd_sc_hs__nor2_1_132/Y sky130_fd_sc_hs__dfrtp_1_482/D
+ sky130_fd_sc_hs__o2bb2ai_1_31/Y sky130_fd_sc_hs__a22oi_1_58/Y VSS VDD sky130_fd_sc_hs__a21oi_1
Xsky130_fd_sc_hs__a21oi_1_164 VDD VSS sky130_fd_sc_hs__nand2_1_156/A sky130_fd_sc_hs__a21oi_1_164/Y
+ sky130_fd_sc_hs__nor3_1_40/Y sky130_fd_sc_hs__nor2_1_149/A VSS VDD sky130_fd_sc_hs__a21oi_1
Xsky130_fd_sc_hs__a21oi_1_175 VDD VSS sky130_fd_sc_hs__a41oi_1_1/Y sky130_fd_sc_hs__dfrtp_1_571/D
+ sky130_fd_sc_hs__o21ai_1_84/Y sky130_fd_sc_hs__buf_4_6/X VSS VDD sky130_fd_sc_hs__a21oi_1
Xsky130_fd_sc_hs__a21oi_1_186 VDD VSS sky130_fd_sc_hs__and3_1_13/A sky130_fd_sc_hs__nor2_1_170/A
+ sky130_fd_sc_hs__nor3_1_49/Y sky130_fd_sc_hs__and3_1_13/B VSS VDD sky130_fd_sc_hs__a21oi_1
Xsky130_fd_sc_hs__a21oi_1_197 VDD VSS sky130_fd_sc_hs__o21ai_1_107/Y sky130_fd_sc_hs__a21oi_1_197/Y
+ sky130_fd_sc_hs__xor2_1_85/X sky130_fd_sc_hs__maj3_1_63/X VSS VDD sky130_fd_sc_hs__a21oi_1
Xsky130_fd_sc_hs__clkbuf_2_180 VDD VSS sky130_fd_sc_hs__clkinv_2_12/A sky130_fd_sc_hs__clkbuf_2_236/A
+ VSS VDD sky130_fd_sc_hs__clkbuf_2
Xsky130_fd_sc_hs__clkbuf_2_191 VDD VSS sky130_fd_sc_hs__clkbuf_2_192/A sky130_fd_sc_hs__clkinv_4_6/A
+ VSS VDD sky130_fd_sc_hs__clkbuf_2
Xsky130_fd_sc_hs__nand2_1_180 VDD VSS sky130_fd_sc_hs__nor2_1_160/Y sky130_fd_sc_hs__a32o_1_10/A2
+ sky130_fd_sc_hs__nor3_4_2/A VSS VDD sky130_fd_sc_hs__nand2_1
Xsky130_fd_sc_hs__nand2_1_191 VDD VSS sky130_fd_sc_hs__nor3_1_47/B sky130_fd_sc_hs__nor2_2_3/A
+ sky130_fd_sc_hs__nor3_1_48/C VSS VDD sky130_fd_sc_hs__nand2_1
Xsky130_fd_sc_hs__nor3_1_17 VDD VSS sky130_fd_sc_hs__nor3_1_17/Y sky130_fd_sc_hs__nor3_1_17/C
+ sky130_fd_sc_hs__o32a_1_0/A2 sky130_fd_sc_hs__nor3_1_17/A VSS VDD sky130_fd_sc_hs__nor3_1
Xsky130_fd_sc_hs__nor3_1_28 VDD VSS sky130_fd_sc_hs__buf_1_85/A sky130_fd_sc_hs__or3_1_3/C
+ sky130_fd_sc_hs__nor2_4_1/A sky130_fd_sc_hs__or3_1_3/A VSS VDD sky130_fd_sc_hs__nor3_1
Xsky130_fd_sc_hs__nor3_1_39 VDD VSS sky130_fd_sc_hs__nor3_1_39/Y sky130_fd_sc_hs__nor3_1_39/C
+ sky130_fd_sc_hs__nor3_1_39/B sky130_fd_sc_hs__or2_1_22/A VSS VDD sky130_fd_sc_hs__nor3_1
Xsky130_fd_sc_hs__nand2_2_1 VDD VSS sky130_fd_sc_hs__buf_8_12/A sky130_fd_sc_hs__nand2_2_1/B
+ sky130_fd_sc_hs__nor2_2_2/A VSS VDD sky130_fd_sc_hs__nand2_2
Xsky130_fd_sc_hs__dfrtp_1_108 sky130_fd_sc_hs__buf_8_38/X VDD VSS sky130_fd_sc_hs__maj3_1_3/C
+ sky130_fd_sc_hs__clkinv_1_19/A sky130_fd_sc_hs__mux2_1_97/X VSS VDD sky130_fd_sc_hs__dfrtp_1
Xsky130_fd_sc_hs__dfrtp_1_119 sky130_fd_sc_hs__clkbuf_4_2/X VDD VSS sky130_fd_sc_hs__and2_1_6/A
+ sky130_fd_sc_hs__clkbuf_2_39/X sky130_fd_sc_hs__o2bb2ai_1_4/Y VSS VDD sky130_fd_sc_hs__dfrtp_1
Xsky130_fd_sc_hs__clkinv_1_103 VDD VSS sky130_fd_sc_hs__clkinv_1_103/A sky130_fd_sc_hs__clkinv_1_103/Y
+ VSS VDD sky130_fd_sc_hs__clkinv_1
Xsky130_fd_sc_hs__clkinv_1_114 VDD VSS sky130_fd_sc_hs__clkinv_1_114/A sky130_fd_sc_hs__clkinv_1_114/Y
+ VSS VDD sky130_fd_sc_hs__clkinv_1
Xsky130_fd_sc_hs__clkinv_1_125 VDD VSS sky130_fd_sc_hs__clkinv_1_125/A sky130_fd_sc_hs__clkinv_1_125/Y
+ VSS VDD sky130_fd_sc_hs__clkinv_1
Xsky130_fd_sc_hs__clkinv_1_136 VDD VSS sky130_fd_sc_hs__xnor2_1_121/Y sky130_fd_sc_hs__or3_1_7/B
+ VSS VDD sky130_fd_sc_hs__clkinv_1
Xsky130_fd_sc_hs__clkinv_1_147 VDD VSS sky130_fd_sc_hs__o31a_1_6/A2 sky130_fd_sc_hs__o311ai_1_20/B1
+ VSS VDD sky130_fd_sc_hs__clkinv_1
Xsky130_fd_sc_hs__clkinv_1_158 VDD VSS sky130_fd_sc_hs__clkinv_1_158/A sky130_fd_sc_hs__clkinv_1_158/Y
+ VSS VDD sky130_fd_sc_hs__clkinv_1
Xsky130_fd_sc_hs__dfrtp_1_620 sky130_fd_sc_hs__clkbuf_4_31/X VDD VSS sky130_fd_sc_hs__nand2_1_198/A
+ sky130_fd_sc_hs__clkbuf_2_189/X sky130_fd_sc_hs__mux2_1_324/X VSS VDD sky130_fd_sc_hs__dfrtp_1
Xsky130_fd_sc_hs__dfrtp_1_631 sky130_fd_sc_hs__clkbuf_4_30/X VDD VSS sky130_fd_sc_hs__mux2_1_335/A1
+ sky130_fd_sc_hs__clkinv_1_142/A sky130_fd_sc_hs__mux2_1_335/X VSS VDD sky130_fd_sc_hs__dfrtp_1
Xsky130_fd_sc_hs__dfrtp_1_642 sky130_fd_sc_hs__clkbuf_4_30/X VDD VSS sky130_fd_sc_hs__mux2_1_337/A0
+ sky130_fd_sc_hs__clkinv_1_142/A sky130_fd_sc_hs__mux2_1_337/X VSS VDD sky130_fd_sc_hs__dfrtp_1
Xsky130_fd_sc_hs__dfrtp_1_653 sky130_fd_sc_hs__clkbuf_4_31/X VDD VSS sky130_fd_sc_hs__nand2_1_197/A
+ sky130_fd_sc_hs__clkbuf_2_189/X sky130_fd_sc_hs__mux2_1_350/X VSS VDD sky130_fd_sc_hs__dfrtp_1
Xsky130_fd_sc_hs__dfrtp_1_664 sky130_fd_sc_hs__clkbuf_4_35/X VDD VSS sky130_fd_sc_hs__mux2_1_366/A1
+ sky130_fd_sc_hs__clkinv_1_155/A sky130_fd_sc_hs__mux2_1_366/X VSS VDD sky130_fd_sc_hs__dfrtp_1
Xsky130_fd_sc_hs__nor2_1_106 VDD VSS sky130_fd_sc_hs__nor2_1_107/Y sky130_fd_sc_hs__nor2_1_106/Y
+ sky130_fd_sc_hs__nor2_1_106/A VSS VDD sky130_fd_sc_hs__nor2_1
Xsky130_fd_sc_hs__dfrtp_1_675 sky130_fd_sc_hs__clkbuf_4_35/X VDD VSS sky130_fd_sc_hs__mux2_1_379/A1
+ sky130_fd_sc_hs__clkbuf_2_209/X sky130_fd_sc_hs__mux2_1_379/X VSS VDD sky130_fd_sc_hs__dfrtp_1
Xsky130_fd_sc_hs__nor2_1_117 VDD VSS sky130_fd_sc_hs__nor2_1_82/B sky130_fd_sc_hs__nor2_1_117/Y
+ sky130_fd_sc_hs__xor2_1_74/A VSS VDD sky130_fd_sc_hs__nor2_1
Xsky130_fd_sc_hs__dfrtp_1_686 sky130_fd_sc_hs__clkbuf_4_33/X VDD VSS sky130_fd_sc_hs__mux2_1_395/A0
+ sky130_fd_sc_hs__clkbuf_2_214/X sky130_fd_sc_hs__mux2_1_395/X VSS VDD sky130_fd_sc_hs__dfrtp_1
Xsky130_fd_sc_hs__nor2_1_128 VDD VSS sky130_fd_sc_hs__nor2_1_128/B sky130_fd_sc_hs__nor2b_1_33/A
+ sky130_fd_sc_hs__or2_1_30/B VSS VDD sky130_fd_sc_hs__nor2_1
Xsky130_fd_sc_hs__dfrtp_1_5 sky130_fd_sc_hs__clkbuf_4_4/X VDD VSS sky130_fd_sc_hs__mux2_1_3/A0
+ sky130_fd_sc_hs__clkbuf_2_5/X sky130_fd_sc_hs__mux2_1_3/X VSS VDD sky130_fd_sc_hs__dfrtp_1
Xsky130_fd_sc_hs__nor2_1_139 VDD VSS sky130_fd_sc_hs__o21a_1_26/A2 sky130_fd_sc_hs__nor2_1_139/Y
+ sky130_fd_sc_hs__nor3_1_37/B VSS VDD sky130_fd_sc_hs__nor2_1
Xsky130_fd_sc_hs__dfrtp_1_697 sky130_fd_sc_hs__clkbuf_4_51/X VDD VSS sky130_fd_sc_hs__mux2_1_399/A0
+ sky130_fd_sc_hs__clkbuf_2_217/X sky130_fd_sc_hs__mux2_1_399/X VSS VDD sky130_fd_sc_hs__dfrtp_1
Xsky130_fd_sc_hs__a22oi_1_15 VDD VSS sky130_fd_sc_hs__mux2_1_5/A0 sky130_fd_sc_hs__and4_1_0/B
+ sky130_fd_sc_hs__nand2_1_51/B sky130_fd_sc_hs__a222o_1_3/C2 sky130_fd_sc_hs__mux2_1_4/A1
+ VSS VDD sky130_fd_sc_hs__a22oi_1
Xsky130_fd_sc_hs__a22oi_1_26 VDD VSS sky130_fd_sc_hs__mux2_1_66/A0 sky130_fd_sc_hs__nand2_1_12/A
+ sky130_fd_sc_hs__a22oi_1_7/B1 sky130_fd_sc_hs__nand2_1_51/B sky130_fd_sc_hs__mux2_1_77/A0
+ VSS VDD sky130_fd_sc_hs__a22oi_1
Xsky130_fd_sc_hs__a22oi_1_37 VDD VSS sky130_fd_sc_hs__mux2_1_114/A1 sky130_fd_sc_hs__nand2_1_34/A
+ sky130_fd_sc_hs__buf_16_9/X sky130_fd_sc_hs__a222o_1_3/C2 sky130_fd_sc_hs__mux2_1_110/A1
+ VSS VDD sky130_fd_sc_hs__a22oi_1
Xsky130_fd_sc_hs__a22oi_1_48 VDD VSS sky130_fd_sc_hs__mux2_1_156/A1 sky130_fd_sc_hs__and4_1_3/C
+ sky130_fd_sc_hs__buf_16_8/X sky130_fd_sc_hs__a22oi_1_6/B1 sky130_fd_sc_hs__maj3_1_9/C
+ VSS VDD sky130_fd_sc_hs__a22oi_1
Xsky130_fd_sc_hs__a22oi_1_59 VDD VSS sky130_fd_sc_hs__nor3_1_33/A sky130_fd_sc_hs__a22oi_1_59/Y
+ sky130_fd_sc_hs__nor2_1_176/Y sky130_fd_sc_hs__and2_1_33/X sky130_fd_sc_hs__mux2i_1_5/A1
+ VSS VDD sky130_fd_sc_hs__a22oi_1
Xsky130_fd_sc_hs__nor2_1_50 VDD VSS sky130_fd_sc_hs__nor3_1_13/Y sky130_fd_sc_hs__nor2_1_50/Y
+ sky130_fd_sc_hs__nor2_1_50/A VSS VDD sky130_fd_sc_hs__nor2_1
Xsky130_fd_sc_hs__nor2_1_61 VDD VSS sky130_fd_sc_hs__nor2_1_82/B sky130_fd_sc_hs__nor2_1_61/Y
+ sky130_fd_sc_hs__xor2_1_29/A VSS VDD sky130_fd_sc_hs__nor2_1
Xsky130_fd_sc_hs__nor2_1_72 VDD VSS sky130_fd_sc_hs__xor2_1_50/A sky130_fd_sc_hs__nor2_1_72/Y
+ sky130_fd_sc_hs__xor2_1_3/A VSS VDD sky130_fd_sc_hs__nor2_1
Xsky130_fd_sc_hs__nor2_1_83 VDD VSS sky130_fd_sc_hs__nor2_1_83/B sky130_fd_sc_hs__nor2_1_83/Y
+ sky130_fd_sc_hs__nor2_1_83/A VSS VDD sky130_fd_sc_hs__nor2_1
Xsky130_fd_sc_hs__nor2_1_94 VDD VSS sky130_fd_sc_hs__nor2_1_94/B sky130_fd_sc_hs__nor2_2_2/A
+ sky130_fd_sc_hs__nor2_1_94/A VSS VDD sky130_fd_sc_hs__nor2_1
Xsky130_fd_sc_hs__xnor2_1_150 VDD VSS sky130_fd_sc_hs__nand2_1_85/Y sky130_fd_sc_hs__a21o_1_4/B1
+ sky130_fd_sc_hs__xor2_1_45/X VSS VDD sky130_fd_sc_hs__xnor2_1
Xsky130_fd_sc_hs__mux2_1_90 VDD VSS sky130_fd_sc_hs__mux2_1_90/X sky130_fd_sc_hs__mux2_1_7/S
+ sky130_fd_sc_hs__mux2_1_90/A0 sky130_fd_sc_hs__mux2_1_94/A1 VSS VDD sky130_fd_sc_hs__mux2_1
Xsky130_fd_sc_hs__xnor2_1_3 VDD VSS sky130_fd_sc_hs__xor2_1_0/A sky130_fd_sc_hs__nor2_1_8/A
+ sky130_fd_sc_hs__xor2_1_0/B VSS VDD sky130_fd_sc_hs__xnor2_1
Xsky130_fd_sc_hs__nor2b_1_50 VDD VSS sky130_fd_sc_hs__or2_1_21/A sky130_fd_sc_hs__nor2b_1_50/Y
+ sky130_fd_sc_hs__or2_1_21/B VSS VDD sky130_fd_sc_hs__nor2b_1
Xsky130_fd_sc_hs__a31o_1_8 VDD VSS sky130_fd_sc_hs__a31o_1_8/X sky130_fd_sc_hs__a31o_1_8/A3
+ sky130_fd_sc_hs__a31o_1_9/A2 sky130_fd_sc_hs__a31o_1_9/A1 sky130_fd_sc_hs__a31o_1_8/B1
+ VSS VDD sky130_fd_sc_hs__a31o_1
Xsky130_fd_sc_hs__or2_1_2 VDD VSS sky130_fd_sc_hs__or2_1_2/B sky130_fd_sc_hs__or2_1_2/A
+ sky130_fd_sc_hs__or2_1_2/X VSS VDD sky130_fd_sc_hs__or2_1
Xsky130_fd_sc_hs__dfrtp_1_450 sky130_fd_sc_hs__clkbuf_4_22/X VDD VSS sky130_fd_sc_hs__buf_1_141/A
+ sky130_fd_sc_hs__clkbuf_2_132/X sky130_fd_sc_hs__buf_1_92/X VSS VDD sky130_fd_sc_hs__dfrtp_1
Xsky130_fd_sc_hs__dfrtp_1_461 sky130_fd_sc_hs__clkbuf_4_22/X VDD VSS sky130_fd_sc_hs__xor2_1_68/B
+ sky130_fd_sc_hs__clkinv_1_94/A sky130_fd_sc_hs__dfrtp_1_461/D VSS VDD sky130_fd_sc_hs__dfrtp_1
Xsky130_fd_sc_hs__dfrtp_1_472 sky130_fd_sc_hs__clkbuf_4_22/A VDD VSS sky130_fd_sc_hs__maj3_1_48/C
+ sky130_fd_sc_hs__clkbuf_2_143/X sky130_fd_sc_hs__nor2_1_112/Y VSS VDD sky130_fd_sc_hs__dfrtp_1
Xsky130_fd_sc_hs__dfrtp_1_483 sky130_fd_sc_hs__clkbuf_4_23/X VDD VSS sky130_fd_sc_hs__or3_1_4/A
+ sky130_fd_sc_hs__clkbuf_2_152/X sky130_fd_sc_hs__dfrtp_1_483/D VSS VDD sky130_fd_sc_hs__dfrtp_1
Xsky130_fd_sc_hs__dfrtp_1_494 sky130_fd_sc_hs__clkbuf_4_23/X VDD VSS sky130_fd_sc_hs__nor3_1_37/B
+ sky130_fd_sc_hs__clkbuf_2_154/X sky130_fd_sc_hs__dfrtp_1_494/D VSS VDD sky130_fd_sc_hs__dfrtp_1
Xsky130_fd_sc_hs__clkbuf_4_2 VDD VSS sky130_fd_sc_hs__buf_8_38/X sky130_fd_sc_hs__clkbuf_4_2/X
+ VSS VDD sky130_fd_sc_hs__clkbuf_4
Xsky130_fd_sc_hs__o21a_1_18 VDD VSS sky130_fd_sc_hs__o21a_1_18/X sky130_fd_sc_hs__and2_1_26/X
+ sky130_fd_sc_hs__buf_8_14/X sky130_fd_sc_hs__xnor2_1_89/Y VSS VDD sky130_fd_sc_hs__o21a_1
Xsky130_fd_sc_hs__o21a_1_29 VDD VSS sky130_fd_sc_hs__o21a_1_29/X sky130_fd_sc_hs__nor3_4_0/C
+ sky130_fd_sc_hs__o21a_1_29/B1 sky130_fd_sc_hs__nor3_4_0/B VSS VDD sky130_fd_sc_hs__o21a_1
Xsky130_fd_sc_hs__and2_1_19 VDD VSS sky130_fd_sc_hs__and2_1_19/A sky130_fd_sc_hs__and2_1_19/B
+ sky130_fd_sc_hs__and2_1_19/X VSS VDD sky130_fd_sc_hs__and2_1
Xsky130_fd_sc_hs__clkinv_4_2 VDD VSS sky130_fd_sc_hs__clkinv_4_2/Y sky130_fd_sc_hs__clkinv_4_2/A
+ VSS VDD sky130_fd_sc_hs__clkinv_4
Xsky130_fd_sc_hs__mux2_1_410 VDD VSS sky130_fd_sc_hs__mux2_1_410/X sky130_fd_sc_hs__buf_16_1/X
+ sky130_fd_sc_hs__mux2_1_410/A0 sky130_fd_sc_hs__a22o_1_88/B2 VSS VDD sky130_fd_sc_hs__mux2_1
Xsky130_fd_sc_hs__mux2_1_421 VDD VSS sky130_fd_sc_hs__mux2_1_421/X sky130_fd_sc_hs__buf_16_15/A
+ sky130_fd_sc_hs__a22o_1_84/B2 sky130_fd_sc_hs__a222o_1_7/C2 VSS VDD sky130_fd_sc_hs__mux2_1
Xsky130_fd_sc_hs__mux2_1_432 VDD VSS sky130_fd_sc_hs__mux2_1_432/X sky130_fd_sc_hs__buf_16_13/A
+ sky130_fd_sc_hs__xor2_1_89/B sky130_fd_sc_hs__a22o_1_88/B2 VSS VDD sky130_fd_sc_hs__mux2_1
Xsky130_fd_sc_hs__mux2_1_443 VDD VSS sky130_fd_sc_hs__mux2_1_443/X sky130_fd_sc_hs__buf_16_3/X
+ sky130_fd_sc_hs__a22o_1_94/B2 sky130_fd_sc_hs__mux2_1_443/A1 VSS VDD sky130_fd_sc_hs__mux2_1
Xsky130_fd_sc_hs__mux2_1_454 VDD VSS sky130_fd_sc_hs__mux2_1_454/X sky130_fd_sc_hs__buf_16_16/A
+ sky130_fd_sc_hs__a22o_1_92/B2 sky130_fd_sc_hs__mux2_1_454/A1 VSS VDD sky130_fd_sc_hs__mux2_1
Xsky130_fd_sc_hs__mux2_1_465 VDD VSS sky130_fd_sc_hs__mux2_1_465/X sky130_fd_sc_hs__buf_8_24/X
+ sky130_fd_sc_hs__mux2_1_477/A1 sky130_fd_sc_hs__mux2_1_465/A1 VSS VDD sky130_fd_sc_hs__mux2_1
Xsky130_fd_sc_hs__mux2_1_476 VDD VSS sky130_fd_sc_hs__mux2_1_476/X sky130_fd_sc_hs__buf_8_23/X
+ sky130_fd_sc_hs__mux2_1_476/A0 sky130_fd_sc_hs__a22o_1_64/B2 VSS VDD sky130_fd_sc_hs__mux2_1
Xsky130_fd_sc_hs__mux2_1_487 VDD VSS sky130_fd_sc_hs__mux2_1_487/X sky130_fd_sc_hs__nor2_1_82/B
+ sky130_fd_sc_hs__xor2_1_67/A sky130_fd_sc_hs__nor2_1_185/Y VSS VDD sky130_fd_sc_hs__mux2_1
Xsky130_fd_sc_hs__buf_4_4 VDD VSS sky130_fd_sc_hs__buf_4_4/A sky130_fd_sc_hs__buf_4_4/X
+ VSS VDD sky130_fd_sc_hs__buf_4
Xsky130_fd_sc_hs__dfrtp_1_280 sky130_fd_sc_hs__buf_2_0/A VDD VSS sky130_fd_sc_hs__and3_1_9/B
+ sky130_fd_sc_hs__clkinv_1_52/A sky130_fd_sc_hs__nor3_1_19/Y VSS VDD sky130_fd_sc_hs__dfrtp_1
Xsky130_fd_sc_hs__dfrtp_1_291 sky130_fd_sc_hs__clkbuf_4_12/A VDD VSS sky130_fd_sc_hs__dfrtp_1_291/Q
+ sky130_fd_sc_hs__clkbuf_2_72/X sky130_fd_sc_hs__nand2_1_69/A VSS VDD sky130_fd_sc_hs__dfrtp_1
Xsky130_fd_sc_hs__buf_1_18 VDD VSS sky130_fd_sc_hs__buf_1_18/A srm_total_count[4]
+ VSS VDD sky130_fd_sc_hs__buf_1
Xsky130_fd_sc_hs__buf_1_29 VDD VSS sky130_fd_sc_hs__buf_1_29/A w_wr_data[2] VSS VDD
+ sky130_fd_sc_hs__buf_1
Xsky130_fd_sc_hs__a22o_1_10 VDD VSS sky130_fd_sc_hs__a22o_1_10/X sky130_fd_sc_hs__xnor3_1_0/X
+ sky130_fd_sc_hs__nor2_4_3/Y sky130_fd_sc_hs__a32o_1_2/B1 sky130_fd_sc_hs__maj3_1_8/A
+ VSS VDD sky130_fd_sc_hs__a22o_1
Xsky130_fd_sc_hs__a22o_1_21 VDD VSS sky130_fd_sc_hs__a22o_1_21/X sky130_fd_sc_hs__a22o_1_21/B2
+ sky130_fd_sc_hs__a22o_1_6/B1 sky130_fd_sc_hs__nor2_2_0/Y sky130_fd_sc_hs__buf_1_16/A
+ VSS VDD sky130_fd_sc_hs__a22o_1
Xsky130_fd_sc_hs__a22o_1_32 VDD VSS sky130_fd_sc_hs__a22o_1_32/X sky130_fd_sc_hs__mux2_1_61/A0
+ sky130_fd_sc_hs__buf_8_17/X sky130_fd_sc_hs__buf_8_15/X sky130_fd_sc_hs__a22o_1_32/A1
+ VSS VDD sky130_fd_sc_hs__a22o_1
Xsky130_fd_sc_hs__clkinv_1_90 VDD VSS sky130_fd_sc_hs__nor2_1_83/B sky130_fd_sc_hs__nand3_1_22/A
+ VSS VDD sky130_fd_sc_hs__clkinv_1
Xsky130_fd_sc_hs__a22o_1_43 VDD VSS sky130_fd_sc_hs__a22o_1_43/X sky130_fd_sc_hs__a22o_1_43/B2
+ sky130_fd_sc_hs__or2_1_11/X sky130_fd_sc_hs__a32o_1_7/B1 sky130_fd_sc_hs__maj3_1_21/C
+ VSS VDD sky130_fd_sc_hs__a22o_1
Xsky130_fd_sc_hs__clkbuf_2_10 VDD VSS sky130_fd_sc_hs__clkbuf_2_10/X sky130_fd_sc_hs__clkinv_4_0/A
+ VSS VDD sky130_fd_sc_hs__clkbuf_2
Xsky130_fd_sc_hs__a22o_1_54 VDD VSS sky130_fd_sc_hs__a22o_1_54/X sky130_fd_sc_hs__a22o_1_64/A1
+ sky130_fd_sc_hs__a22o_1_93/B1 sky130_fd_sc_hs__a22o_1_93/A2 sky130_fd_sc_hs__maj3_1_16/C
+ VSS VDD sky130_fd_sc_hs__a22o_1
Xsky130_fd_sc_hs__clkbuf_2_21 VDD VSS sky130_fd_sc_hs__clkinv_1_8/A sky130_fd_sc_hs__clkbuf_2_92/A
+ VSS VDD sky130_fd_sc_hs__clkbuf_2
Xsky130_fd_sc_hs__a22o_1_65 VDD VSS sky130_fd_sc_hs__a22o_1_65/X sky130_fd_sc_hs__a22o_1_65/B2
+ sky130_fd_sc_hs__a22o_1_93/B1 sky130_fd_sc_hs__a22o_1_93/A2 sky130_fd_sc_hs__nor2_1_68/A
+ VSS VDD sky130_fd_sc_hs__a22o_1
Xsky130_fd_sc_hs__a22o_1_76 VDD VSS sky130_fd_sc_hs__a22o_1_76/X sky130_fd_sc_hs__a22o_1_76/B2
+ sky130_fd_sc_hs__buf_8_16/A sky130_fd_sc_hs__buf_8_18/A sky130_fd_sc_hs__xnor2_1_85/A
+ VSS VDD sky130_fd_sc_hs__a22o_1
Xsky130_fd_sc_hs__clkbuf_2_32 VDD VSS sky130_fd_sc_hs__clkbuf_2_32/X sky130_fd_sc_hs__clkbuf_2_3/A
+ VSS VDD sky130_fd_sc_hs__clkbuf_2
Xsky130_fd_sc_hs__a22o_1_87 VDD VSS sky130_fd_sc_hs__a22o_1_87/X sky130_fd_sc_hs__a22o_1_91/A1
+ sky130_fd_sc_hs__a22o_1_90/B1 sky130_fd_sc_hs__a22o_1_90/A2 sky130_fd_sc_hs__maj3_1_40/C
+ VSS VDD sky130_fd_sc_hs__a22o_1
Xsky130_fd_sc_hs__clkbuf_2_43 VDD VSS sky130_fd_sc_hs__clkinv_2_0/A sky130_fd_sc_hs__inv_8_0/A
+ VSS VDD sky130_fd_sc_hs__clkbuf_2
Xsky130_fd_sc_hs__a22o_1_98 VDD VSS sky130_fd_sc_hs__a22o_1_98/X sky130_fd_sc_hs__o31a_1_3/X
+ sky130_fd_sc_hs__o21ai_1_51/Y sky130_fd_sc_hs__a32o_1_7/B1 sky130_fd_sc_hs__maj3_1_36/C
+ VSS VDD sky130_fd_sc_hs__a22o_1
Xsky130_fd_sc_hs__clkbuf_2_54 VDD VSS sky130_fd_sc_hs__clkinv_1_39/A sky130_fd_sc_hs__inv_8_0/A
+ VSS VDD sky130_fd_sc_hs__clkbuf_2
Xsky130_fd_sc_hs__a21o_1_7 VDD VSS sky130_fd_sc_hs__a21o_1_7/X sky130_fd_sc_hs__maj3_1_59/X
+ sky130_fd_sc_hs__and2_1_48/X sky130_fd_sc_hs__a21o_1_7/A2 VSS VDD sky130_fd_sc_hs__a21o_1
Xsky130_fd_sc_hs__clkbuf_2_65 VDD VSS sky130_fd_sc_hs__clkinv_1_49/A sky130_fd_sc_hs__clkbuf_2_92/A
+ VSS VDD sky130_fd_sc_hs__clkbuf_2
Xsky130_fd_sc_hs__clkbuf_2_76 VDD VSS sky130_fd_sc_hs__clkbuf_2_76/X sky130_fd_sc_hs__clkinv_4_2/A
+ VSS VDD sky130_fd_sc_hs__clkbuf_2
Xsky130_fd_sc_hs__nand4_1_4 VDD VSS sky130_fd_sc_hs__nand4_1_4/C sky130_fd_sc_hs__nand4_1_4/Y
+ sky130_fd_sc_hs__nor2_1_93/Y sky130_fd_sc_hs__nor2_2_2/B sky130_fd_sc_hs__nand4_1_5/A
+ VSS VDD sky130_fd_sc_hs__nand4_1
Xsky130_fd_sc_hs__clkbuf_2_87 VDD VSS sky130_fd_sc_hs__clkinv_1_57/A sky130_fd_sc_hs__clkinv_4_3/A
+ VSS VDD sky130_fd_sc_hs__clkbuf_2
Xsky130_fd_sc_hs__clkbuf_2_98 VDD VSS sky130_fd_sc_hs__clkinv_1_65/A sky130_fd_sc_hs__clkinv_4_4/A
+ VSS VDD sky130_fd_sc_hs__clkbuf_2
Xsky130_fd_sc_hs__maj3_1_16 VDD VSS sky130_fd_sc_hs__xor2_1_51/A sky130_fd_sc_hs__xor2_1_51/B
+ sky130_fd_sc_hs__xor2_1_27/A sky130_fd_sc_hs__maj3_1_16/C VSS VDD sky130_fd_sc_hs__maj3_1
Xsky130_fd_sc_hs__maj3_1_27 VDD VSS sky130_fd_sc_hs__xor2_1_39/A sky130_fd_sc_hs__xor2_1_39/B
+ sky130_fd_sc_hs__maj3_1_27/X sky130_fd_sc_hs__maj3_1_27/C VSS VDD sky130_fd_sc_hs__maj3_1
Xsky130_fd_sc_hs__maj3_1_38 VDD VSS sky130_fd_sc_hs__xor2_1_66/A sky130_fd_sc_hs__xor2_1_66/B
+ sky130_fd_sc_hs__maj3_1_38/X sky130_fd_sc_hs__maj3_1_38/C VSS VDD sky130_fd_sc_hs__maj3_1
Xsky130_fd_sc_hs__maj3_1_49 VDD VSS sky130_fd_sc_hs__xor2_1_59/A sky130_fd_sc_hs__xor2_1_59/B
+ sky130_fd_sc_hs__maj3_1_49/X sky130_fd_sc_hs__maj3_1_49/C VSS VDD sky130_fd_sc_hs__maj3_1
Xsky130_fd_sc_hs__nor4_1_0 VDD VSS sky130_fd_sc_hs__nor4_1_0/Y sky130_fd_sc_hs__nor4_1_0/D
+ sky130_fd_sc_hs__nor4_1_0/C sky130_fd_sc_hs__nor4_1_0/B sky130_fd_sc_hs__nor4_1_0/A
+ VSS VDD sky130_fd_sc_hs__nor4_1
Xsky130_fd_sc_hs__nand2_1_10 VDD VSS sky130_fd_sc_hs__a22o_1_8/A2 sky130_fd_sc_hs__nand3_1_6/A
+ sky130_fd_sc_hs__nand2_1_10/A VSS VDD sky130_fd_sc_hs__nand2_1
Xsky130_fd_sc_hs__nand2_1_21 VDD VSS sky130_fd_sc_hs__maj3_1_8/B sky130_fd_sc_hs__nand2_1_21/Y
+ sky130_fd_sc_hs__maj3_1_8/A VSS VDD sky130_fd_sc_hs__nand2_1
Xsky130_fd_sc_hs__mux2_1_240 VDD VSS sky130_fd_sc_hs__mux2_1_240/X sky130_fd_sc_hs__mux2_1_370/S
+ sky130_fd_sc_hs__xor2_1_65/B sky130_fd_sc_hs__mux2_1_355/A1 VSS VDD sky130_fd_sc_hs__mux2_1
Xsky130_fd_sc_hs__nand2_1_32 VDD VSS sky130_fd_sc_hs__or3_1_0/X sky130_fd_sc_hs__o21ai_1_9/A1
+ sky130_fd_sc_hs__nand2_1_32/A VSS VDD sky130_fd_sc_hs__nand2_1
Xsky130_fd_sc_hs__mux2_1_251 VDD VSS sky130_fd_sc_hs__mux2_1_251/X sky130_fd_sc_hs__nor2_1_93/B
+ sky130_fd_sc_hs__a32oi_1_1/B2 sky130_fd_sc_hs__a22o_1_84/B2 VSS VDD sky130_fd_sc_hs__mux2_1
Xsky130_fd_sc_hs__mux2_1_262 VDD VSS sky130_fd_sc_hs__mux2_1_262/X sky130_fd_sc_hs__mux2_1_328/S
+ sky130_fd_sc_hs__mux2_1_262/A0 sky130_fd_sc_hs__a22o_1_62/B2 VSS VDD sky130_fd_sc_hs__mux2_1
Xsky130_fd_sc_hs__nand2_1_43 VDD VSS sky130_fd_sc_hs__a32o_1_2/B1 sky130_fd_sc_hs__nand2_1_44/A
+ sky130_fd_sc_hs__nor2_1_26/A VSS VDD sky130_fd_sc_hs__nand2_1
Xsky130_fd_sc_hs__nand2_1_54 VDD VSS sky130_fd_sc_hs__xor2_1_18/B sky130_fd_sc_hs__nand2_1_54/Y
+ sky130_fd_sc_hs__xor2_1_18/A VSS VDD sky130_fd_sc_hs__nand2_1
Xsky130_fd_sc_hs__mux2_1_273 VDD VSS sky130_fd_sc_hs__mux2_1_273/X sky130_fd_sc_hs__buf_4_1/A
+ sky130_fd_sc_hs__a22o_1_84/B2 sky130_fd_sc_hs__a222o_1_7/A1 VSS VDD sky130_fd_sc_hs__mux2_1
Xsky130_fd_sc_hs__nand2_1_65 VDD VSS sky130_fd_sc_hs__or2_1_10/B sky130_fd_sc_hs__nor2_1_57/B
+ sky130_fd_sc_hs__or2_1_10/A VSS VDD sky130_fd_sc_hs__nand2_1
Xsky130_fd_sc_hs__mux2_1_284 VDD VSS sky130_fd_sc_hs__mux2_1_284/X sky130_fd_sc_hs__o31ai_2_0/B1
+ sky130_fd_sc_hs__buf_1_163/A sky130_fd_sc_hs__a22o_1_91/B2 VSS VDD sky130_fd_sc_hs__mux2_1
Xsky130_fd_sc_hs__nand2_1_76 VDD VSS sky130_fd_sc_hs__a21o_1_3/A1 sky130_fd_sc_hs__xnor2_1_67/A
+ sky130_fd_sc_hs__nand2_1_85/A VSS VDD sky130_fd_sc_hs__nand2_1
Xsky130_fd_sc_hs__mux2_1_295 VDD VSS sky130_fd_sc_hs__mux2_1_295/X sky130_fd_sc_hs__mux2_1_98/S
+ sky130_fd_sc_hs__mux2_1_295/A0 sky130_fd_sc_hs__a22o_1_61/B2 VSS VDD sky130_fd_sc_hs__mux2_1
Xsky130_fd_sc_hs__nand2_1_87 VDD VSS sky130_fd_sc_hs__a31o_1_8/X sky130_fd_sc_hs__a32o_1_7/A2
+ sky130_fd_sc_hs__xnor2_1_68/Y VSS VDD sky130_fd_sc_hs__nand2_1
Xsky130_fd_sc_hs__a222oi_1_17 VDD VSS sky130_fd_sc_hs__buf_8_32/X sky130_fd_sc_hs__mux2_1_314/A1
+ sky130_fd_sc_hs__buf_8_33/X sky130_fd_sc_hs__a222o_1_7/B1 sky130_fd_sc_hs__xor2_1_65/A
+ sky130_fd_sc_hs__nand4_1_10/D sky130_fd_sc_hs__mux2_1_355/A0 VSS VDD sky130_fd_sc_hs__a222oi_1
Xsky130_fd_sc_hs__nand2_1_98 VDD VSS sky130_fd_sc_hs__or2_1_15/B sky130_fd_sc_hs__nand2_1_98/Y
+ sky130_fd_sc_hs__or2_1_15/A VSS VDD sky130_fd_sc_hs__nand2_1
Xsky130_fd_sc_hs__a222oi_1_28 VDD VSS sky130_fd_sc_hs__mux2_1_231/A1 sky130_fd_sc_hs__buf_8_32/X
+ sky130_fd_sc_hs__buf_4_4/A sky130_fd_sc_hs__a222o_1_7/B1 sky130_fd_sc_hs__xor2_1_54/A
+ sky130_fd_sc_hs__nand2_1_196/A sky130_fd_sc_hs__xor2_1_54/B VSS VDD sky130_fd_sc_hs__a222oi_1
Xsky130_fd_sc_hs__a22oi_1_108 VDD VSS sky130_fd_sc_hs__mux2_1_441/A0 sky130_fd_sc_hs__nand3_1_45/B
+ sky130_fd_sc_hs__nand2_1_51/B sky130_fd_sc_hs__a22oi_1_6/A2 sky130_fd_sc_hs__mux2_1_440/A1
+ VSS VDD sky130_fd_sc_hs__a22oi_1
Xsky130_fd_sc_hs__a22oi_1_119 VDD VSS sky130_fd_sc_hs__mux2i_1_3/A0 sky130_fd_sc_hs__a22oi_1_119/Y
+ sky130_fd_sc_hs__nor2b_1_49/Y sky130_fd_sc_hs__and2_1_33/X sky130_fd_sc_hs__mux2i_1_14/A0
+ VSS VDD sky130_fd_sc_hs__a22oi_1
Xsky130_fd_sc_hs__dlygate4sd3_1_11 VSS VDD raw_bits_i[8] sky130_fd_sc_hs__buf_1_77/A
+ VSS VDD sky130_fd_sc_hs__dlygate4sd3_1
Xsky130_fd_sc_hs__dlygate4sd3_1_22 VSS VDD raw_bits_i[15] sky130_fd_sc_hs__buf_1_76/A
+ VSS VDD sky130_fd_sc_hs__dlygate4sd3_1
Xsky130_fd_sc_hs__o21ai_1_11 VDD VSS sky130_fd_sc_hs__o21ai_1_11/Y sky130_fd_sc_hs__buf_1_22/X
+ sky130_fd_sc_hs__and2_1_10/X sky130_fd_sc_hs__o21a_1_3/X VSS VDD sky130_fd_sc_hs__o21ai_1
Xsky130_fd_sc_hs__o21ai_1_22 VDD VSS sky130_fd_sc_hs__o21ai_1_22/Y sky130_fd_sc_hs__nor2_4_3/Y
+ sky130_fd_sc_hs__o21a_1_6/X sky130_fd_sc_hs__nor2_1_33/Y VSS VDD sky130_fd_sc_hs__o21ai_1
Xsky130_fd_sc_hs__o21ai_1_33 VDD VSS sky130_fd_sc_hs__o21ai_1_33/Y sky130_fd_sc_hs__a21oi_1_59/Y
+ sky130_fd_sc_hs__or2_1_10/X sky130_fd_sc_hs__o21a_1_16/A1 VSS VDD sky130_fd_sc_hs__o21ai_1
Xsky130_fd_sc_hs__o21ai_1_44 VDD VSS sky130_fd_sc_hs__o21ai_1_44/Y sky130_fd_sc_hs__buf_8_2/X
+ sky130_fd_sc_hs__buf_8_10/A sky130_fd_sc_hs__xor2_1_3/A VSS VDD sky130_fd_sc_hs__o21ai_1
Xsky130_fd_sc_hs__o21ai_1_55 VDD VSS sky130_fd_sc_hs__o21ai_1_55/Y sky130_fd_sc_hs__o21ai_1_55/B1
+ sky130_fd_sc_hs__xor2_1_73/X sky130_fd_sc_hs__maj3_1_43/X VSS VDD sky130_fd_sc_hs__o21ai_1
Xsky130_fd_sc_hs__o21ai_1_66 VDD VSS sky130_fd_sc_hs__o21ai_1_66/Y sky130_fd_sc_hs__o21a_1_4/B1
+ sky130_fd_sc_hs__nor3_1_45/Y sky130_fd_sc_hs__o21ai_1_66/A1 VSS VDD sky130_fd_sc_hs__o21ai_1
Xsky130_fd_sc_hs__o21ai_1_77 VDD VSS sky130_fd_sc_hs__o21ai_1_77/Y sky130_fd_sc_hs__o311ai_1_17/Y
+ sky130_fd_sc_hs__nand4_1_9/Y sky130_fd_sc_hs__or2_1_25/A VSS VDD sky130_fd_sc_hs__o21ai_1
Xsky130_fd_sc_hs__o21ai_1_88 VDD VSS sky130_fd_sc_hs__o21ai_1_88/Y sky130_fd_sc_hs__or3_1_8/B
+ sky130_fd_sc_hs__or3_1_8/C sky130_fd_sc_hs__or3_1_8/A VSS VDD sky130_fd_sc_hs__o21ai_1
Xsky130_fd_sc_hs__o21ai_1_99 VDD VSS sky130_fd_sc_hs__o21ai_1_99/Y sky130_fd_sc_hs__buf_8_37/X
+ sky130_fd_sc_hs__buf_8_36/X sky130_fd_sc_hs__xor2_1_85/A VSS VDD sky130_fd_sc_hs__o21ai_1
Xsky130_fd_sc_hs__o211ai_1_11 VDD VSS sky130_fd_sc_hs__nor2_1_121/Y sky130_fd_sc_hs__o211ai_1_11/Y
+ sky130_fd_sc_hs__o32ai_1_0/B2 sky130_fd_sc_hs__or2_1_30/B sky130_fd_sc_hs__or2_1_21/B
+ VSS VDD sky130_fd_sc_hs__o211ai_1
Xsky130_fd_sc_hs__buf_16_7 sky130_fd_sc_hs__buf_16_7/X VDD VSS sky130_fd_sc_hs__buf_16_7/A
+ VSS VDD sky130_fd_sc_hs__buf_16
Xsky130_fd_sc_hs__nor2_4_1 VDD VSS sky130_fd_sc_hs__nor2_4_3/A sky130_fd_sc_hs__nor2_4_1/A
+ sky130_fd_sc_hs__or3_1_3/B VSS VDD sky130_fd_sc_hs__nor2_4
Xsky130_fd_sc_hs__dfrtp_1_802 sky130_fd_sc_hs__buf_8_9/X VDD VSS sky130_fd_sc_hs__xor2_1_56/B
+ sky130_fd_sc_hs__clkbuf_2_239/X sky130_fd_sc_hs__mux2_1_227/X VSS VDD sky130_fd_sc_hs__dfrtp_1
Xsky130_fd_sc_hs__dfrtp_1_813 sky130_fd_sc_hs__clkbuf_4_2/X VDD VSS sky130_fd_sc_hs__mux2_1_476/A0
+ sky130_fd_sc_hs__clkinv_1_132/A sky130_fd_sc_hs__mux2_1_476/X VSS VDD sky130_fd_sc_hs__dfrtp_1
Xsky130_fd_sc_hs__dfrtp_1_824 sky130_fd_sc_hs__buf_8_9/A VDD VSS sky130_fd_sc_hs__xor2_1_45/A
+ sky130_fd_sc_hs__clkbuf_2_102/X sky130_fd_sc_hs__a22o_1_58/X VSS VDD sky130_fd_sc_hs__dfrtp_1
Xsky130_fd_sc_hs__dfrtp_1_835 sky130_fd_sc_hs__clkbuf_4_1/X VDD VSS sky130_fd_sc_hs__nand2_1_10/A
+ sky130_fd_sc_hs__clkinv_1_8/A sky130_fd_sc_hs__mux2_1_53/X VSS VDD sky130_fd_sc_hs__dfrtp_1
Xsky130_fd_sc_hs__a21oi_1_110 VDD VSS sky130_fd_sc_hs__nand2_2_1/B sky130_fd_sc_hs__or3_1_1/C
+ sky130_fd_sc_hs__nor2_2_2/B sky130_fd_sc_hs__nor2_2_2/A VSS VDD sky130_fd_sc_hs__a21oi_1
Xsky130_fd_sc_hs__clkbuf_8_9 VDD VSS sky130_fd_sc_hs__mux2_1_368/S sky130_fd_sc_hs__nor2_2_7/Y
+ VSS VDD sky130_fd_sc_hs__clkbuf_8
Xsky130_fd_sc_hs__a21oi_1_121 VDD VSS sky130_fd_sc_hs__and4_1_5/B sky130_fd_sc_hs__nor2_1_106/A
+ sky130_fd_sc_hs__nor2_4_0/Y sky130_fd_sc_hs__and4_1_5/A VSS VDD sky130_fd_sc_hs__a21oi_1
Xsky130_fd_sc_hs__a21oi_1_132 VDD VSS sky130_fd_sc_hs__a21oi_1_135/Y sky130_fd_sc_hs__nor2_1_112/B
+ sky130_fd_sc_hs__clkbuf_2_140/X sky130_fd_sc_hs__maj3_1_48/C VSS VDD sky130_fd_sc_hs__a21oi_1
Xsky130_fd_sc_hs__a21oi_1_143 VDD VSS sky130_fd_sc_hs__or2_1_30/B sky130_fd_sc_hs__nor3_1_33/C
+ sky130_fd_sc_hs__or2_1_21/X sky130_fd_sc_hs__nor3_1_44/B VSS VDD sky130_fd_sc_hs__a21oi_1
Xsky130_fd_sc_hs__a21oi_1_154 VDD VSS sky130_fd_sc_hs__or2_1_22/X sky130_fd_sc_hs__or2_1_23/B
+ sky130_fd_sc_hs__mux2i_1_16/Y sky130_fd_sc_hs__and2_1_35/B VSS VDD sky130_fd_sc_hs__a21oi_1
Xsky130_fd_sc_hs__a21oi_1_165 VDD VSS sky130_fd_sc_hs__mux2i_1_9/A1 sky130_fd_sc_hs__a21oi_1_165/Y
+ sky130_fd_sc_hs__nand2_1_159/B sky130_fd_sc_hs__nor3_1_41/B VSS VDD sky130_fd_sc_hs__a21oi_1
Xsky130_fd_sc_hs__a21oi_1_176 VDD VSS sky130_fd_sc_hs__buf_1_161/A sky130_fd_sc_hs__a21oi_1_176/Y
+ sky130_fd_sc_hs__mux2_1_5/S sky130_fd_sc_hs__nand4_1_9/D VSS VDD sky130_fd_sc_hs__a21oi_1
Xsky130_fd_sc_hs__a21oi_1_187 VDD VSS sky130_fd_sc_hs__nand3_1_37/Y sky130_fd_sc_hs__nand3_1_38/A
+ sky130_fd_sc_hs__a222o_1_2/A2 sky130_fd_sc_hs__mux2_1_363/A0 VSS VDD sky130_fd_sc_hs__a21oi_1
Xsky130_fd_sc_hs__a21oi_1_198 VDD VSS sky130_fd_sc_hs__o21ai_1_108/Y sky130_fd_sc_hs__a21oi_1_198/Y
+ sky130_fd_sc_hs__xor2_1_86/X sky130_fd_sc_hs__maj3_1_62/X VSS VDD sky130_fd_sc_hs__a21oi_1
Xsky130_fd_sc_hs__clkbuf_2_170 VDD VSS sky130_fd_sc_hs__clkinv_1_123/A sky130_fd_sc_hs__clkbuf_2_176/A
+ VSS VDD sky130_fd_sc_hs__clkbuf_2
Xsky130_fd_sc_hs__clkbuf_2_181 VDD VSS sky130_fd_sc_hs__clkinv_1_131/A sky130_fd_sc_hs__clkbuf_2_236/A
+ VSS VDD sky130_fd_sc_hs__clkbuf_2
Xsky130_fd_sc_hs__clkbuf_2_192 VDD VSS sky130_fd_sc_hs__clkbuf_2_192/X sky130_fd_sc_hs__clkbuf_2_192/A
+ VSS VDD sky130_fd_sc_hs__clkbuf_2
Xsky130_fd_sc_hs__nand2_1_170 VDD VSS sky130_fd_sc_hs__nor2b_1_50/Y sky130_fd_sc_hs__o22ai_1_6/B2
+ sky130_fd_sc_hs__nor3_1_40/Y VSS VDD sky130_fd_sc_hs__nand2_1
Xsky130_fd_sc_hs__nand2_1_181 VDD VSS sky130_fd_sc_hs__nor3_1_48/B sky130_fd_sc_hs__nor2_1_160/B
+ sky130_fd_sc_hs__nor3_1_48/A VSS VDD sky130_fd_sc_hs__nand2_1
Xsky130_fd_sc_hs__nand2_1_192 VDD VSS sky130_fd_sc_hs__nor2_1_159/B sky130_fd_sc_hs__nor3_4_2/B
+ sky130_fd_sc_hs__o21a_1_29/B1 VSS VDD sky130_fd_sc_hs__nand2_1
Xsky130_fd_sc_hs__nor3_1_18 VDD VSS sky130_fd_sc_hs__nor3_1_18/Y sky130_fd_sc_hs__nor3_1_18/C
+ sky130_fd_sc_hs__and3_1_9/C sky130_fd_sc_hs__o32a_1_0/A2 VSS VDD sky130_fd_sc_hs__nor3_1
Xsky130_fd_sc_hs__nor3_1_29 VDD VSS sky130_fd_sc_hs__buf_1_84/A sky130_fd_sc_hs__or3_1_3/C
+ sky130_fd_sc_hs__or3_1_3/B sky130_fd_sc_hs__or3_1_3/A VSS VDD sky130_fd_sc_hs__nor3_1
Xsky130_fd_sc_hs__nand2_2_2 VDD VSS sky130_fd_sc_hs__o21a_1_4/B1 sky130_fd_sc_hs__nand2_2_2/B
+ sky130_fd_sc_hs__nand2_2_2/A VSS VDD sky130_fd_sc_hs__nand2_2
Xsky130_fd_sc_hs__dfrtp_1_109 sky130_fd_sc_hs__clkbuf_4_2/X VDD VSS sky130_fd_sc_hs__mux2_1_106/A0
+ sky130_fd_sc_hs__clkbuf_2_37/X sky130_fd_sc_hs__mux2_1_106/X VSS VDD sky130_fd_sc_hs__dfrtp_1
Xsky130_fd_sc_hs__clkinv_1_104 VDD VSS sky130_fd_sc_hs__nor2_1_152/A sky130_fd_sc_hs__o22ai_1_6/A1
+ VSS VDD sky130_fd_sc_hs__clkinv_1
Xsky130_fd_sc_hs__clkinv_1_115 VDD VSS sky130_fd_sc_hs__nor3_1_48/B sky130_fd_sc_hs__nor3_1_46/B
+ VSS VDD sky130_fd_sc_hs__clkinv_1
Xsky130_fd_sc_hs__clkinv_1_126 VDD VSS sky130_fd_sc_hs__clkinv_1_126/A sky130_fd_sc_hs__clkinv_1_126/Y
+ VSS VDD sky130_fd_sc_hs__clkinv_1
Xsky130_fd_sc_hs__clkinv_1_137 VDD VSS sky130_fd_sc_hs__o31a_1_7/A2 sky130_fd_sc_hs__o311a_1_0/B1
+ VSS VDD sky130_fd_sc_hs__clkinv_1
Xsky130_fd_sc_hs__clkinv_1_148 VDD VSS sky130_fd_sc_hs__xor2_1_84/X sky130_fd_sc_hs__nor2_1_178/B
+ VSS VDD sky130_fd_sc_hs__clkinv_1
Xsky130_fd_sc_hs__clkinv_1_159 VDD VSS sky130_fd_sc_hs__xnor3_1_1/A sky130_fd_sc_hs__a41o_1_0/B1
+ VSS VDD sky130_fd_sc_hs__clkinv_1
Xsky130_fd_sc_hs__dfrtp_1_610 sky130_fd_sc_hs__clkbuf_4_2/X VDD VSS sky130_fd_sc_hs__mux2_1_483/A0
+ sky130_fd_sc_hs__clkinv_1_133/A sky130_fd_sc_hs__mux2_1_483/X VSS VDD sky130_fd_sc_hs__dfrtp_1
Xsky130_fd_sc_hs__dfrtp_1_621 sky130_fd_sc_hs__clkbuf_4_31/X VDD VSS sky130_fd_sc_hs__mux2_1_322/A1
+ sky130_fd_sc_hs__clkbuf_2_189/X sky130_fd_sc_hs__mux2_1_322/X VSS VDD sky130_fd_sc_hs__dfrtp_1
Xsky130_fd_sc_hs__dfrtp_1_632 sky130_fd_sc_hs__buf_8_30/X VDD VSS sky130_fd_sc_hs__mux2_1_336/A0
+ sky130_fd_sc_hs__clkinv_1_142/A sky130_fd_sc_hs__mux2_1_336/X VSS VDD sky130_fd_sc_hs__dfrtp_1
Xsky130_fd_sc_hs__dfrtp_1_643 sky130_fd_sc_hs__clkbuf_4_30/X VDD VSS sky130_fd_sc_hs__mux2_1_341/A1
+ sky130_fd_sc_hs__clkinv_1_144/A sky130_fd_sc_hs__mux2_1_341/X VSS VDD sky130_fd_sc_hs__dfrtp_1
Xsky130_fd_sc_hs__dfrtp_1_654 sky130_fd_sc_hs__clkbuf_4_2/X VDD VSS sky130_fd_sc_hs__a221o_1_1/A1
+ sky130_fd_sc_hs__clkinv_1_132/A sky130_fd_sc_hs__mux2_1_311/X VSS VDD sky130_fd_sc_hs__dfrtp_1
Xsky130_fd_sc_hs__dfrtp_1_665 sky130_fd_sc_hs__clkbuf_4_35/X VDD VSS sky130_fd_sc_hs__mux2_1_368/A0
+ sky130_fd_sc_hs__dfrtp_2_4/CLK sky130_fd_sc_hs__mux2_1_368/X VSS VDD sky130_fd_sc_hs__dfrtp_1
Xsky130_fd_sc_hs__nor2_1_107 VDD VSS sky130_fd_sc_hs__nor2_1_107/B sky130_fd_sc_hs__nor2_1_107/Y
+ sky130_fd_sc_hs__buf_8_13/X VSS VDD sky130_fd_sc_hs__nor2_1
Xsky130_fd_sc_hs__dfrtp_1_676 sky130_fd_sc_hs__clkbuf_4_35/X VDD VSS sky130_fd_sc_hs__mux2_1_382/A1
+ sky130_fd_sc_hs__clkbuf_2_209/X sky130_fd_sc_hs__mux2_1_382/X VSS VDD sky130_fd_sc_hs__dfrtp_1
Xsky130_fd_sc_hs__nor2_1_118 VDD VSS sky130_fd_sc_hs__nor3_4_8/B sky130_fd_sc_hs__o21a_1_23/A2
+ sky130_fd_sc_hs__o21ai_1_58/Y VSS VDD sky130_fd_sc_hs__nor2_1
Xsky130_fd_sc_hs__dfrtp_1_687 sky130_fd_sc_hs__clkbuf_4_33/X VDD VSS sky130_fd_sc_hs__xor2_1_88/B
+ sky130_fd_sc_hs__clkbuf_2_213/X sky130_fd_sc_hs__mux2_1_389/X VSS VDD sky130_fd_sc_hs__dfrtp_1
Xsky130_fd_sc_hs__nor2_1_129 VDD VSS sky130_fd_sc_hs__nor2b_1_33/A sky130_fd_sc_hs__nor2_1_129/Y
+ sky130_fd_sc_hs__nor2_1_129/A VSS VDD sky130_fd_sc_hs__nor2_1
Xsky130_fd_sc_hs__dfrtp_1_6 sky130_fd_sc_hs__clkbuf_4_4/X VDD VSS sky130_fd_sc_hs__mux2_1_9/A0
+ sky130_fd_sc_hs__clkbuf_2_1/X sky130_fd_sc_hs__mux2_1_9/X VSS VDD sky130_fd_sc_hs__dfrtp_1
Xsky130_fd_sc_hs__dfrtp_1_698 sky130_fd_sc_hs__clkbuf_4_51/X VDD VSS sky130_fd_sc_hs__mux2_1_400/A0
+ sky130_fd_sc_hs__clkbuf_2_215/X sky130_fd_sc_hs__mux2_1_400/X VSS VDD sky130_fd_sc_hs__dfrtp_1
Xsky130_fd_sc_hs__a22oi_1_16 VDD VSS sky130_fd_sc_hs__nor2_1_2/A sky130_fd_sc_hs__nor3_1_5/C
+ sky130_fd_sc_hs__nand2b_1_2/Y sky130_fd_sc_hs__nor3_1_2/C sky130_fd_sc_hs__nor2_1_8/A
+ VSS VDD sky130_fd_sc_hs__a22oi_1
Xsky130_fd_sc_hs__a22oi_1_27 VDD VSS sky130_fd_sc_hs__mux2_1_78/A0 sky130_fd_sc_hs__nand2_1_12/B
+ sky130_fd_sc_hs__buf_16_7/X sky130_fd_sc_hs__a22oi_1_6/A2 sky130_fd_sc_hs__mux2_1_69/A1
+ VSS VDD sky130_fd_sc_hs__a22oi_1
Xsky130_fd_sc_hs__a22oi_1_38 VDD VSS sky130_fd_sc_hs__mux2_1_96/A1 sky130_fd_sc_hs__nand2_1_16/B
+ sky130_fd_sc_hs__a222o_1_3/C2 sky130_fd_sc_hs__a22oi_1_6/B1 sky130_fd_sc_hs__maj3_1_1/C
+ VSS VDD sky130_fd_sc_hs__a22oi_1
Xsky130_fd_sc_hs__a22oi_1_49 VDD VSS sky130_fd_sc_hs__maj3_1_9/B sky130_fd_sc_hs__nand4_1_0/C
+ sky130_fd_sc_hs__a22o_1_8/B1 sky130_fd_sc_hs__a22o_1_8/A2 sky130_fd_sc_hs__mux2_1_143/A0
+ VSS VDD sky130_fd_sc_hs__a22oi_1
Xsky130_fd_sc_hs__nor2_1_40 VDD VSS sky130_fd_sc_hs__nor2_1_40/B sky130_fd_sc_hs__or2_1_8/B
+ sky130_fd_sc_hs__o32a_1_0/A1 VSS VDD sky130_fd_sc_hs__nor2_1
Xsky130_fd_sc_hs__nor2_1_51 VDD VSS sky130_fd_sc_hs__and3_1_8/B sky130_fd_sc_hs__nor2_1_51/Y
+ sky130_fd_sc_hs__and3_1_8/A VSS VDD sky130_fd_sc_hs__nor2_1
Xsky130_fd_sc_hs__nor2_1_62 VDD VSS sky130_fd_sc_hs__nor2_1_62/B sky130_fd_sc_hs__nor2_1_62/Y
+ sky130_fd_sc_hs__buf_8_19/X VSS VDD sky130_fd_sc_hs__nor2_1
Xsky130_fd_sc_hs__nor2_1_73 VDD VSS sky130_fd_sc_hs__or2_1_6/A sky130_fd_sc_hs__nor2_1_73/Y
+ sky130_fd_sc_hs__nor2_1_73/A VSS VDD sky130_fd_sc_hs__nor2_1
Xsky130_fd_sc_hs__nor2_1_84 VDD VSS sky130_fd_sc_hs__buf_8_11/A sky130_fd_sc_hs__nor2_1_84/Y
+ sky130_fd_sc_hs__xor2_1_62/B VSS VDD sky130_fd_sc_hs__nor2_1
Xsky130_fd_sc_hs__nor2_1_95 VDD VSS sky130_fd_sc_hs__nor2_1_95/B sky130_fd_sc_hs__or3_1_1/A
+ sky130_fd_sc_hs__buf_1_94/X VSS VDD sky130_fd_sc_hs__nor2_1
Xsky130_fd_sc_hs__xnor2_1_140 VDD VSS sky130_fd_sc_hs__xor2_1_85/A sky130_fd_sc_hs__xnor2_1_143/B
+ sky130_fd_sc_hs__xor2_1_90/X VSS VDD sky130_fd_sc_hs__xnor2_1
Xsky130_fd_sc_hs__mux2_1_80 VDD VSS sky130_fd_sc_hs__mux2_1_80/X sky130_fd_sc_hs__mux2_1_5/S
+ sky130_fd_sc_hs__mux2_1_80/A0 sky130_fd_sc_hs__mux2_1_95/A1 VSS VDD sky130_fd_sc_hs__mux2_1
Xsky130_fd_sc_hs__mux2_1_91 VDD VSS sky130_fd_sc_hs__mux2_1_91/X sky130_fd_sc_hs__buf_16_1/X
+ sky130_fd_sc_hs__mux2_1_91/A0 sky130_fd_sc_hs__mux2_1_94/A1 VSS VDD sky130_fd_sc_hs__mux2_1
Xsky130_fd_sc_hs__xnor2_1_4 VDD VSS sky130_fd_sc_hs__nor3_1_5/Y sky130_fd_sc_hs__xnor2_1_4/Y
+ sky130_fd_sc_hs__xnor2_1_4/B VSS VDD sky130_fd_sc_hs__xnor2_1
Xsky130_fd_sc_hs__nor2b_1_40 VDD VSS sky130_fd_sc_hs__nor3_1_39/C sky130_fd_sc_hs__nor2b_1_40/Y
+ sky130_fd_sc_hs__nor3_1_37/C VSS VDD sky130_fd_sc_hs__nor2b_1
Xsky130_fd_sc_hs__nor2b_1_51 VDD VSS sky130_fd_sc_hs__or3b_1_0/A sky130_fd_sc_hs__nor2b_1_51/Y
+ sky130_fd_sc_hs__or2_1_29/A VSS VDD sky130_fd_sc_hs__nor2b_1
Xsky130_fd_sc_hs__a31o_1_9 VDD VSS sky130_fd_sc_hs__a31o_1_9/X sky130_fd_sc_hs__a31o_1_9/A3
+ sky130_fd_sc_hs__a31o_1_9/A2 sky130_fd_sc_hs__a31o_1_9/A1 sky130_fd_sc_hs__buf_8_12/X
+ VSS VDD sky130_fd_sc_hs__a31o_1
Xsky130_fd_sc_hs__or2_1_3 VDD VSS sky130_fd_sc_hs__or2_1_3/B sky130_fd_sc_hs__or2_1_3/A
+ sky130_fd_sc_hs__or2_1_3/X VSS VDD sky130_fd_sc_hs__or2_1
Xsky130_fd_sc_hs__dfrtp_1_440 sky130_fd_sc_hs__clkbuf_4_16/X VDD VSS sky130_fd_sc_hs__xor2_1_61/A
+ sky130_fd_sc_hs__clkbuf_2_118/A sky130_fd_sc_hs__mux2_1_238/X VSS VDD sky130_fd_sc_hs__dfrtp_1
Xsky130_fd_sc_hs__dfrtp_1_451 sky130_fd_sc_hs__clkbuf_4_22/X VDD VSS sky130_fd_sc_hs__dfrtp_1_454/D
+ sky130_fd_sc_hs__clkbuf_2_132/X sky130_fd_sc_hs__dfrtp_1_451/D VSS VDD sky130_fd_sc_hs__dfrtp_1
Xsky130_fd_sc_hs__dfrtp_1_462 sky130_fd_sc_hs__clkbuf_4_22/X VDD VSS sky130_fd_sc_hs__xor2_1_68/A
+ sky130_fd_sc_hs__clkinv_1_94/A sky130_fd_sc_hs__dfrtp_1_462/D VSS VDD sky130_fd_sc_hs__dfrtp_1
Xsky130_fd_sc_hs__dfrtp_1_473 sky130_fd_sc_hs__clkbuf_4_22/A VDD VSS sky130_fd_sc_hs__xor2_1_74/B
+ sky130_fd_sc_hs__clkbuf_2_144/X sky130_fd_sc_hs__dfrtp_1_473/D VSS VDD sky130_fd_sc_hs__dfrtp_1
Xsky130_fd_sc_hs__dfrtp_1_484 sky130_fd_sc_hs__clkbuf_4_23/X VDD VSS sky130_fd_sc_hs__xor2_1_75/A
+ sky130_fd_sc_hs__clkbuf_2_152/X sky130_fd_sc_hs__dfrtp_1_484/D VSS VDD sky130_fd_sc_hs__dfrtp_1
Xsky130_fd_sc_hs__dfrtp_1_495 sky130_fd_sc_hs__clkbuf_4_23/X VDD VSS sky130_fd_sc_hs__o21ai_1_63/B1
+ sky130_fd_sc_hs__clkbuf_2_149/X sky130_fd_sc_hs__nand2_1_139/Y VSS VDD sky130_fd_sc_hs__dfrtp_1
Xsky130_fd_sc_hs__clkbuf_4_3 VDD VSS sky130_fd_sc_hs__clkbuf_4_3/A sky130_fd_sc_hs__clkbuf_4_3/X
+ VSS VDD sky130_fd_sc_hs__clkbuf_4
Xsky130_fd_sc_hs__o21a_1_19 VDD VSS sky130_fd_sc_hs__o21a_1_19/X sky130_fd_sc_hs__xor2_1_64/X
+ sky130_fd_sc_hs__o21a_1_19/B1 sky130_fd_sc_hs__xnor2_1_91/A VSS VDD sky130_fd_sc_hs__o21a_1
Xsky130_fd_sc_hs__clkinv_4_3 VDD VSS sky130_fd_sc_hs__clkinv_4_3/Y sky130_fd_sc_hs__clkinv_4_3/A
+ VSS VDD sky130_fd_sc_hs__clkinv_4
Xsky130_fd_sc_hs__mux2_1_400 VDD VSS sky130_fd_sc_hs__mux2_1_400/X sky130_fd_sc_hs__buf_16_4/A
+ sky130_fd_sc_hs__mux2_1_400/A0 sky130_fd_sc_hs__dfrtp_2_2/Q VSS VDD sky130_fd_sc_hs__mux2_1
Xsky130_fd_sc_hs__mux2_1_411 VDD VSS sky130_fd_sc_hs__mux2_1_411/X sky130_fd_sc_hs__buf_16_12/A
+ sky130_fd_sc_hs__nand2_1_220/A sky130_fd_sc_hs__a22o_1_88/B2 VSS VDD sky130_fd_sc_hs__mux2_1
Xsky130_fd_sc_hs__mux2_1_422 VDD VSS sky130_fd_sc_hs__mux2_1_422/X sky130_fd_sc_hs__buf_8_28/A
+ sky130_fd_sc_hs__a22o_1_84/B2 sky130_fd_sc_hs__mux2_1_422/A1 VSS VDD sky130_fd_sc_hs__mux2_1
Xsky130_fd_sc_hs__mux2_1_433 VDD VSS sky130_fd_sc_hs__mux2_1_433/X sky130_fd_sc_hs__buf_16_13/A
+ sky130_fd_sc_hs__nor2_1_183/A sky130_fd_sc_hs__a22o_1_91/B2 VSS VDD sky130_fd_sc_hs__mux2_1
Xsky130_fd_sc_hs__mux2_1_444 VDD VSS sky130_fd_sc_hs__mux2_1_444/X sky130_fd_sc_hs__buf_16_1/X
+ sky130_fd_sc_hs__mux2_1_444/A0 sky130_fd_sc_hs__a22o_1_94/B2 VSS VDD sky130_fd_sc_hs__mux2_1
Xsky130_fd_sc_hs__mux2_1_455 VDD VSS sky130_fd_sc_hs__mux2_1_455/X sky130_fd_sc_hs__buf_16_3/X
+ sky130_fd_sc_hs__a22o_1_92/B2 sky130_fd_sc_hs__mux2_1_455/A1 VSS VDD sky130_fd_sc_hs__mux2_1
Xsky130_fd_sc_hs__mux2_1_466 VDD VSS sky130_fd_sc_hs__mux2_1_466/X sky130_fd_sc_hs__buf_16_0/A
+ sky130_fd_sc_hs__xor2_1_82/B sky130_fd_sc_hs__a22o_1_94/B2 VSS VDD sky130_fd_sc_hs__mux2_1
Xsky130_fd_sc_hs__mux2_1_477 VDD VSS sky130_fd_sc_hs__mux2_1_477/X sky130_fd_sc_hs__o21a_1_29/B1
+ sky130_fd_sc_hs__buf_1_190/A sky130_fd_sc_hs__mux2_1_477/A1 VSS VDD sky130_fd_sc_hs__mux2_1
Xsky130_fd_sc_hs__mux2_1_488 VDD VSS sky130_fd_sc_hs__mux2_1_488/X sky130_fd_sc_hs__buf_16_1/X
+ sky130_fd_sc_hs__mux2_1_488/A0 sky130_fd_sc_hs__a22o_1_64/B2 VSS VDD sky130_fd_sc_hs__mux2_1
Xsky130_fd_sc_hs__buf_4_5 VDD VSS sky130_fd_sc_hs__buf_4_5/A sky130_fd_sc_hs__buf_4_5/X
+ VSS VDD sky130_fd_sc_hs__buf_4
Xsky130_fd_sc_hs__dfrtp_1_270 sky130_fd_sc_hs__buf_8_8/X VDD VSS sky130_fd_sc_hs__xor2_1_35/B
+ sky130_fd_sc_hs__clkinv_1_53/A sky130_fd_sc_hs__mux2_1_191/X VSS VDD sky130_fd_sc_hs__dfrtp_1
Xsky130_fd_sc_hs__dfrtp_1_281 sky130_fd_sc_hs__buf_8_4/A VDD VSS sky130_fd_sc_hs__xnor2_1_42/B
+ sky130_fd_sc_hs__clkbuf_2_70/X sky130_fd_sc_hs__dfrtp_1_281/D VSS VDD sky130_fd_sc_hs__dfrtp_1
Xsky130_fd_sc_hs__dfrtp_1_292 sky130_fd_sc_hs__buf_8_4/A VDD VSS sky130_fd_sc_hs__xor2_1_22/A
+ sky130_fd_sc_hs__clkbuf_2_70/X sky130_fd_sc_hs__dfrtp_1_292/D VSS VDD sky130_fd_sc_hs__dfrtp_1
Xsky130_fd_sc_hs__buf_1_19 VDD VSS sky130_fd_sc_hs__buf_1_19/A srm_residue_o[6] VSS
+ VDD sky130_fd_sc_hs__buf_1
Xsky130_fd_sc_hs__clkbuf_2_0 VDD VSS sky130_fd_sc_hs__clkinv_1_0/A sky130_fd_sc_hs__clkinv_4_0/A
+ VSS VDD sky130_fd_sc_hs__clkbuf_2
Xsky130_fd_sc_hs__a22o_1_11 VDD VSS sky130_fd_sc_hs__nor3_1_7/A sky130_fd_sc_hs__mux2_1_93/A1
+ sky130_fd_sc_hs__buf_16_8/X sky130_fd_sc_hs__nand2_1_33/B sky130_fd_sc_hs__mux2_1_87/A0
+ VSS VDD sky130_fd_sc_hs__a22o_1
Xsky130_fd_sc_hs__clkinv_1_80 VDD VSS sky130_fd_sc_hs__nand2b_1_37/Y sky130_fd_sc_hs__clkinv_1_80/Y
+ VSS VDD sky130_fd_sc_hs__clkinv_1
Xsky130_fd_sc_hs__a22o_1_22 VDD VSS sky130_fd_sc_hs__a22o_1_22/X sky130_fd_sc_hs__xor2_1_0/A
+ sky130_fd_sc_hs__a22o_1_6/B1 sky130_fd_sc_hs__nor2_2_0/Y sky130_fd_sc_hs__buf_1_188/A
+ VSS VDD sky130_fd_sc_hs__a22o_1
Xsky130_fd_sc_hs__clkinv_1_91 VDD VSS sky130_fd_sc_hs__and2_1_30/A sky130_fd_sc_hs__clkinv_1_91/Y
+ VSS VDD sky130_fd_sc_hs__clkinv_1
Xsky130_fd_sc_hs__a22o_1_33 VDD VSS sky130_fd_sc_hs__a22o_1_33/X sky130_fd_sc_hs__xnor2_1_50/Y
+ sky130_fd_sc_hs__nor2_1_45/Y sky130_fd_sc_hs__nor2_1_45/B sky130_fd_sc_hs__nor3_1_2/A
+ VSS VDD sky130_fd_sc_hs__a22o_1
Xsky130_fd_sc_hs__a22o_1_44 VDD VSS sky130_fd_sc_hs__a22o_1_44/X sky130_fd_sc_hs__mux2_1_98/A1
+ sky130_fd_sc_hs__buf_8_17/X sky130_fd_sc_hs__buf_8_15/X sky130_fd_sc_hs__a22o_1_48/B2
+ VSS VDD sky130_fd_sc_hs__a22o_1
Xsky130_fd_sc_hs__clkbuf_2_11 VDD VSS sky130_fd_sc_hs__clkinv_1_4/A sky130_fd_sc_hs__clkinv_4_0/A
+ VSS VDD sky130_fd_sc_hs__clkbuf_2
Xsky130_fd_sc_hs__a22o_1_55 VDD VSS sky130_fd_sc_hs__a22o_1_55/X sky130_fd_sc_hs__a22o_1_55/B2
+ sky130_fd_sc_hs__a22o_1_93/B1 sky130_fd_sc_hs__a22o_1_93/A2 sky130_fd_sc_hs__maj3_1_17/C
+ VSS VDD sky130_fd_sc_hs__a22o_1
Xsky130_fd_sc_hs__clkbuf_2_22 VDD VSS sky130_fd_sc_hs__clkinv_1_9/A sky130_fd_sc_hs__clkbuf_2_92/A
+ VSS VDD sky130_fd_sc_hs__clkbuf_2
Xsky130_fd_sc_hs__a22o_1_66 VDD VSS sky130_fd_sc_hs__a22o_1_66/X sky130_fd_sc_hs__a22o_1_66/B2
+ sky130_fd_sc_hs__a22o_1_93/B1 sky130_fd_sc_hs__a22o_1_93/A2 sky130_fd_sc_hs__maj3_1_27/C
+ VSS VDD sky130_fd_sc_hs__a22o_1
Xsky130_fd_sc_hs__clkbuf_2_33 VDD VSS sky130_fd_sc_hs__clkinv_1_17/A sky130_fd_sc_hs__inv_8_0/A
+ VSS VDD sky130_fd_sc_hs__clkbuf_2
Xsky130_fd_sc_hs__a22o_1_77 VDD VSS sky130_fd_sc_hs__a22o_1_77/X sky130_fd_sc_hs__a22o_1_77/B2
+ sky130_fd_sc_hs__buf_8_16/A sky130_fd_sc_hs__buf_8_18/A sky130_fd_sc_hs__xnor2_1_84/A
+ VSS VDD sky130_fd_sc_hs__a22o_1
Xsky130_fd_sc_hs__a22o_1_88 VDD VSS sky130_fd_sc_hs__a22o_1_88/X sky130_fd_sc_hs__a22o_1_88/B2
+ sky130_fd_sc_hs__buf_8_17/A sky130_fd_sc_hs__buf_8_15/A sky130_fd_sc_hs__a22o_1_88/A1
+ VSS VDD sky130_fd_sc_hs__a22o_1
Xsky130_fd_sc_hs__clkbuf_2_44 VDD VSS sky130_fd_sc_hs__clkinv_1_32/A sky130_fd_sc_hs__clkinv_4_1/A
+ VSS VDD sky130_fd_sc_hs__clkbuf_2
Xsky130_fd_sc_hs__a22o_1_99 VDD VSS sky130_fd_sc_hs__a22o_1_99/X sky130_fd_sc_hs__a22o_1_99/B2
+ sky130_fd_sc_hs__or2_1_19/X sky130_fd_sc_hs__buf_8_13/X sky130_fd_sc_hs__maj3_1_40/C
+ VSS VDD sky130_fd_sc_hs__a22o_1
Xsky130_fd_sc_hs__clkbuf_2_55 VDD VSS sky130_fd_sc_hs__clkbuf_2_55/X sky130_fd_sc_hs__inv_8_0/A
+ VSS VDD sky130_fd_sc_hs__clkbuf_2
Xsky130_fd_sc_hs__clkbuf_2_66 VDD VSS sky130_fd_sc_hs__clkbuf_2_66/X sky130_fd_sc_hs__dfstp_1_0/CLK
+ VSS VDD sky130_fd_sc_hs__clkbuf_2
Xsky130_fd_sc_hs__clkbuf_2_77 VDD VSS sky130_fd_sc_hs__clkinv_1_51/A sky130_fd_sc_hs__clkbuf_2_92/A
+ VSS VDD sky130_fd_sc_hs__clkbuf_2
Xsky130_fd_sc_hs__a21o_1_8 VDD VSS sky130_fd_sc_hs__a21o_1_8/X sky130_fd_sc_hs__a21o_1_8/A1
+ sky130_fd_sc_hs__xor2_1_57/X sky130_fd_sc_hs__a21o_1_4/X VSS VDD sky130_fd_sc_hs__a21o_1
Xsky130_fd_sc_hs__nand4_1_5 VDD VSS sky130_fd_sc_hs__nand4_1_5/C sky130_fd_sc_hs__nand4_1_5/Y
+ sky130_fd_sc_hs__nand4_1_5/D sky130_fd_sc_hs__buf_4_2/X sky130_fd_sc_hs__nand4_1_5/A
+ VSS VDD sky130_fd_sc_hs__nand4_1
Xsky130_fd_sc_hs__clkbuf_2_88 VDD VSS sky130_fd_sc_hs__clkinv_1_59/A sky130_fd_sc_hs__clkinv_4_3/A
+ VSS VDD sky130_fd_sc_hs__clkbuf_2
Xsky130_fd_sc_hs__clkbuf_2_99 VDD VSS sky130_fd_sc_hs__clkinv_1_70/A sky130_fd_sc_hs__clkinv_4_3/A
+ VSS VDD sky130_fd_sc_hs__clkbuf_2
Xsky130_fd_sc_hs__maj3_1_17 VDD VSS sky130_fd_sc_hs__xor2_1_29/A sky130_fd_sc_hs__xor2_1_29/B
+ sky130_fd_sc_hs__xor2_1_31/A sky130_fd_sc_hs__maj3_1_17/C VSS VDD sky130_fd_sc_hs__maj3_1
Xsky130_fd_sc_hs__maj3_1_28 VDD VSS sky130_fd_sc_hs__or2_1_15/A sky130_fd_sc_hs__or2_1_15/B
+ sky130_fd_sc_hs__xor2_1_48/A sky130_fd_sc_hs__xor2_1_52/B VSS VDD sky130_fd_sc_hs__maj3_1
Xsky130_fd_sc_hs__maj3_1_39 VDD VSS sky130_fd_sc_hs__xor2_1_68/A sky130_fd_sc_hs__xor2_1_68/B
+ sky130_fd_sc_hs__maj3_1_39/X sky130_fd_sc_hs__maj3_1_39/C VSS VDD sky130_fd_sc_hs__maj3_1
Xsky130_fd_sc_hs__clkinv_2_0 VDD VSS sky130_fd_sc_hs__clkinv_2_0/Y sky130_fd_sc_hs__clkinv_2_0/A
+ VSS VDD sky130_fd_sc_hs__clkinv_2
Xsky130_fd_sc_hs__mux2_1_230 VDD VSS sky130_fd_sc_hs__mux2_1_230/X sky130_fd_sc_hs__mux2_1_370/S
+ sky130_fd_sc_hs__xor2_1_54/B sky130_fd_sc_hs__mux2_1_477/A1 VSS VDD sky130_fd_sc_hs__mux2_1
Xsky130_fd_sc_hs__nand2_1_11 VDD VSS sky130_fd_sc_hs__o21a_1_0/A1 sky130_fd_sc_hs__nand2_1_11/Y
+ sky130_fd_sc_hs__nor2_1_7/A VSS VDD sky130_fd_sc_hs__nand2_1
Xsky130_fd_sc_hs__nand2_1_22 VDD VSS sky130_fd_sc_hs__nand3b_1_0/C sky130_fd_sc_hs__xnor2_1_10/A
+ sky130_fd_sc_hs__nand2_1_54/Y VSS VDD sky130_fd_sc_hs__nand2_1
Xsky130_fd_sc_hs__mux2_1_241 VDD VSS sky130_fd_sc_hs__mux2_1_241/X sky130_fd_sc_hs__mux2_1_397/S
+ sky130_fd_sc_hs__xor2_1_65/A sky130_fd_sc_hs__mux2_1_355/A1 VSS VDD sky130_fd_sc_hs__mux2_1
Xsky130_fd_sc_hs__nand2_1_33 VDD VSS sky130_fd_sc_hs__nand2_1_33/B sky130_fd_sc_hs__nand2_1_33/Y
+ sky130_fd_sc_hs__nand2_1_33/A VSS VDD sky130_fd_sc_hs__nand2_1
Xsky130_fd_sc_hs__mux2_1_252 VDD VSS sky130_fd_sc_hs__mux2_1_252/X sky130_fd_sc_hs__o21a_1_29/B1
+ sky130_fd_sc_hs__buf_1_134/A sky130_fd_sc_hs__nor3_1_48/A VSS VDD sky130_fd_sc_hs__mux2_1
Xsky130_fd_sc_hs__nand2_1_44 VDD VSS sky130_fd_sc_hs__o21ai_1_16/Y sky130_fd_sc_hs__nand2_1_44/Y
+ sky130_fd_sc_hs__nand2_1_44/A VSS VDD sky130_fd_sc_hs__nand2_1
Xsky130_fd_sc_hs__mux2_1_263 VDD VSS sky130_fd_sc_hs__mux2_1_263/X sky130_fd_sc_hs__buf_8_24/X
+ sky130_fd_sc_hs__a22o_1_62/B2 sky130_fd_sc_hs__mux2_1_263/A1 VSS VDD sky130_fd_sc_hs__mux2_1
Xsky130_fd_sc_hs__nand2_1_55 VDD VSS sky130_fd_sc_hs__o32a_1_0/A3 sky130_fd_sc_hs__nor3_1_13/C
+ sky130_fd_sc_hs__and3_1_5/C VSS VDD sky130_fd_sc_hs__nand2_1
Xsky130_fd_sc_hs__mux2_1_274 VDD VSS sky130_fd_sc_hs__mux2_1_274/X sky130_fd_sc_hs__mux2_1_7/S
+ sky130_fd_sc_hs__mux2_1_274/A0 sky130_fd_sc_hs__a22o_1_95/B2 VSS VDD sky130_fd_sc_hs__mux2_1
Xsky130_fd_sc_hs__nand2_1_66 VDD VSS sky130_fd_sc_hs__a32o_1_4/B1 sky130_fd_sc_hs__o31ai_1_6/B1
+ sky130_fd_sc_hs__and3_1_8/C VSS VDD sky130_fd_sc_hs__nand2_1
Xsky130_fd_sc_hs__mux2_1_285 VDD VSS sky130_fd_sc_hs__mux2_1_285/X sky130_fd_sc_hs__o31ai_2_0/B1
+ sky130_fd_sc_hs__buf_1_165/A sky130_fd_sc_hs__mux2_1_473/A1 VSS VDD sky130_fd_sc_hs__mux2_1
Xsky130_fd_sc_hs__nand2_1_77 VDD VSS sky130_fd_sc_hs__a21o_1_3/X sky130_fd_sc_hs__nand2_1_77/Y
+ sky130_fd_sc_hs__a31o_1_7/A1 VSS VDD sky130_fd_sc_hs__nand2_1
Xsky130_fd_sc_hs__mux2_1_296 VDD VSS sky130_fd_sc_hs__mux2_1_296/X sky130_fd_sc_hs__buf_8_22/X
+ sky130_fd_sc_hs__mux2_1_296/A0 sky130_fd_sc_hs__a22o_1_61/B2 VSS VDD sky130_fd_sc_hs__mux2_1
Xsky130_fd_sc_hs__nand2_1_88 VDD VSS sky130_fd_sc_hs__xor2_1_35/A sky130_fd_sc_hs__nand2_1_88/Y
+ sky130_fd_sc_hs__and2_1_6/A VSS VDD sky130_fd_sc_hs__nand2_1
Xsky130_fd_sc_hs__a222oi_1_18 VDD VSS sky130_fd_sc_hs__nor3b_1_2/Y sky130_fd_sc_hs__nor2_1_179/Y
+ sky130_fd_sc_hs__nand2_1_198/B sky130_fd_sc_hs__clkbuf_8_14/X sky130_fd_sc_hs__mux2_1_322/A1
+ sky130_fd_sc_hs__nand2_1_199/A sky130_fd_sc_hs__mux2_1_327/A1 VSS VDD sky130_fd_sc_hs__a222oi_1
Xsky130_fd_sc_hs__nand2_1_99 VDD VSS sky130_fd_sc_hs__nand2_1_99/B sky130_fd_sc_hs__xnor2_1_83/A
+ sky130_fd_sc_hs__nand2_1_99/A VSS VDD sky130_fd_sc_hs__nand2_1
Xsky130_fd_sc_hs__a22oi_1_109 VDD VSS sky130_fd_sc_hs__mux2_1_444/A0 sky130_fd_sc_hs__nand2_1_225/A
+ sky130_fd_sc_hs__buf_16_7/X sky130_fd_sc_hs__a22o_1_9/A2 sky130_fd_sc_hs__mux2_1_443/A1
+ VSS VDD sky130_fd_sc_hs__a22oi_1
Xsky130_fd_sc_hs__dlygate4sd3_1_12 VSS VDD raw_bits_i[6] sky130_fd_sc_hs__buf_1_73/A
+ VSS VDD sky130_fd_sc_hs__dlygate4sd3_1
Xsky130_fd_sc_hs__dlygate4sd3_1_23 VSS VDD raw_bits_i[1] sky130_fd_sc_hs__buf_1_75/A
+ VSS VDD sky130_fd_sc_hs__dlygate4sd3_1
Xsky130_fd_sc_hs__o21ai_1_12 VDD VSS sky130_fd_sc_hs__nor2_1_25/B sky130_fd_sc_hs__nand2_1_35/Y
+ sky130_fd_sc_hs__nor2_1_26/Y sky130_fd_sc_hs__a31oi_1_1/Y VSS VDD sky130_fd_sc_hs__o21ai_1
Xsky130_fd_sc_hs__o21ai_1_23 VDD VSS sky130_fd_sc_hs__o21ai_1_23/Y sky130_fd_sc_hs__a21oi_1_42/Y
+ sky130_fd_sc_hs__maj3_1_10/C sky130_fd_sc_hs__xor2_1_16/X VSS VDD sky130_fd_sc_hs__o21ai_1
Xsky130_fd_sc_hs__o21ai_1_34 VDD VSS sky130_fd_sc_hs__o21ai_1_34/Y sky130_fd_sc_hs__nand2_1_67/Y
+ sky130_fd_sc_hs__o31ai_1_6/A1 sky130_fd_sc_hs__and3_1_8/A VSS VDD sky130_fd_sc_hs__o21ai_1
Xsky130_fd_sc_hs__o21ai_1_45 VDD VSS sky130_fd_sc_hs__o21ai_1_45/Y sky130_fd_sc_hs__buf_8_2/X
+ sky130_fd_sc_hs__buf_8_10/A sky130_fd_sc_hs__or2_1_15/A VSS VDD sky130_fd_sc_hs__o21ai_1
Xsky130_fd_sc_hs__o21ai_1_56 VDD VSS sky130_fd_sc_hs__maj3_1_42/A sky130_fd_sc_hs__o21ai_1_56/B1
+ sky130_fd_sc_hs__or2_1_20/B sky130_fd_sc_hs__or2_1_20/A VSS VDD sky130_fd_sc_hs__o21ai_1
Xsky130_fd_sc_hs__o21ai_1_67 VDD VSS sky130_fd_sc_hs__o21ai_1_67/Y sky130_fd_sc_hs__o311ai_1_19/Y
+ sky130_fd_sc_hs__buf_16_2/X sky130_fd_sc_hs__o41ai_1_3/A2 VSS VDD sky130_fd_sc_hs__o21ai_1
Xsky130_fd_sc_hs__o21ai_1_78 VDD VSS sky130_fd_sc_hs__o21ai_1_78/Y sky130_fd_sc_hs__buf_1_136/A
+ sky130_fd_sc_hs__nor2_1_159/Y sky130_fd_sc_hs__o31a_1_4/X VSS VDD sky130_fd_sc_hs__o21ai_1
Xsky130_fd_sc_hs__o21ai_1_89 VDD VSS sky130_fd_sc_hs__o21ai_1_89/Y sky130_fd_sc_hs__o31a_1_7/A1
+ sky130_fd_sc_hs__or3_1_7/A sky130_fd_sc_hs__o31a_1_7/A2 VSS VDD sky130_fd_sc_hs__o21ai_1
Xsky130_fd_sc_hs__clkbuf_8_10 VDD VSS sky130_fd_sc_hs__mux2_1_370/S sky130_fd_sc_hs__nor3_4_1/Y
+ VSS VDD sky130_fd_sc_hs__clkbuf_8
Xsky130_fd_sc_hs__o211ai_1_12 VDD VSS sky130_fd_sc_hs__o31a_1_5/B1 sky130_fd_sc_hs__o21ai_1_83/B1
+ sky130_fd_sc_hs__buf_1_143/A sky130_fd_sc_hs__nor2_2_8/B sky130_fd_sc_hs__or3_1_1/X
+ VSS VDD sky130_fd_sc_hs__o211ai_1
Xsky130_fd_sc_hs__buf_16_8 sky130_fd_sc_hs__buf_16_8/X VDD VSS sky130_fd_sc_hs__buf_16_8/A
+ VSS VDD sky130_fd_sc_hs__buf_16
Xsky130_fd_sc_hs__and4_1_0 VDD VSS sky130_fd_sc_hs__and4_1_0/A sky130_fd_sc_hs__and4_1_0/B
+ sky130_fd_sc_hs__and4_1_0/C sky130_fd_sc_hs__and4_1_0/D sky130_fd_sc_hs__and4_1_0/X
+ VSS VDD sky130_fd_sc_hs__and4_1
Xsky130_fd_sc_hs__nor2_4_2 VDD VSS sky130_fd_sc_hs__nor2_4_2/Y sky130_fd_sc_hs__nor2_4_2/A
+ sky130_fd_sc_hs__nor2_4_2/B VSS VDD sky130_fd_sc_hs__nor2_4
Xsky130_fd_sc_hs__dfrtp_1_803 sky130_fd_sc_hs__clkbuf_4_23/A VDD VSS sky130_fd_sc_hs__xor2_1_54/B
+ sky130_fd_sc_hs__clkbuf_2_239/X sky130_fd_sc_hs__mux2_1_230/X VSS VDD sky130_fd_sc_hs__dfrtp_1
Xsky130_fd_sc_hs__dfrtp_1_814 sky130_fd_sc_hs__clkbuf_4_1/X VDD VSS sky130_fd_sc_hs__mux2_1_480/A0
+ sky130_fd_sc_hs__clkinv_1_19/A sky130_fd_sc_hs__mux2_1_480/X VSS VDD sky130_fd_sc_hs__dfrtp_1
Xsky130_fd_sc_hs__dfrtp_1_825 sky130_fd_sc_hs__buf_8_9/X VDD VSS sky130_fd_sc_hs__xor2_1_56/A
+ sky130_fd_sc_hs__clkbuf_2_241/X sky130_fd_sc_hs__mux2_1_228/X VSS VDD sky130_fd_sc_hs__dfrtp_1
Xsky130_fd_sc_hs__a21oi_1_100 VDD VSS sky130_fd_sc_hs__nor2_1_81/Y sky130_fd_sc_hs__xnor2_1_84/B
+ sky130_fd_sc_hs__nand2_1_85/A sky130_fd_sc_hs__xnor2_1_85/A VSS VDD sky130_fd_sc_hs__a21oi_1
Xsky130_fd_sc_hs__a21oi_1_111 VDD VSS sky130_fd_sc_hs__and2_1_29/X sky130_fd_sc_hs__nand4b_1_0/D
+ sky130_fd_sc_hs__nor2_2_2/Y sky130_fd_sc_hs__nor2_1_97/A VSS VDD sky130_fd_sc_hs__a21oi_1
Xsky130_fd_sc_hs__a21oi_1_122 VDD VSS sky130_fd_sc_hs__a31oi_1_9/Y sky130_fd_sc_hs__dfrtp_1_521/D
+ sky130_fd_sc_hs__nor2_1_107/Y sky130_fd_sc_hs__and4_1_5/C VSS VDD sky130_fd_sc_hs__a21oi_1
Xsky130_fd_sc_hs__a21oi_1_133 VDD VSS sky130_fd_sc_hs__nor2_1_114/Y sky130_fd_sc_hs__dfrtp_1_471/D
+ sky130_fd_sc_hs__buf_8_11/A sky130_fd_sc_hs__o21ai_1_103/Y VSS VDD sky130_fd_sc_hs__a21oi_1
Xsky130_fd_sc_hs__a21oi_1_144 VDD VSS sky130_fd_sc_hs__o21bai_1_4/Y sky130_fd_sc_hs__nor2_1_155/B
+ sky130_fd_sc_hs__or2_1_21/X sky130_fd_sc_hs__nor2_1_149/A VSS VDD sky130_fd_sc_hs__a21oi_1
Xsky130_fd_sc_hs__a21oi_1_155 VDD VSS sky130_fd_sc_hs__or2_1_22/B sky130_fd_sc_hs__a21oi_1_155/Y
+ sky130_fd_sc_hs__or3_1_4/X sky130_fd_sc_hs__nor3_1_36/A VSS VDD sky130_fd_sc_hs__a21oi_1
Xsky130_fd_sc_hs__a21oi_1_166 VDD VSS sky130_fd_sc_hs__nor3_1_41/B sky130_fd_sc_hs__a22oi_1_67/A2
+ sky130_fd_sc_hs__nor3_1_32/B sky130_fd_sc_hs__nor2_1_149/A VSS VDD sky130_fd_sc_hs__a21oi_1
Xsky130_fd_sc_hs__a21oi_1_177 VDD VSS sky130_fd_sc_hs__nand2_1_230/Y sky130_fd_sc_hs__nand3_1_46/B
+ sky130_fd_sc_hs__buf_8_33/X sky130_fd_sc_hs__mux2_1_283/A0 VSS VDD sky130_fd_sc_hs__a21oi_1
Xsky130_fd_sc_hs__a21oi_1_188 VDD VSS sky130_fd_sc_hs__xor2_1_81/X sky130_fd_sc_hs__o31ai_1_19/A2
+ sky130_fd_sc_hs__and3_1_14/C sky130_fd_sc_hs__and3_1_14/A VSS VDD sky130_fd_sc_hs__a21oi_1
Xsky130_fd_sc_hs__a21oi_1_199 VDD VSS sky130_fd_sc_hs__o21ai_1_101/Y sky130_fd_sc_hs__a21oi_1_199/Y
+ sky130_fd_sc_hs__xnor2_1_142/Y sky130_fd_sc_hs__buf_8_36/X VSS VDD sky130_fd_sc_hs__a21oi_1
Xsky130_fd_sc_hs__clkbuf_2_160 VDD VSS sky130_fd_sc_hs__clkinv_1_111/A sky130_fd_sc_hs__clkbuf_2_176/A
+ VSS VDD sky130_fd_sc_hs__clkbuf_2
Xsky130_fd_sc_hs__clkbuf_2_171 VDD VSS sky130_fd_sc_hs__clkbuf_2_171/X sky130_fd_sc_hs__clkbuf_2_176/A
+ VSS VDD sky130_fd_sc_hs__clkbuf_2
Xsky130_fd_sc_hs__clkbuf_2_182 VDD VSS sky130_fd_sc_hs__clkinv_1_132/A sky130_fd_sc_hs__clkbuf_2_236/A
+ VSS VDD sky130_fd_sc_hs__clkbuf_2
Xsky130_fd_sc_hs__nand2_1_160 VDD VSS sky130_fd_sc_hs__nand2_1_160/B sky130_fd_sc_hs__nand2_1_160/Y
+ sky130_fd_sc_hs__mux2i_1_9/A1 VSS VDD sky130_fd_sc_hs__nand2_1
Xsky130_fd_sc_hs__clkbuf_2_193 VDD VSS sky130_fd_sc_hs__clkbuf_2_193/X sky130_fd_sc_hs__clkinv_4_6/A
+ VSS VDD sky130_fd_sc_hs__clkbuf_2
Xsky130_fd_sc_hs__nand2_1_171 VDD VSS sky130_fd_sc_hs__nor2_1_101/Y sky130_fd_sc_hs__and2_1_34/B
+ sky130_fd_sc_hs__nor2b_1_41/Y VSS VDD sky130_fd_sc_hs__nand2_1
Xsky130_fd_sc_hs__nand2_1_182 VDD VSS sky130_fd_sc_hs__nor2b_1_45/Y sky130_fd_sc_hs__o21ai_1_84/A2
+ sky130_fd_sc_hs__xor2_1_79/B VSS VDD sky130_fd_sc_hs__nand2_1
Xsky130_fd_sc_hs__nand2_1_193 VDD VSS sky130_fd_sc_hs__xor2_1_79/X sky130_fd_sc_hs__or3_1_6/C
+ sky130_fd_sc_hs__o31ai_2_0/A1 VSS VDD sky130_fd_sc_hs__nand2_1
Xsky130_fd_sc_hs__nor3_1_19 VDD VSS sky130_fd_sc_hs__nor3_1_19/Y sky130_fd_sc_hs__nor3_1_19/C
+ sky130_fd_sc_hs__and3_1_9/X sky130_fd_sc_hs__o32a_1_0/A2 VSS VDD sky130_fd_sc_hs__nor3_1
Xsky130_fd_sc_hs__clkinv_1_105 VDD VSS sky130_fd_sc_hs__dfrtp_1_500/Q sky130_fd_sc_hs__o22ai_1_9/A1
+ VSS VDD sky130_fd_sc_hs__clkinv_1
Xsky130_fd_sc_hs__clkinv_1_116 VDD VSS sky130_fd_sc_hs__clkinv_1_116/A sky130_fd_sc_hs__clkinv_1_116/Y
+ VSS VDD sky130_fd_sc_hs__clkinv_1
Xsky130_fd_sc_hs__clkinv_1_127 VDD VSS sky130_fd_sc_hs__clkinv_1_127/A sky130_fd_sc_hs__clkinv_1_127/Y
+ VSS VDD sky130_fd_sc_hs__clkinv_1
Xsky130_fd_sc_hs__clkinv_1_138 VDD VSS sky130_fd_sc_hs__maj3_1_51/X sky130_fd_sc_hs__nor2_1_99/A
+ VSS VDD sky130_fd_sc_hs__clkinv_1
Xsky130_fd_sc_hs__clkinv_1_149 VDD VSS sky130_fd_sc_hs__xnor2_1_139/Y sky130_fd_sc_hs__maj3_1_53/C
+ VSS VDD sky130_fd_sc_hs__clkinv_1
Xsky130_fd_sc_hs__dfrtp_1_600 sky130_fd_sc_hs__clkbuf_4_30/X VDD VSS sky130_fd_sc_hs__mux2_1_303/A0
+ sky130_fd_sc_hs__clkinv_1_131/A sky130_fd_sc_hs__mux2_1_303/X VSS VDD sky130_fd_sc_hs__dfrtp_1
Xsky130_fd_sc_hs__dfrtp_1_611 sky130_fd_sc_hs__clkbuf_4_31/X VDD VSS sky130_fd_sc_hs__xor2_1_53/A
+ sky130_fd_sc_hs__clkbuf_2_239/X sky130_fd_sc_hs__a22o_1_120/X VSS VDD sky130_fd_sc_hs__dfrtp_1
Xsky130_fd_sc_hs__dfrtp_1_622 sky130_fd_sc_hs__clkbuf_4_31/X VDD VSS sky130_fd_sc_hs__mux2_1_326/A1
+ sky130_fd_sc_hs__clkbuf_2_193/X sky130_fd_sc_hs__mux2_1_326/X VSS VDD sky130_fd_sc_hs__dfrtp_1
Xsky130_fd_sc_hs__dfrtp_1_633 sky130_fd_sc_hs__clkbuf_4_30/X VDD VSS sky130_fd_sc_hs__mux2_1_340/A1
+ sky130_fd_sc_hs__clkinv_1_143/A sky130_fd_sc_hs__mux2_1_340/X VSS VDD sky130_fd_sc_hs__dfrtp_1
Xsky130_fd_sc_hs__dfrtp_1_644 sky130_fd_sc_hs__clkbuf_4_31/X VDD VSS sky130_fd_sc_hs__mux2_1_325/A0
+ sky130_fd_sc_hs__clkbuf_2_189/X sky130_fd_sc_hs__mux2_1_325/X VSS VDD sky130_fd_sc_hs__dfrtp_1
Xsky130_fd_sc_hs__dfrtp_1_655 sky130_fd_sc_hs__clkbuf_4_33/X VDD VSS sky130_fd_sc_hs__mux2_1_356/A0
+ sky130_fd_sc_hs__clkbuf_2_200/X sky130_fd_sc_hs__mux2_1_356/X VSS VDD sky130_fd_sc_hs__dfrtp_1
Xsky130_fd_sc_hs__dfrtp_1_666 sky130_fd_sc_hs__clkbuf_4_35/X VDD VSS sky130_fd_sc_hs__or2_1_29/A
+ sky130_fd_sc_hs__dfrtp_2_4/CLK sky130_fd_sc_hs__mux2_1_485/X VSS VDD sky130_fd_sc_hs__dfrtp_1
Xsky130_fd_sc_hs__nor2_1_108 VDD VSS sky130_fd_sc_hs__or3_1_2/A sky130_fd_sc_hs__nor2_1_108/Y
+ sky130_fd_sc_hs__nor2b_1_29/Y VSS VDD sky130_fd_sc_hs__nor2_1
Xsky130_fd_sc_hs__dfrtp_1_677 sky130_fd_sc_hs__clkbuf_4_35/X VDD VSS sky130_fd_sc_hs__a222o_1_6/B2
+ sky130_fd_sc_hs__clkbuf_2_210/X sky130_fd_sc_hs__mux2_1_383/X VSS VDD sky130_fd_sc_hs__dfrtp_1
Xsky130_fd_sc_hs__nor2_1_119 VDD VSS sky130_fd_sc_hs__nor2_1_98/B sky130_fd_sc_hs__nor2_1_119/Y
+ sky130_fd_sc_hs__nor2_1_94/A VSS VDD sky130_fd_sc_hs__nor2_1
Xsky130_fd_sc_hs__dfrtp_1_688 sky130_fd_sc_hs__clkbuf_4_33/X VDD VSS sky130_fd_sc_hs__mux2_1_394/A1
+ sky130_fd_sc_hs__clkbuf_2_214/X sky130_fd_sc_hs__mux2_1_394/X VSS VDD sky130_fd_sc_hs__dfrtp_1
Xsky130_fd_sc_hs__dfrtp_1_7 sky130_fd_sc_hs__clkbuf_4_4/X VDD VSS sky130_fd_sc_hs__dfrtp_1_7/Q
+ sky130_fd_sc_hs__clkbuf_2_1/X sky130_fd_sc_hs__mux2_1_10/X VSS VDD sky130_fd_sc_hs__dfrtp_1
Xsky130_fd_sc_hs__dfrtp_1_699 sky130_fd_sc_hs__buf_8_29/X VDD VSS sky130_fd_sc_hs__mux2_1_286/A0
+ sky130_fd_sc_hs__clkbuf_2_215/X sky130_fd_sc_hs__mux2_1_286/X VSS VDD sky130_fd_sc_hs__dfrtp_1
Xsky130_fd_sc_hs__a22oi_1_17 VDD VSS sky130_fd_sc_hs__mux2_1_52/A0 sky130_fd_sc_hs__and4_1_1/D
+ sky130_fd_sc_hs__a22oi_1_7/B1 sky130_fd_sc_hs__a22o_1_8/A2 sky130_fd_sc_hs__mux2_1_45/A0
+ VSS VDD sky130_fd_sc_hs__a22oi_1
Xsky130_fd_sc_hs__a22oi_1_28 VDD VSS sky130_fd_sc_hs__mux2_1_76/A0 sky130_fd_sc_hs__nand2_1_13/B
+ sky130_fd_sc_hs__a22oi_1_7/B1 sky130_fd_sc_hs__a22oi_1_5/A2 sky130_fd_sc_hs__mux2_1_74/A0
+ VSS VDD sky130_fd_sc_hs__a22oi_1
Xsky130_fd_sc_hs__a22oi_1_39 VDD VSS sky130_fd_sc_hs__xnor2_1_27/A sky130_fd_sc_hs__nand3_1_4/C
+ sky130_fd_sc_hs__a22oi_1_6/B1 sky130_fd_sc_hs__a22o_1_8/B1 sky130_fd_sc_hs__xor2_1_9/B
+ VSS VDD sky130_fd_sc_hs__a22oi_1
Xsky130_fd_sc_hs__nor2_1_30 VDD VSS sky130_fd_sc_hs__and2_1_9/B sky130_fd_sc_hs__nor2_1_30/Y
+ sky130_fd_sc_hs__and2_1_9/A VSS VDD sky130_fd_sc_hs__nor2_1
Xsky130_fd_sc_hs__nor2_1_41 VDD VSS sky130_fd_sc_hs__nor2_1_41/B sky130_fd_sc_hs__nor2_2_1/B
+ sky130_fd_sc_hs__nor2_1_41/A VSS VDD sky130_fd_sc_hs__nor2_1
Xsky130_fd_sc_hs__nor2_1_52 VDD VSS sky130_fd_sc_hs__and3_1_9/X sky130_fd_sc_hs__nor3_1_16/C
+ sky130_fd_sc_hs__nor2_1_52/A VSS VDD sky130_fd_sc_hs__nor2_1
Xsky130_fd_sc_hs__nor2_1_63 VDD VSS sky130_fd_sc_hs__nor2_1_63/B sky130_fd_sc_hs__nor2_1_63/Y
+ sky130_fd_sc_hs__buf_8_19/X VSS VDD sky130_fd_sc_hs__nor2_1
Xsky130_fd_sc_hs__nor2_1_74 VDD VSS sky130_fd_sc_hs__nor2_1_74/B sky130_fd_sc_hs__xor2_1_55/B
+ sky130_fd_sc_hs__nor2_1_74/A VSS VDD sky130_fd_sc_hs__nor2_1
Xsky130_fd_sc_hs__nor2_1_85 VDD VSS sky130_fd_sc_hs__buf_8_21/A sky130_fd_sc_hs__nor2_1_85/Y
+ sky130_fd_sc_hs__xor2_1_62/A VSS VDD sky130_fd_sc_hs__nor2_1
Xsky130_fd_sc_hs__nor2_1_96 VDD VSS sky130_fd_sc_hs__nor3_1_24/C sky130_fd_sc_hs__or3_1_1/B
+ sky130_fd_sc_hs__nor2_4_0/B VSS VDD sky130_fd_sc_hs__nor2_1
Xsky130_fd_sc_hs__xnor2_1_130 VDD VSS sky130_fd_sc_hs__maj3_1_66/X sky130_fd_sc_hs__xnor2_1_142/B
+ sky130_fd_sc_hs__xnor2_1_133/Y VSS VDD sky130_fd_sc_hs__xnor2_1
Xsky130_fd_sc_hs__xnor2_1_141 VDD VSS sky130_fd_sc_hs__maj3_1_64/A sky130_fd_sc_hs__xnor2_1_141/Y
+ sky130_fd_sc_hs__xnor2_1_143/Y VSS VDD sky130_fd_sc_hs__xnor2_1
Xsky130_fd_sc_hs__mux2_1_70 VDD VSS sky130_fd_sc_hs__mux2_1_70/X sky130_fd_sc_hs__buf_16_2/X
+ sky130_fd_sc_hs__mux2_1_94/A1 sky130_fd_sc_hs__mux2_1_70/A1 VSS VDD sky130_fd_sc_hs__mux2_1
Xsky130_fd_sc_hs__mux2_1_81 VDD VSS sky130_fd_sc_hs__mux2_1_81/X sky130_fd_sc_hs__buf_16_2/X
+ sky130_fd_sc_hs__mux2_1_99/A0 sky130_fd_sc_hs__mux2_1_81/A1 VSS VDD sky130_fd_sc_hs__mux2_1
Xsky130_fd_sc_hs__mux2_1_92 VDD VSS sky130_fd_sc_hs__mux2_1_92/X sky130_fd_sc_hs__buf_16_0/X
+ sky130_fd_sc_hs__maj3_1_2/C sky130_fd_sc_hs__mux2_1_94/A1 VSS VDD sky130_fd_sc_hs__mux2_1
Xsky130_fd_sc_hs__xnor2_1_5 VDD VSS sky130_fd_sc_hs__xnor2_1_5/A sky130_fd_sc_hs__nor3_1_2/C
+ sky130_fd_sc_hs__nor2_1_5/Y VSS VDD sky130_fd_sc_hs__xnor2_1
Xsky130_fd_sc_hs__nor2b_1_30 VDD VSS sky130_fd_sc_hs__nor2b_1_29/A sky130_fd_sc_hs__or3_1_2/A
+ sky130_fd_sc_hs__maj3_1_40/X VSS VDD sky130_fd_sc_hs__nor2b_1
Xsky130_fd_sc_hs__nor2b_1_41 VDD VSS sky130_fd_sc_hs__nor3_1_26/A sky130_fd_sc_hs__nor2b_1_41/Y
+ sky130_fd_sc_hs__nor3_1_26/B VSS VDD sky130_fd_sc_hs__nor2b_1
Xsky130_fd_sc_hs__nor2b_1_52 VDD VSS sky130_fd_sc_hs__xnor2_1_11/Y sky130_fd_sc_hs__or2_1_6/A
+ sky130_fd_sc_hs__maj3_1_20/X VSS VDD sky130_fd_sc_hs__nor2b_1
Xsky130_fd_sc_hs__o22ai_1_0 VDD VSS sky130_fd_sc_hs__and2_1_29/B sky130_fd_sc_hs__nand2_2_2/B
+ sky130_fd_sc_hs__o22ai_1_0/Y sky130_fd_sc_hs__nor2_1_92/B sky130_fd_sc_hs__nor3_1_26/A
+ VSS VDD sky130_fd_sc_hs__o22ai_1
Xsky130_fd_sc_hs__or2_1_4 VDD VSS sky130_fd_sc_hs__or2_1_5/X sky130_fd_sc_hs__or2_1_4/A
+ sky130_fd_sc_hs__or2_1_4/X VSS VDD sky130_fd_sc_hs__or2_1
Xsky130_fd_sc_hs__dfrtp_1_430 sky130_fd_sc_hs__clkbuf_4_19/X VDD VSS sky130_fd_sc_hs__a22o_1_93/B2
+ sky130_fd_sc_hs__clkinv_1_85/A sky130_fd_sc_hs__a22o_1_93/X VSS VDD sky130_fd_sc_hs__dfrtp_1
Xsky130_fd_sc_hs__dfrtp_1_441 sky130_fd_sc_hs__clkbuf_4_16/X VDD VSS sky130_fd_sc_hs__a22o_1_82/B2
+ sky130_fd_sc_hs__dfrtp_2_3/CLK sky130_fd_sc_hs__a22o_1_82/X VSS VDD sky130_fd_sc_hs__dfrtp_1
Xsky130_fd_sc_hs__dfrtp_1_452 sky130_fd_sc_hs__clkbuf_4_22/X VDD VSS sky130_fd_sc_hs__buf_1_167/A
+ sky130_fd_sc_hs__clkinv_1_92/A sky130_fd_sc_hs__buf_1_185/X VSS VDD sky130_fd_sc_hs__dfrtp_1
Xsky130_fd_sc_hs__dfrtp_1_463 sky130_fd_sc_hs__clkbuf_4_22/X VDD VSS sky130_fd_sc_hs__and4_1_5/A
+ sky130_fd_sc_hs__clkinv_1_95/A sky130_fd_sc_hs__o21ai_1_53/Y VSS VDD sky130_fd_sc_hs__dfrtp_1
Xsky130_fd_sc_hs__dfrtp_1_474 sky130_fd_sc_hs__clkbuf_4_22/A VDD VSS sky130_fd_sc_hs__xor2_1_74/A
+ sky130_fd_sc_hs__clkbuf_2_143/X sky130_fd_sc_hs__dfrtp_1_474/D VSS VDD sky130_fd_sc_hs__dfrtp_1
Xsky130_fd_sc_hs__dfrtp_1_485 sky130_fd_sc_hs__clkbuf_4_23/X VDD VSS sky130_fd_sc_hs__nor3_1_37/C
+ sky130_fd_sc_hs__clkinv_1_103/A sky130_fd_sc_hs__o21a_1_26/X VSS VDD sky130_fd_sc_hs__dfrtp_1
Xsky130_fd_sc_hs__dfrtp_1_496 sky130_fd_sc_hs__clkbuf_4_23/X VDD VSS sky130_fd_sc_hs__nor2_1_152/A
+ sky130_fd_sc_hs__clkinv_1_106/A sky130_fd_sc_hs__dfrtp_1_496/D VSS VDD sky130_fd_sc_hs__dfrtp_1
Xsky130_fd_sc_hs__clkbuf_4_4 VDD VSS sky130_fd_sc_hs__clkbuf_4_4/A sky130_fd_sc_hs__clkbuf_4_4/X
+ VSS VDD sky130_fd_sc_hs__clkbuf_4
Xsky130_fd_sc_hs__clkinv_4_4 VDD VSS sky130_fd_sc_hs__clkinv_4_4/Y sky130_fd_sc_hs__clkinv_4_4/A
+ VSS VDD sky130_fd_sc_hs__clkinv_4
Xsky130_fd_sc_hs__mux2_1_401 VDD VSS sky130_fd_sc_hs__mux2_1_401/X sky130_fd_sc_hs__buf_16_2/A
+ sky130_fd_sc_hs__dfrtp_2_2/Q sky130_fd_sc_hs__mux2_1_401/A1 VSS VDD sky130_fd_sc_hs__mux2_1
Xsky130_fd_sc_hs__mux2_1_412 VDD VSS sky130_fd_sc_hs__mux2_1_412/X sky130_fd_sc_hs__mux2_1_4/S
+ sky130_fd_sc_hs__a22o_1_88/B2 sky130_fd_sc_hs__mux2_1_412/A1 VSS VDD sky130_fd_sc_hs__mux2_1
Xsky130_fd_sc_hs__mux2_1_423 VDD VSS sky130_fd_sc_hs__mux2_1_423/X sky130_fd_sc_hs__buf_16_14/A
+ sky130_fd_sc_hs__mux2_1_423/A0 sky130_fd_sc_hs__dfrtp_2_3/Q VSS VDD sky130_fd_sc_hs__mux2_1
Xsky130_fd_sc_hs__mux2_1_434 VDD VSS sky130_fd_sc_hs__mux2_1_434/X sky130_fd_sc_hs__mux2_1_4/S
+ sky130_fd_sc_hs__a22o_1_91/B2 sky130_fd_sc_hs__mux2_1_434/A1 VSS VDD sky130_fd_sc_hs__mux2_1
Xsky130_fd_sc_hs__mux2_1_445 VDD VSS sky130_fd_sc_hs__mux2_1_445/X sky130_fd_sc_hs__buf_16_1/X
+ sky130_fd_sc_hs__mux2_1_445/A0 sky130_fd_sc_hs__a22o_1_92/B2 VSS VDD sky130_fd_sc_hs__mux2_1
Xsky130_fd_sc_hs__mux2_1_456 VDD VSS sky130_fd_sc_hs__mux2_1_456/X sky130_fd_sc_hs__buf_16_5/A
+ sky130_fd_sc_hs__mux2_1_456/A0 sky130_fd_sc_hs__a22o_1_92/B2 VSS VDD sky130_fd_sc_hs__mux2_1
Xsky130_fd_sc_hs__mux2_1_467 VDD VSS sky130_fd_sc_hs__mux2_1_467/X sky130_fd_sc_hs__buf_16_6/A
+ sky130_fd_sc_hs__mux2_1_467/A0 sky130_fd_sc_hs__a22o_1_94/B2 VSS VDD sky130_fd_sc_hs__mux2_1
Xsky130_fd_sc_hs__mux2_1_478 VDD VSS sky130_fd_sc_hs__mux2_1_478/X sky130_fd_sc_hs__mux2_1_8/S
+ sky130_fd_sc_hs__mux2_1_478/A0 sky130_fd_sc_hs__mux2_1_85/A0 VSS VDD sky130_fd_sc_hs__mux2_1
Xsky130_fd_sc_hs__buf_4_6 VDD VSS sky130_fd_sc_hs__buf_4_6/A sky130_fd_sc_hs__buf_4_6/X
+ VSS VDD sky130_fd_sc_hs__buf_4
Xsky130_fd_sc_hs__dfrtp_1_260 sky130_fd_sc_hs__buf_8_8/X VDD VSS sky130_fd_sc_hs__mux2_1_188/A0
+ sky130_fd_sc_hs__clkinv_1_51/A sky130_fd_sc_hs__mux2_1_188/X VSS VDD sky130_fd_sc_hs__dfrtp_1
Xsky130_fd_sc_hs__dfrtp_1_271 sky130_fd_sc_hs__buf_8_8/X VDD VSS sky130_fd_sc_hs__mux2_1_195/A0
+ sky130_fd_sc_hs__clkbuf_2_80/X sky130_fd_sc_hs__mux2_1_195/X VSS VDD sky130_fd_sc_hs__dfrtp_1
Xsky130_fd_sc_hs__dfrtp_1_282 sky130_fd_sc_hs__buf_8_4/A VDD VSS sky130_fd_sc_hs__xnor2_1_43/A
+ sky130_fd_sc_hs__clkbuf_2_70/X sky130_fd_sc_hs__dfrtp_1_282/D VSS VDD sky130_fd_sc_hs__dfrtp_1
Xsky130_fd_sc_hs__dfrtp_1_293 sky130_fd_sc_hs__buf_8_4/A VDD VSS sky130_fd_sc_hs__xnor2_1_42/A
+ sky130_fd_sc_hs__clkbuf_2_70/X sky130_fd_sc_hs__dfrtp_1_293/D VSS VDD sky130_fd_sc_hs__dfrtp_1
Xsky130_fd_sc_hs__clkbuf_2_1 VDD VSS sky130_fd_sc_hs__clkbuf_2_1/X sky130_fd_sc_hs__clkbuf_2_3/A
+ VSS VDD sky130_fd_sc_hs__clkbuf_2
Xsky130_fd_sc_hs__a22o_1_12 VDD VSS sky130_fd_sc_hs__a22o_1_12/X sky130_fd_sc_hs__o21a_1_1/X
+ sky130_fd_sc_hs__nand2b_1_3/B sky130_fd_sc_hs__a32o_1_2/B1 sky130_fd_sc_hs__maj3_1_2/A
+ VSS VDD sky130_fd_sc_hs__a22o_1
Xsky130_fd_sc_hs__clkinv_1_70 VDD VSS sky130_fd_sc_hs__clkinv_1_70/A sky130_fd_sc_hs__clkinv_1_70/Y
+ VSS VDD sky130_fd_sc_hs__clkinv_1
Xsky130_fd_sc_hs__a22o_1_23 VDD VSS sky130_fd_sc_hs__a22o_1_23/X sky130_fd_sc_hs__xnor2_1_49/B
+ sky130_fd_sc_hs__nor2_1_45/Y sky130_fd_sc_hs__nor2_1_45/B sky130_fd_sc_hs__xor2_1_0/A
+ VSS VDD sky130_fd_sc_hs__a22o_1
Xsky130_fd_sc_hs__clkinv_1_81 VDD VSS sky130_fd_sc_hs__clkinv_1_81/A sky130_fd_sc_hs__clkinv_1_81/Y
+ VSS VDD sky130_fd_sc_hs__clkinv_1
Xsky130_fd_sc_hs__a22o_1_34 VDD VSS sky130_fd_sc_hs__a22o_1_34/X sky130_fd_sc_hs__xnor2_1_51/A
+ sky130_fd_sc_hs__nor2_1_45/Y sky130_fd_sc_hs__nor2_1_45/B sky130_fd_sc_hs__and2_1_0/A
+ VSS VDD sky130_fd_sc_hs__a22o_1
Xsky130_fd_sc_hs__clkinv_1_92 VDD VSS sky130_fd_sc_hs__clkinv_1_92/A sky130_fd_sc_hs__clkinv_1_92/Y
+ VSS VDD sky130_fd_sc_hs__clkinv_1
Xsky130_fd_sc_hs__a22o_1_45 VDD VSS sky130_fd_sc_hs__a22o_1_45/X sky130_fd_sc_hs__mux2_1_95/A1
+ sky130_fd_sc_hs__buf_8_17/X sky130_fd_sc_hs__buf_8_15/X sky130_fd_sc_hs__a22o_1_50/B2
+ VSS VDD sky130_fd_sc_hs__a22o_1
Xsky130_fd_sc_hs__clkbuf_2_12 VDD VSS sky130_fd_sc_hs__clkbuf_2_12/X sky130_fd_sc_hs__clkinv_4_0/A
+ VSS VDD sky130_fd_sc_hs__clkbuf_2
Xsky130_fd_sc_hs__a22o_1_56 VDD VSS sky130_fd_sc_hs__a22o_1_56/X sky130_fd_sc_hs__a22o_1_56/B2
+ sky130_fd_sc_hs__a22o_1_93/B1 sky130_fd_sc_hs__a22o_1_93/A2 sky130_fd_sc_hs__or2_1_12/A
+ VSS VDD sky130_fd_sc_hs__a22o_1
Xsky130_fd_sc_hs__clkbuf_2_23 VDD VSS sky130_fd_sc_hs__clkbuf_2_23/X sky130_fd_sc_hs__clkbuf_2_3/A
+ VSS VDD sky130_fd_sc_hs__clkbuf_2
Xsky130_fd_sc_hs__a22o_1_67 VDD VSS sky130_fd_sc_hs__a22o_1_67/X sky130_fd_sc_hs__a22o_1_67/B2
+ sky130_fd_sc_hs__buf_8_17/X sky130_fd_sc_hs__buf_8_15/X sky130_fd_sc_hs__a22o_1_67/A1
+ VSS VDD sky130_fd_sc_hs__a22o_1
Xsky130_fd_sc_hs__a22o_1_78 VDD VSS sky130_fd_sc_hs__a22o_1_78/X sky130_fd_sc_hs__a22o_1_78/B2
+ sky130_fd_sc_hs__buf_8_16/A sky130_fd_sc_hs__buf_8_18/A sky130_fd_sc_hs__maj3_1_36/C
+ VSS VDD sky130_fd_sc_hs__a22o_1
Xsky130_fd_sc_hs__clkbuf_2_34 VDD VSS sky130_fd_sc_hs__clkinv_1_18/A sky130_fd_sc_hs__clkbuf_2_3/A
+ VSS VDD sky130_fd_sc_hs__clkbuf_2
Xsky130_fd_sc_hs__a22o_1_89 VDD VSS sky130_fd_sc_hs__a22o_1_89/X sky130_fd_sc_hs__a22o_1_89/B2
+ sky130_fd_sc_hs__buf_8_17/A sky130_fd_sc_hs__buf_8_15/A sky130_fd_sc_hs__a22o_1_90/B2
+ VSS VDD sky130_fd_sc_hs__a22o_1
Xsky130_fd_sc_hs__clkbuf_2_45 VDD VSS sky130_fd_sc_hs__clkinv_1_33/A sky130_fd_sc_hs__clkinv_4_1/A
+ VSS VDD sky130_fd_sc_hs__clkbuf_2
Xsky130_fd_sc_hs__clkbuf_2_56 VDD VSS sky130_fd_sc_hs__clkinv_1_40/A sky130_fd_sc_hs__inv_8_0/A
+ VSS VDD sky130_fd_sc_hs__clkbuf_2
Xsky130_fd_sc_hs__clkbuf_2_67 VDD VSS sky130_fd_sc_hs__clkbuf_2_67/X sky130_fd_sc_hs__clkbuf_2_92/A
+ VSS VDD sky130_fd_sc_hs__clkbuf_2
Xsky130_fd_sc_hs__clkbuf_2_78 VDD VSS sky130_fd_sc_hs__clkbuf_2_78/X sky130_fd_sc_hs__clkinv_4_2/A
+ VSS VDD sky130_fd_sc_hs__clkbuf_2
Xsky130_fd_sc_hs__clkbuf_2_89 VDD VSS sky130_fd_sc_hs__clkinv_2_5/A sky130_fd_sc_hs__clkinv_4_3/A
+ VSS VDD sky130_fd_sc_hs__clkbuf_2
Xsky130_fd_sc_hs__nand4_1_6 VDD VSS sky130_fd_sc_hs__nor3_1_37/C sky130_fd_sc_hs__nand4_1_6/Y
+ sky130_fd_sc_hs__nand4_1_6/D sky130_fd_sc_hs__nor3_1_37/B sky130_fd_sc_hs__nor3_1_37/A
+ VSS VDD sky130_fd_sc_hs__nand4_1
Xsky130_fd_sc_hs__maj3_1_18 VDD VSS sky130_fd_sc_hs__xor2_1_30/A sky130_fd_sc_hs__xor2_1_30/B
+ sky130_fd_sc_hs__maj3_1_18/X sky130_fd_sc_hs__maj3_1_18/C VSS VDD sky130_fd_sc_hs__maj3_1
Xsky130_fd_sc_hs__maj3_1_29 VDD VSS sky130_fd_sc_hs__xor2_1_53/A sky130_fd_sc_hs__xor2_1_56/A
+ sky130_fd_sc_hs__maj3_1_29/X sky130_fd_sc_hs__xor2_1_56/B VSS VDD sky130_fd_sc_hs__maj3_1
Xsky130_fd_sc_hs__clkinv_2_1 VDD VSS sky130_fd_sc_hs__clkinv_2_1/Y sky130_fd_sc_hs__clkinv_2_1/A
+ VSS VDD sky130_fd_sc_hs__clkinv_2
Xsky130_fd_sc_hs__nand2_1_12 VDD VSS sky130_fd_sc_hs__nand2_1_12/B sky130_fd_sc_hs__nor3_1_6/C
+ sky130_fd_sc_hs__nand2_1_12/A VSS VDD sky130_fd_sc_hs__nand2_1
Xsky130_fd_sc_hs__mux2_1_220 VDD VSS sky130_fd_sc_hs__mux2_1_220/X sky130_fd_sc_hs__nor2_1_82/B
+ sky130_fd_sc_hs__xor2_1_42/A sky130_fd_sc_hs__a21oi_1_49/Y VSS VDD sky130_fd_sc_hs__mux2_1
Xsky130_fd_sc_hs__mux2_1_231 VDD VSS sky130_fd_sc_hs__mux2_1_231/X sky130_fd_sc_hs__mux2_1_341/S
+ sky130_fd_sc_hs__mux2_1_477/A1 sky130_fd_sc_hs__mux2_1_231/A1 VSS VDD sky130_fd_sc_hs__mux2_1
Xsky130_fd_sc_hs__nand2_1_23 VDD VSS sky130_fd_sc_hs__and2_1_1/X sky130_fd_sc_hs__nand2b_1_3/B
+ sky130_fd_sc_hs__o21a_1_1/A1 VSS VDD sky130_fd_sc_hs__nand2_1
Xsky130_fd_sc_hs__mux2_1_242 VDD VSS sky130_fd_sc_hs__mux2_1_242/X sky130_fd_sc_hs__mux2_1_397/S
+ sky130_fd_sc_hs__or2_1_18/B sky130_fd_sc_hs__dfrtp_2_1/Q VSS VDD sky130_fd_sc_hs__mux2_1
Xsky130_fd_sc_hs__nand2_1_34 VDD VSS sky130_fd_sc_hs__nand2_1_34/B sky130_fd_sc_hs__nand2_1_34/Y
+ sky130_fd_sc_hs__nand2_1_34/A VSS VDD sky130_fd_sc_hs__nand2_1
Xsky130_fd_sc_hs__mux2_1_253 VDD VSS sky130_fd_sc_hs__mux2_1_253/X sky130_fd_sc_hs__o21a_1_29/B1
+ sky130_fd_sc_hs__buf_1_131/A sky130_fd_sc_hs__mux2_1_40/A0 VSS VDD sky130_fd_sc_hs__mux2_1
Xsky130_fd_sc_hs__nand2_1_45 VDD VSS sky130_fd_sc_hs__or2_1_4/X sky130_fd_sc_hs__nand2_1_45/Y
+ sky130_fd_sc_hs__nand2_1_45/A VSS VDD sky130_fd_sc_hs__nand2_1
Xsky130_fd_sc_hs__mux2_1_264 VDD VSS sky130_fd_sc_hs__mux2_1_264/X sky130_fd_sc_hs__o21a_1_29/B1
+ sky130_fd_sc_hs__buf_1_166/A sky130_fd_sc_hs__a22o_1_75/B2 VSS VDD sky130_fd_sc_hs__mux2_1
Xsky130_fd_sc_hs__nand2_1_56 VDD VSS sky130_fd_sc_hs__nor2_1_43/Y sky130_fd_sc_hs__o41ai_1_0/B1
+ sky130_fd_sc_hs__nor2_1_41/B VSS VDD sky130_fd_sc_hs__nand2_1
Xsky130_fd_sc_hs__mux2_1_275 VDD VSS sky130_fd_sc_hs__mux2_1_275/X sky130_fd_sc_hs__nor2_2_6/Y
+ sky130_fd_sc_hs__mux2_1_275/A0 sky130_fd_sc_hs__a22o_1_84/B2 VSS VDD sky130_fd_sc_hs__mux2_1
Xsky130_fd_sc_hs__nand2_1_67 VDD VSS sky130_fd_sc_hs__a32o_1_4/B1 sky130_fd_sc_hs__nand2_1_67/Y
+ sky130_fd_sc_hs__and3_1_8/A VSS VDD sky130_fd_sc_hs__nand2_1
Xsky130_fd_sc_hs__mux2_1_286 VDD VSS sky130_fd_sc_hs__mux2_1_286/X sky130_fd_sc_hs__nor2_2_4/Y
+ sky130_fd_sc_hs__mux2_1_286/A0 sky130_fd_sc_hs__mux2_1_473/A1 VSS VDD sky130_fd_sc_hs__mux2_1
Xsky130_fd_sc_hs__nand2_1_78 VDD VSS sky130_fd_sc_hs__o211ai_1_5/Y sky130_fd_sc_hs__a31o_1_9/A3
+ sky130_fd_sc_hs__a31o_1_8/A3 VSS VDD sky130_fd_sc_hs__nand2_1
Xsky130_fd_sc_hs__mux2_1_297 VDD VSS sky130_fd_sc_hs__mux2_1_297/X sky130_fd_sc_hs__buf_4_0/X
+ sky130_fd_sc_hs__mux2_1_297/A0 sky130_fd_sc_hs__mux2_1_355/A1 VSS VDD sky130_fd_sc_hs__mux2_1
Xsky130_fd_sc_hs__nand2_1_89 VDD VSS sky130_fd_sc_hs__o22ai_1_15/Y sky130_fd_sc_hs__nand2_1_89/Y
+ sky130_fd_sc_hs__o21a_1_4/B1 VSS VDD sky130_fd_sc_hs__nand2_1
Xsky130_fd_sc_hs__a222oi_1_19 VDD VSS sky130_fd_sc_hs__buf_8_31/X sky130_fd_sc_hs__mux2_1_351/A0
+ sky130_fd_sc_hs__buf_4_3/X sky130_fd_sc_hs__clkbuf_8_15/X sky130_fd_sc_hs__mux2_1_336/A0
+ sky130_fd_sc_hs__o2111a_1_0/D1 sky130_fd_sc_hs__mux2_1_339/A0 VSS VDD sky130_fd_sc_hs__a222oi_1
Xsky130_fd_sc_hs__dlygate4sd3_1_13 VSS VDD raw_bits_i[10] sky130_fd_sc_hs__buf_1_81/A
+ VSS VDD sky130_fd_sc_hs__dlygate4sd3_1
Xsky130_fd_sc_hs__dlygate4sd3_1_24 VSS VDD raw_bits_i[16] sky130_fd_sc_hs__buf_1_90/A
+ VSS VDD sky130_fd_sc_hs__dlygate4sd3_1
Xsky130_fd_sc_hs__o21ai_1_13 VDD VSS sky130_fd_sc_hs__o21ai_1_13/Y sky130_fd_sc_hs__o21a_1_12/X
+ sky130_fd_sc_hs__xnor2_1_39/Y sky130_fd_sc_hs__a31o_1_14/B1 VSS VDD sky130_fd_sc_hs__o21ai_1
Xsky130_fd_sc_hs__o21ai_1_24 VDD VSS sky130_fd_sc_hs__o21ai_1_24/Y sky130_fd_sc_hs__buf_8_2/A
+ sky130_fd_sc_hs__buf_1_22/X sky130_fd_sc_hs__maj3_1_0/A VSS VDD sky130_fd_sc_hs__o21ai_1
Xsky130_fd_sc_hs__o21ai_1_35 VDD VSS sky130_fd_sc_hs__nor2_1_56/B sky130_fd_sc_hs__nor2_1_40/B
+ sky130_fd_sc_hs__and3_1_5/X sky130_fd_sc_hs__nor3_1_17/A VSS VDD sky130_fd_sc_hs__o21ai_1
Xsky130_fd_sc_hs__o21ai_1_46 VDD VSS sky130_fd_sc_hs__o21ai_1_46/Y sky130_fd_sc_hs__buf_8_2/X
+ sky130_fd_sc_hs__buf_8_10/A sky130_fd_sc_hs__nor2_1_77/A VSS VDD sky130_fd_sc_hs__o21ai_1
Xsky130_fd_sc_hs__o21ai_1_57 VDD VSS sky130_fd_sc_hs__o21ai_1_57/Y sky130_fd_sc_hs__nor2_4_0/Y
+ sky130_fd_sc_hs__xor3_1_0/X sky130_fd_sc_hs__maj3_1_48/X VSS VDD sky130_fd_sc_hs__o21ai_1
Xsky130_fd_sc_hs__o21ai_1_68 VDD VSS sky130_fd_sc_hs__o21ai_1_68/Y sky130_fd_sc_hs__o311ai_1_22/Y
+ sky130_fd_sc_hs__mux2_1_99/S sky130_fd_sc_hs__o41ai_1_3/A2 VSS VDD sky130_fd_sc_hs__o21ai_1
Xsky130_fd_sc_hs__o21ai_1_79 VDD VSS sky130_fd_sc_hs__o21ai_1_79/Y sky130_fd_sc_hs__o21ai_1_78/Y
+ sky130_fd_sc_hs__nor2_2_5/B sky130_fd_sc_hs__o21ai_1_79/A1 VSS VDD sky130_fd_sc_hs__o21ai_1
Xsky130_fd_sc_hs__clkbuf_8_11 VDD VSS sky130_fd_sc_hs__a222o_1_7/A2 sky130_fd_sc_hs__nor3_4_5/Y
+ VSS VDD sky130_fd_sc_hs__clkbuf_8
Xsky130_fd_sc_hs__o211ai_1_13 VDD VSS sky130_fd_sc_hs__o31a_1_5/B1 sky130_fd_sc_hs__o21ai_1_74/B1
+ sky130_fd_sc_hs__buf_1_140/A sky130_fd_sc_hs__or2_1_26/X sky130_fd_sc_hs__or3_1_1/X
+ VSS VDD sky130_fd_sc_hs__o211ai_1
Xsky130_fd_sc_hs__buf_16_9 sky130_fd_sc_hs__buf_16_9/X VDD VSS sky130_fd_sc_hs__buf_16_9/A
+ VSS VDD sky130_fd_sc_hs__buf_16
Xsky130_fd_sc_hs__and4_1_1 VDD VSS sky130_fd_sc_hs__and4_1_1/A sky130_fd_sc_hs__and4_1_1/B
+ sky130_fd_sc_hs__and4_1_1/C sky130_fd_sc_hs__and4_1_1/D sky130_fd_sc_hs__and4_1_1/X
+ VSS VDD sky130_fd_sc_hs__and4_1
Xsky130_fd_sc_hs__nor2_4_3 VDD VSS sky130_fd_sc_hs__nor2_4_3/Y sky130_fd_sc_hs__nor2_4_3/A
+ sky130_fd_sc_hs__nor2_4_3/B VSS VDD sky130_fd_sc_hs__nor2_4
Xsky130_fd_sc_hs__dfrtp_1_804 sky130_fd_sc_hs__clkbuf_4_23/A VDD VSS sky130_fd_sc_hs__xor2_1_65/B
+ sky130_fd_sc_hs__clkinv_1_84/A sky130_fd_sc_hs__mux2_1_240/X VSS VDD sky130_fd_sc_hs__dfrtp_1
Xsky130_fd_sc_hs__dfrtp_1_815 sky130_fd_sc_hs__clkbuf_4_1/X VDD VSS sky130_fd_sc_hs__mux2_1_478/A0
+ sky130_fd_sc_hs__clkinv_1_8/A sky130_fd_sc_hs__mux2_1_478/X VSS VDD sky130_fd_sc_hs__dfrtp_1
Xsky130_fd_sc_hs__dfrtp_1_826 sky130_fd_sc_hs__clkbuf_4_2/X VDD VSS sky130_fd_sc_hs__mux2_1_310/A0
+ sky130_fd_sc_hs__clkinv_1_29/A sky130_fd_sc_hs__mux2_1_310/X VSS VDD sky130_fd_sc_hs__dfrtp_1
Xsky130_fd_sc_hs__a21oi_1_101 VDD VSS sky130_fd_sc_hs__xnor2_1_84/Y sky130_fd_sc_hs__a21oi_1_101/Y
+ sky130_fd_sc_hs__a21o_1_8/X sky130_fd_sc_hs__a31o_1_11/A1 VSS VDD sky130_fd_sc_hs__a21oi_1
Xsky130_fd_sc_hs__a21oi_1_112 VDD VSS sky130_fd_sc_hs__o31ai_1_10/Y sky130_fd_sc_hs__o21ai_1_49/A1
+ sky130_fd_sc_hs__or2_1_18/X sky130_fd_sc_hs__a31o_1_13/A2 VSS VDD sky130_fd_sc_hs__a21oi_1
Xsky130_fd_sc_hs__a21oi_1_123 VDD VSS sky130_fd_sc_hs__nor2_1_104/Y sky130_fd_sc_hs__dfrtp_1_461/D
+ sky130_fd_sc_hs__buf_8_11/X sky130_fd_sc_hs__o21ai_1_66/Y VSS VDD sky130_fd_sc_hs__a21oi_1
Xsky130_fd_sc_hs__a21oi_1_134 VDD VSS sky130_fd_sc_hs__nor2_1_113/Y sky130_fd_sc_hs__dfrtp_1_517/D
+ sky130_fd_sc_hs__o21ai_1_103/Y sky130_fd_sc_hs__buf_8_21/X VSS VDD sky130_fd_sc_hs__a21oi_1
Xsky130_fd_sc_hs__a21oi_1_145 VDD VSS sky130_fd_sc_hs__o22ai_1_2/A1 sky130_fd_sc_hs__a21oi_1_145/Y
+ sky130_fd_sc_hs__or2_1_30/B sky130_fd_sc_hs__mux2i_1_5/A1 VSS VDD sky130_fd_sc_hs__a21oi_1
Xsky130_fd_sc_hs__a21oi_1_156 VDD VSS sky130_fd_sc_hs__nor2_1_134/Y sky130_fd_sc_hs__dfrtp_1_483/D
+ sky130_fd_sc_hs__nor2_1_132/B sky130_fd_sc_hs__or3_1_4/A VSS VDD sky130_fd_sc_hs__a21oi_1
Xsky130_fd_sc_hs__a21oi_1_167 VDD VSS sky130_fd_sc_hs__or3b_1_1/X sky130_fd_sc_hs__o31ai_4_0/A3
+ sky130_fd_sc_hs__a22oi_1_119/Y sky130_fd_sc_hs__a22oi_1_63/Y VSS VDD sky130_fd_sc_hs__a21oi_1
Xsky130_fd_sc_hs__a21oi_1_178 VDD VSS sky130_fd_sc_hs__a21oi_1_176/Y sky130_fd_sc_hs__dfrtp_1_579/D
+ sky130_fd_sc_hs__o21ai_1_82/Y sky130_fd_sc_hs__buf_4_6/X VSS VDD sky130_fd_sc_hs__a21oi_1
Xsky130_fd_sc_hs__a21oi_1_189 VDD VSS sky130_fd_sc_hs__o21ai_1_92/Y sky130_fd_sc_hs__o21ai_1_93/A2
+ sky130_fd_sc_hs__xnor2_1_128/Y sky130_fd_sc_hs__buf_8_36/X VSS VDD sky130_fd_sc_hs__a21oi_1
Xsky130_fd_sc_hs__clkbuf_2_150 VDD VSS sky130_fd_sc_hs__clkinv_1_102/A sky130_fd_sc_hs__inv_8_1/A
+ VSS VDD sky130_fd_sc_hs__clkbuf_2
Xsky130_fd_sc_hs__clkbuf_2_161 VDD VSS sky130_fd_sc_hs__clkinv_1_109/A sky130_fd_sc_hs__clkbuf_2_176/A
+ VSS VDD sky130_fd_sc_hs__clkbuf_2
Xsky130_fd_sc_hs__clkbuf_2_172 VDD VSS sky130_fd_sc_hs__buf_8_3/A sky130_fd_sc_hs__mux2_1_289/S
+ VSS VDD sky130_fd_sc_hs__clkbuf_2
Xsky130_fd_sc_hs__nand2_1_150 VDD VSS sky130_fd_sc_hs__nand4_1_7/D sky130_fd_sc_hs__mux2i_1_11/S
+ sky130_fd_sc_hs__nor2b_1_39/Y VSS VDD sky130_fd_sc_hs__nand2_1
Xsky130_fd_sc_hs__clkbuf_2_183 VDD VSS sky130_fd_sc_hs__clkinv_1_133/A sky130_fd_sc_hs__clkinv_4_6/A
+ VSS VDD sky130_fd_sc_hs__clkbuf_2
Xsky130_fd_sc_hs__nand2_1_161 VDD VSS sky130_fd_sc_hs__or2_1_30/X sky130_fd_sc_hs__nand2_1_161/Y
+ sky130_fd_sc_hs__mux2i_1_4/A1 VSS VDD sky130_fd_sc_hs__nand2_1
Xsky130_fd_sc_hs__clkbuf_2_194 VDD VSS sky130_fd_sc_hs__clkinv_1_141/A sky130_fd_sc_hs__clkbuf_2_236/A
+ VSS VDD sky130_fd_sc_hs__clkbuf_2
Xsky130_fd_sc_hs__nand2_1_172 VDD VSS sky130_fd_sc_hs__nor2_1_157/Y sky130_fd_sc_hs__and2_1_34/A
+ sky130_fd_sc_hs__nor3_1_24/C VSS VDD sky130_fd_sc_hs__nand2_1
Xsky130_fd_sc_hs__nand2_1_183 VDD VSS sky130_fd_sc_hs__nor2_1_160/B sky130_fd_sc_hs__a32oi_1_0/A3
+ sky130_fd_sc_hs__nor3_1_48/C VSS VDD sky130_fd_sc_hs__nand2_1
Xsky130_fd_sc_hs__nand2_1_194 VDD VSS sky130_fd_sc_hs__a22oi_1_6/B1 sky130_fd_sc_hs__and4_1_6/A
+ sky130_fd_sc_hs__and2_1_9/B VSS VDD sky130_fd_sc_hs__nand2_1
Xsky130_fd_sc_hs__clkinv_1_106 VDD VSS sky130_fd_sc_hs__clkinv_1_106/A sky130_fd_sc_hs__clkinv_1_106/Y
+ VSS VDD sky130_fd_sc_hs__clkinv_1
Xsky130_fd_sc_hs__clkinv_1_117 VDD VSS sky130_fd_sc_hs__dfstp_1_2/CLK sky130_fd_sc_hs__clkinv_1_117/Y
+ VSS VDD sky130_fd_sc_hs__clkinv_1
Xsky130_fd_sc_hs__clkinv_1_128 VDD VSS sky130_fd_sc_hs__clkinv_1_128/A sky130_fd_sc_hs__clkinv_1_128/Y
+ VSS VDD sky130_fd_sc_hs__clkinv_1
Xsky130_fd_sc_hs__clkinv_1_139 VDD VSS sky130_fd_sc_hs__or2_1_18/A sky130_fd_sc_hs__and3_1_12/A
+ VSS VDD sky130_fd_sc_hs__clkinv_1
Xsky130_fd_sc_hs__nor2_2_0 VDD VSS sky130_fd_sc_hs__nor2_2_1/Y sky130_fd_sc_hs__nor2_2_0/Y
+ sky130_fd_sc_hs__nor2_2_0/A VSS VDD sky130_fd_sc_hs__nor2_2
Xsky130_fd_sc_hs__dfrtp_1_601 sky130_fd_sc_hs__clkbuf_4_30/X VDD VSS sky130_fd_sc_hs__mux2_1_304/A0
+ sky130_fd_sc_hs__clkbuf_2_179/X sky130_fd_sc_hs__mux2_1_304/X VSS VDD sky130_fd_sc_hs__dfrtp_1
Xsky130_fd_sc_hs__dfrtp_1_612 sky130_fd_sc_hs__clkbuf_4_31/X VDD VSS sky130_fd_sc_hs__mux2_1_355/A0
+ sky130_fd_sc_hs__clkinv_1_135/A sky130_fd_sc_hs__mux2_1_355/X VSS VDD sky130_fd_sc_hs__dfrtp_1
Xsky130_fd_sc_hs__dfrtp_1_623 sky130_fd_sc_hs__clkbuf_4_31/X VDD VSS sky130_fd_sc_hs__mux2_1_328/A0
+ sky130_fd_sc_hs__clkbuf_2_193/X sky130_fd_sc_hs__mux2_1_328/X VSS VDD sky130_fd_sc_hs__dfrtp_1
Xsky130_fd_sc_hs__dfrtp_1_634 sky130_fd_sc_hs__buf_8_30/X VDD VSS sky130_fd_sc_hs__maj3_1_52/A
+ sky130_fd_sc_hs__clkbuf_2_201/X sky130_fd_sc_hs__a22o_1_125/X VSS VDD sky130_fd_sc_hs__dfrtp_1
Xsky130_fd_sc_hs__dfrtp_1_645 sky130_fd_sc_hs__buf_8_30/A VDD VSS sky130_fd_sc_hs__mux2_1_351/A0
+ sky130_fd_sc_hs__clkbuf_2_189/X sky130_fd_sc_hs__mux2_1_351/X VSS VDD sky130_fd_sc_hs__dfrtp_1
Xsky130_fd_sc_hs__dfrtp_1_656 sky130_fd_sc_hs__clkbuf_4_33/X VDD VSS sky130_fd_sc_hs__mux2_1_358/A0
+ sky130_fd_sc_hs__clkbuf_2_200/X sky130_fd_sc_hs__mux2_1_358/X VSS VDD sky130_fd_sc_hs__dfrtp_1
Xsky130_fd_sc_hs__dfrtp_1_667 sky130_fd_sc_hs__clkbuf_4_35/X VDD VSS sky130_fd_sc_hs__xor2_1_85/A
+ sky130_fd_sc_hs__clkinv_1_155/A sky130_fd_sc_hs__dfrtp_1_667/D VSS VDD sky130_fd_sc_hs__dfrtp_1
Xsky130_fd_sc_hs__nor2_1_109 VDD VSS sky130_fd_sc_hs__buf_8_21/X sky130_fd_sc_hs__nor2_1_109/Y
+ sky130_fd_sc_hs__xor2_1_70/A VSS VDD sky130_fd_sc_hs__nor2_1
Xsky130_fd_sc_hs__dfrtp_1_678 sky130_fd_sc_hs__clkbuf_4_35/X VDD VSS sky130_fd_sc_hs__mux2_1_378/A0
+ sky130_fd_sc_hs__clkbuf_2_209/X sky130_fd_sc_hs__mux2_1_378/X VSS VDD sky130_fd_sc_hs__dfrtp_1
Xsky130_fd_sc_hs__dfrtp_1_689 sky130_fd_sc_hs__clkbuf_4_33/X VDD VSS sky130_fd_sc_hs__mux2_1_390/A1
+ sky130_fd_sc_hs__clkbuf_2_213/X sky130_fd_sc_hs__mux2_1_390/X VSS VDD sky130_fd_sc_hs__dfrtp_1
Xsky130_fd_sc_hs__dfrtp_1_8 sky130_fd_sc_hs__clkbuf_4_4/A VDD VSS sky130_fd_sc_hs__maj3_1_7/B
+ sky130_fd_sc_hs__dfrtp_1_8/CLK sky130_fd_sc_hs__dfrtp_1_8/D VSS VDD sky130_fd_sc_hs__dfrtp_1
Xsky130_fd_sc_hs__a22oi_1_18 VDD VSS sky130_fd_sc_hs__mux2_1_48/A1 sky130_fd_sc_hs__and4_1_1/B
+ sky130_fd_sc_hs__a222o_1_3/C2 sky130_fd_sc_hs__a222o_1_2/A2 sky130_fd_sc_hs__mux2_1_47/A0
+ VSS VDD sky130_fd_sc_hs__a22oi_1
Xsky130_fd_sc_hs__a22oi_1_29 VDD VSS sky130_fd_sc_hs__mux2_1_75/A1 sky130_fd_sc_hs__nand2_1_13/A
+ sky130_fd_sc_hs__a222o_1_3/C2 sky130_fd_sc_hs__a22o_1_8/A2 sky130_fd_sc_hs__mux2_1_73/A0
+ VSS VDD sky130_fd_sc_hs__a22oi_1
Xsky130_fd_sc_hs__nor2_1_20 VDD VSS sky130_fd_sc_hs__and3_1_1/X sky130_fd_sc_hs__o21a_1_2/B1
+ sky130_fd_sc_hs__and2_1_6/X VSS VDD sky130_fd_sc_hs__nor2_1
Xsky130_fd_sc_hs__nor2_1_31 VDD VSS sky130_fd_sc_hs__nor2_1_31/B sky130_fd_sc_hs__nor2_1_33/B
+ sky130_fd_sc_hs__maj3_1_9/A VSS VDD sky130_fd_sc_hs__nor2_1
Xsky130_fd_sc_hs__nor2_1_42 VDD VSS sky130_fd_sc_hs__nor2_1_42/B sky130_fd_sc_hs__nor2_1_42/Y
+ sky130_fd_sc_hs__nor2_1_42/A VSS VDD sky130_fd_sc_hs__nor2_1
Xsky130_fd_sc_hs__nor2_1_53 VDD VSS sky130_fd_sc_hs__nor2_1_53/B sky130_fd_sc_hs__nor2_1_53/Y
+ sky130_fd_sc_hs__o32a_1_0/A2 VSS VDD sky130_fd_sc_hs__nor2_1
Xsky130_fd_sc_hs__nor2_1_64 VDD VSS sky130_fd_sc_hs__nor2_1_64/B sky130_fd_sc_hs__nor2_1_64/Y
+ sky130_fd_sc_hs__buf_8_19/X VSS VDD sky130_fd_sc_hs__nor2_1
Xsky130_fd_sc_hs__nor2_1_75 VDD VSS sky130_fd_sc_hs__xor2_1_56/A sky130_fd_sc_hs__nor2_1_75/Y
+ sky130_fd_sc_hs__xor2_1_53/A VSS VDD sky130_fd_sc_hs__nor2_1
Xsky130_fd_sc_hs__nor2_1_86 VDD VSS sky130_fd_sc_hs__nor2_1_86/B sky130_fd_sc_hs__nor3_1_22/A
+ sky130_fd_sc_hs__buf_8_12/A VSS VDD sky130_fd_sc_hs__nor2_1
Xsky130_fd_sc_hs__nor2_1_97 VDD VSS sky130_fd_sc_hs__nor2_2_2/B sky130_fd_sc_hs__nor2_4_1/A
+ sky130_fd_sc_hs__nor2_1_97/A VSS VDD sky130_fd_sc_hs__nor2_1
Xsky130_fd_sc_hs__xnor2_1_120 VDD VSS sky130_fd_sc_hs__nor2b_1_45/A sky130_fd_sc_hs__o31ai_2_0/A1
+ sky130_fd_sc_hs__nor2b_1_46/Y VSS VDD sky130_fd_sc_hs__xnor2_1
Xsky130_fd_sc_hs__xnor2_1_131 VDD VSS sky130_fd_sc_hs__xor2_1_89/A sky130_fd_sc_hs__xnor2_1_131/Y
+ sky130_fd_sc_hs__a211o_1_2/X VSS VDD sky130_fd_sc_hs__xnor2_1
Xsky130_fd_sc_hs__xnor2_1_142 VDD VSS sky130_fd_sc_hs__maj3_1_65/X sky130_fd_sc_hs__xnor2_1_142/Y
+ sky130_fd_sc_hs__xnor2_1_142/B VSS VDD sky130_fd_sc_hs__xnor2_1
Xsky130_fd_sc_hs__mux2_1_60 VDD VSS sky130_fd_sc_hs__mux2_1_60/X sky130_fd_sc_hs__mux2_1_6/S
+ sky130_fd_sc_hs__mux2_1_95/A1 sky130_fd_sc_hs__mux2_1_60/A1 VSS VDD sky130_fd_sc_hs__mux2_1
Xsky130_fd_sc_hs__mux2_1_71 VDD VSS sky130_fd_sc_hs__mux2_1_71/X sky130_fd_sc_hs__buf_16_5/X
+ sky130_fd_sc_hs__mux2_1_71/A0 sky130_fd_sc_hs__mux2_1_96/A0 VSS VDD sky130_fd_sc_hs__mux2_1
Xsky130_fd_sc_hs__mux2_1_82 VDD VSS sky130_fd_sc_hs__mux2_1_82/X sky130_fd_sc_hs__mux2_1_7/S
+ sky130_fd_sc_hs__mux2_1_82/A0 sky130_fd_sc_hs__mux2_1_85/A0 VSS VDD sky130_fd_sc_hs__mux2_1
Xsky130_fd_sc_hs__mux2_1_93 VDD VSS sky130_fd_sc_hs__mux2_1_93/X sky130_fd_sc_hs__mux2_1_6/S
+ sky130_fd_sc_hs__mux2_1_94/A1 sky130_fd_sc_hs__mux2_1_93/A1 VSS VDD sky130_fd_sc_hs__mux2_1
Xsky130_fd_sc_hs__xnor2_1_6 VDD VSS sky130_fd_sc_hs__a31o_1_1/X sky130_fd_sc_hs__xnor2_1_6/Y
+ sky130_fd_sc_hs__nor2_1_9/Y VSS VDD sky130_fd_sc_hs__xnor2_1
Xsky130_fd_sc_hs__nor2b_1_20 VDD VSS sky130_fd_sc_hs__maj3_1_29/X sky130_fd_sc_hs__nor2_1_74/A
+ sky130_fd_sc_hs__xnor2_1_77/Y VSS VDD sky130_fd_sc_hs__nor2b_1
Xsky130_fd_sc_hs__nor2b_1_31 VDD VSS sky130_fd_sc_hs__o22ai_1_3/B2 sky130_fd_sc_hs__nor2b_1_31/Y
+ sky130_fd_sc_hs__o22ai_1_3/B1 VSS VDD sky130_fd_sc_hs__nor2b_1
Xsky130_fd_sc_hs__nor2b_1_42 VDD VSS sky130_fd_sc_hs__maj3_1_49/X sky130_fd_sc_hs__nor2_1_83/A
+ sky130_fd_sc_hs__xnor2_1_96/Y VSS VDD sky130_fd_sc_hs__nor2b_1
Xsky130_fd_sc_hs__o22ai_1_1 VDD VSS sky130_fd_sc_hs__nor2_2_2/B sky130_fd_sc_hs__nor3_1_26/C
+ sky130_fd_sc_hs__o22ai_1_1/Y sky130_fd_sc_hs__nand4_1_4/C sky130_fd_sc_hs__nor3_1_24/C
+ VSS VDD sky130_fd_sc_hs__o22ai_1
Xsky130_fd_sc_hs__or2_1_5 VDD VSS sky130_fd_sc_hs__or2_1_5/B sky130_fd_sc_hs__or2_1_5/A
+ sky130_fd_sc_hs__or2_1_5/X VSS VDD sky130_fd_sc_hs__or2_1
Xsky130_fd_sc_hs__dfrtp_1_420 sky130_fd_sc_hs__clkbuf_4_16/X VDD VSS sky130_fd_sc_hs__a22o_1_90/B2
+ sky130_fd_sc_hs__clkinv_1_82/A sky130_fd_sc_hs__a22o_1_90/X VSS VDD sky130_fd_sc_hs__dfrtp_1
Xsky130_fd_sc_hs__dfrtp_1_431 sky130_fd_sc_hs__clkbuf_4_19/X VDD VSS sky130_fd_sc_hs__or2_1_18/B
+ sky130_fd_sc_hs__clkbuf_2_129/A sky130_fd_sc_hs__mux2_1_242/X VSS VDD sky130_fd_sc_hs__dfrtp_1
Xsky130_fd_sc_hs__dfrtp_1_442 sky130_fd_sc_hs__clkbuf_4_56/X VDD VSS sky130_fd_sc_hs__a22o_1_77/B2
+ sky130_fd_sc_hs__clkbuf_2_112/X sky130_fd_sc_hs__a22o_1_77/X VSS VDD sky130_fd_sc_hs__dfrtp_1
Xsky130_fd_sc_hs__dfrtp_1_453 sky130_fd_sc_hs__clkbuf_4_22/X VDD VSS sky130_fd_sc_hs__buf_1_142/A
+ sky130_fd_sc_hs__clkinv_1_92/A sky130_fd_sc_hs__buf_1_91/X VSS VDD sky130_fd_sc_hs__dfrtp_1
Xsky130_fd_sc_hs__dfrtp_1_464 sky130_fd_sc_hs__clkbuf_4_22/A VDD VSS sky130_fd_sc_hs__xor3_1_0/A
+ sky130_fd_sc_hs__clkbuf_2_139/X sky130_fd_sc_hs__mux2_1_247/X VSS VDD sky130_fd_sc_hs__dfrtp_1
Xsky130_fd_sc_hs__dfrtp_1_475 sky130_fd_sc_hs__clkbuf_4_22/A VDD VSS sky130_fd_sc_hs__xor2_1_71/B
+ sky130_fd_sc_hs__clkinv_1_101/A sky130_fd_sc_hs__mux2_1_250/X VSS VDD sky130_fd_sc_hs__dfrtp_1
Xsky130_fd_sc_hs__dfrtp_1_486 sky130_fd_sc_hs__clkbuf_4_23/X VDD VSS sky130_fd_sc_hs__nor3_1_37/A
+ sky130_fd_sc_hs__clkbuf_2_154/X sky130_fd_sc_hs__o21a_1_25/X VSS VDD sky130_fd_sc_hs__dfrtp_1
Xsky130_fd_sc_hs__dfrtp_1_497 sky130_fd_sc_hs__clkbuf_4_23/X VDD VSS sky130_fd_sc_hs__nand2_1_156/A
+ sky130_fd_sc_hs__clkbuf_2_157/A sky130_fd_sc_hs__dfrtp_1_497/D VSS VDD sky130_fd_sc_hs__dfrtp_1
Xsky130_fd_sc_hs__clkbuf_4_5 VDD VSS sky130_fd_sc_hs__buf_8_38/A sky130_fd_sc_hs__clkbuf_4_5/X
+ VSS VDD sky130_fd_sc_hs__clkbuf_4
Xsky130_fd_sc_hs__clkinv_4_5 VDD VSS sky130_fd_sc_hs__clkinv_4_5/Y sky130_fd_sc_hs__clkinv_4_5/A
+ VSS VDD sky130_fd_sc_hs__clkinv_4
Xsky130_fd_sc_hs__mux2_1_402 VDD VSS sky130_fd_sc_hs__mux2_1_402/X sky130_fd_sc_hs__buf_16_14/A
+ sky130_fd_sc_hs__mux2_1_402/A0 sky130_fd_sc_hs__dfrtp_2_2/Q VSS VDD sky130_fd_sc_hs__mux2_1
Xsky130_fd_sc_hs__mux2_1_413 VDD VSS sky130_fd_sc_hs__mux2_1_413/X sky130_fd_sc_hs__buf_16_16/A
+ sky130_fd_sc_hs__a22o_1_88/B2 sky130_fd_sc_hs__mux2_1_413/A1 VSS VDD sky130_fd_sc_hs__mux2_1
Xsky130_fd_sc_hs__mux2_1_424 VDD VSS sky130_fd_sc_hs__mux2_1_424/X sky130_fd_sc_hs__mux2_1_1/S
+ sky130_fd_sc_hs__a22o_1_94/B2 sky130_fd_sc_hs__mux2_1_424/A1 VSS VDD sky130_fd_sc_hs__mux2_1
Xsky130_fd_sc_hs__mux2_1_435 VDD VSS sky130_fd_sc_hs__mux2_1_435/X sky130_fd_sc_hs__buf_16_14/A
+ sky130_fd_sc_hs__mux2_1_435/A0 sky130_fd_sc_hs__a22o_1_91/B2 VSS VDD sky130_fd_sc_hs__mux2_1
Xsky130_fd_sc_hs__mux2_1_446 VDD VSS sky130_fd_sc_hs__mux2_1_446/X sky130_fd_sc_hs__buf_16_2/A
+ sky130_fd_sc_hs__a22o_1_92/B2 sky130_fd_sc_hs__mux2_1_446/A1 VSS VDD sky130_fd_sc_hs__mux2_1
Xsky130_fd_sc_hs__mux2_1_457 VDD VSS sky130_fd_sc_hs__mux2_1_457/X sky130_fd_sc_hs__buf_16_10/A
+ sky130_fd_sc_hs__mux2_1_457/A0 sky130_fd_sc_hs__dfrtp_2_2/Q VSS VDD sky130_fd_sc_hs__mux2_1
Xsky130_fd_sc_hs__mux2_1_468 VDD VSS sky130_fd_sc_hs__mux2_1_468/X sky130_fd_sc_hs__buf_8_27/X
+ sky130_fd_sc_hs__mux2_1_468/A0 sky130_fd_sc_hs__a22o_1_95/B2 VSS VDD sky130_fd_sc_hs__mux2_1
Xsky130_fd_sc_hs__mux2_1_479 VDD VSS sky130_fd_sc_hs__mux2_1_479/X sky130_fd_sc_hs__mux2_1_8/S
+ sky130_fd_sc_hs__mux2_1_479/A0 sky130_fd_sc_hs__mux2_1_99/A0 VSS VDD sky130_fd_sc_hs__mux2_1
Xsky130_fd_sc_hs__buf_4_7 VDD VSS sky130_fd_sc_hs__buf_4_7/A sky130_fd_sc_hs__buf_4_7/X
+ VSS VDD sky130_fd_sc_hs__buf_4
Xsky130_fd_sc_hs__a311oi_1_0 VDD VSS sky130_fd_sc_hs__nor2b_1_2/Y sky130_fd_sc_hs__nor2_1_9/A
+ sky130_fd_sc_hs__a31o_1_1/A3 sky130_fd_sc_hs__xor2_1_7/A sky130_fd_sc_hs__a31o_1_1/A1
+ sky130_fd_sc_hs__or2_1_2/B VSS VDD sky130_fd_sc_hs__a311oi_1
Xsky130_fd_sc_hs__dfrtp_1_250 sky130_fd_sc_hs__clkbuf_4_14/X VDD VSS sky130_fd_sc_hs__mux2_1_99/A0
+ sky130_fd_sc_hs__clkbuf_2_76/X sky130_fd_sc_hs__a22o_1_69/X VSS VDD sky130_fd_sc_hs__dfrtp_1
Xsky130_fd_sc_hs__dfrtp_1_261 sky130_fd_sc_hs__clkbuf_4_14/X VDD VSS sky130_fd_sc_hs__mux2_1_187/A1
+ sky130_fd_sc_hs__clkbuf_2_80/X sky130_fd_sc_hs__mux2_1_187/X VSS VDD sky130_fd_sc_hs__dfrtp_1
Xsky130_fd_sc_hs__dfrtp_1_272 sky130_fd_sc_hs__buf_8_8/X VDD VSS sky130_fd_sc_hs__xor2_1_50/A
+ sky130_fd_sc_hs__clkinv_1_53/A sky130_fd_sc_hs__mux2_1_189/X VSS VDD sky130_fd_sc_hs__dfrtp_1
Xsky130_fd_sc_hs__dfrtp_1_283 sky130_fd_sc_hs__buf_8_4/X VDD VSS sky130_fd_sc_hs__and3_1_5/B
+ sky130_fd_sc_hs__clkbuf_2_71/X sky130_fd_sc_hs__dfrtp_1_283/D VSS VDD sky130_fd_sc_hs__dfrtp_1
Xsky130_fd_sc_hs__dfrtp_1_294 sky130_fd_sc_hs__buf_8_4/X VDD VSS sky130_fd_sc_hs__and3_1_5/C
+ sky130_fd_sc_hs__clkbuf_2_71/X sky130_fd_sc_hs__dfrtp_1_294/D VSS VDD sky130_fd_sc_hs__dfrtp_1
Xsky130_fd_sc_hs__clkbuf_2_2 VDD VSS sky130_fd_sc_hs__clkinv_1_2/A sky130_fd_sc_hs__clkinv_4_0/A
+ VSS VDD sky130_fd_sc_hs__clkbuf_2
Xsky130_fd_sc_hs__clkinv_1_60 VDD VSS sky130_fd_sc_hs__clkinv_1_60/A sky130_fd_sc_hs__clkinv_1_60/Y
+ VSS VDD sky130_fd_sc_hs__clkinv_1
Xsky130_fd_sc_hs__a22o_1_13 VDD VSS sky130_fd_sc_hs__nor3_1_7/B sky130_fd_sc_hs__mux2_1_91/A0
+ sky130_fd_sc_hs__buf_16_7/X sky130_fd_sc_hs__a22o_1_8/B1 sky130_fd_sc_hs__maj3_1_2/B
+ VSS VDD sky130_fd_sc_hs__a22o_1
Xsky130_fd_sc_hs__clkinv_1_71 VDD VSS sky130_fd_sc_hs__clkinv_1_71/A sky130_fd_sc_hs__clkinv_1_71/Y
+ VSS VDD sky130_fd_sc_hs__clkinv_1
Xsky130_fd_sc_hs__clkinv_1_82 VDD VSS sky130_fd_sc_hs__clkinv_1_82/A sky130_fd_sc_hs__clkinv_1_82/Y
+ VSS VDD sky130_fd_sc_hs__clkinv_1
Xsky130_fd_sc_hs__a22o_1_24 VDD VSS sky130_fd_sc_hs__a22o_1_24/X sky130_fd_sc_hs__xnor2_1_42/A
+ sky130_fd_sc_hs__nor2_1_45/Y sky130_fd_sc_hs__nor2_1_45/B sky130_fd_sc_hs__a22o_1_6/B2
+ VSS VDD sky130_fd_sc_hs__a22o_1
Xsky130_fd_sc_hs__clkinv_1_93 VDD VSS sky130_fd_sc_hs__xnor2_1_99/Y sky130_fd_sc_hs__or3_1_2/B
+ VSS VDD sky130_fd_sc_hs__clkinv_1
Xsky130_fd_sc_hs__a22o_1_35 VDD VSS sky130_fd_sc_hs__a22o_1_35/X sky130_fd_sc_hs__o31a_1_1/X
+ sky130_fd_sc_hs__o21ai_1_38/Y sky130_fd_sc_hs__a32o_1_7/B1 sky130_fd_sc_hs__maj3_1_14/C
+ VSS VDD sky130_fd_sc_hs__a22o_1
Xsky130_fd_sc_hs__o21ai_1_0 VDD VSS sky130_fd_sc_hs__o21ai_1_0/Y sky130_fd_sc_hs__nand2_1_8/A
+ sky130_fd_sc_hs__nor2_1_3/Y sky130_fd_sc_hs__nor3_1_4/B VSS VDD sky130_fd_sc_hs__o21ai_1
Xsky130_fd_sc_hs__a22o_1_46 VDD VSS sky130_fd_sc_hs__a22o_1_46/X sky130_fd_sc_hs__a22o_1_72/A1
+ sky130_fd_sc_hs__a22o_1_93/B1 sky130_fd_sc_hs__a22o_1_93/A2 sky130_fd_sc_hs__maj3_1_24/C
+ VSS VDD sky130_fd_sc_hs__a22o_1
Xsky130_fd_sc_hs__clkbuf_2_13 VDD VSS sky130_fd_sc_hs__clkbuf_2_13/X sky130_fd_sc_hs__clkbuf_2_3/A
+ VSS VDD sky130_fd_sc_hs__clkbuf_2
Xsky130_fd_sc_hs__a22o_1_57 VDD VSS sky130_fd_sc_hs__a22o_1_57/X sky130_fd_sc_hs__a22o_1_63/A1
+ sky130_fd_sc_hs__a22o_1_93/B1 sky130_fd_sc_hs__a22o_1_93/A2 sky130_fd_sc_hs__xor2_1_45/A
+ VSS VDD sky130_fd_sc_hs__a22o_1
Xsky130_fd_sc_hs__clkbuf_2_24 VDD VSS sky130_fd_sc_hs__clkbuf_2_24/X sky130_fd_sc_hs__clkbuf_2_3/A
+ VSS VDD sky130_fd_sc_hs__clkbuf_2
Xsky130_fd_sc_hs__a22o_1_68 VDD VSS sky130_fd_sc_hs__a22o_1_68/X sky130_fd_sc_hs__mux2_1_9/A1
+ sky130_fd_sc_hs__buf_8_17/X sky130_fd_sc_hs__buf_8_15/X sky130_fd_sc_hs__a22o_1_68/A1
+ VSS VDD sky130_fd_sc_hs__a22o_1
Xsky130_fd_sc_hs__a22o_1_79 VDD VSS sky130_fd_sc_hs__a22o_1_79/X sky130_fd_sc_hs__a22o_1_84/A1
+ sky130_fd_sc_hs__buf_8_16/A sky130_fd_sc_hs__buf_8_18/A sky130_fd_sc_hs__maj3_1_37/C
+ VSS VDD sky130_fd_sc_hs__a22o_1
Xsky130_fd_sc_hs__clkbuf_2_35 VDD VSS sky130_fd_sc_hs__clkbuf_2_35/X sky130_fd_sc_hs__clkbuf_2_3/A
+ VSS VDD sky130_fd_sc_hs__clkbuf_2
Xsky130_fd_sc_hs__clkbuf_2_46 VDD VSS sky130_fd_sc_hs__clkinv_1_34/A sky130_fd_sc_hs__clkinv_4_1/A
+ VSS VDD sky130_fd_sc_hs__clkbuf_2
Xsky130_fd_sc_hs__clkbuf_2_57 VDD VSS sky130_fd_sc_hs__clkinv_1_43/A sky130_fd_sc_hs__clkinv_4_1/A
+ VSS VDD sky130_fd_sc_hs__clkbuf_2
Xsky130_fd_sc_hs__clkbuf_2_68 VDD VSS sky130_fd_sc_hs__dfstp_1_0/CLK sky130_fd_sc_hs__clkinv_4_2/A
+ VSS VDD sky130_fd_sc_hs__clkbuf_2
Xsky130_fd_sc_hs__clkbuf_2_79 VDD VSS sky130_fd_sc_hs__clkinv_1_52/A sky130_fd_sc_hs__clkbuf_2_92/A
+ VSS VDD sky130_fd_sc_hs__clkbuf_2
Xsky130_fd_sc_hs__nand4_1_7 VDD VSS sky130_fd_sc_hs__nor3_1_37/C sky130_fd_sc_hs__nand4_1_7/Y
+ sky130_fd_sc_hs__nand4_1_7/D sky130_fd_sc_hs__nor3_1_37/B sky130_fd_sc_hs__nor3_1_37/A
+ VSS VDD sky130_fd_sc_hs__nand4_1
Xsky130_fd_sc_hs__maj3_1_19 VDD VSS sky130_fd_sc_hs__xor2_1_34/A sky130_fd_sc_hs__xor2_1_34/B
+ sky130_fd_sc_hs__maj3_1_19/X sky130_fd_sc_hs__maj3_1_19/C VSS VDD sky130_fd_sc_hs__maj3_1
Xsky130_fd_sc_hs__clkinv_2_2 VDD VSS sky130_fd_sc_hs__clkinv_2_2/Y sky130_fd_sc_hs__clkinv_2_2/A
+ VSS VDD sky130_fd_sc_hs__clkinv_2
Xsky130_fd_sc_hs__mux2_1_210 VDD VSS sky130_fd_sc_hs__mux2_1_210/X sky130_fd_sc_hs__nor2_1_82/B
+ sky130_fd_sc_hs__xor2_1_34/A sky130_fd_sc_hs__nor2_1_62/Y VSS VDD sky130_fd_sc_hs__mux2_1
Xsky130_fd_sc_hs__mux2_1_221 VDD VSS sky130_fd_sc_hs__mux2_1_221/X sky130_fd_sc_hs__nor2_1_66/B
+ sky130_fd_sc_hs__xor2_1_38/B sky130_fd_sc_hs__nor2_1_64/Y VSS VDD sky130_fd_sc_hs__mux2_1
Xsky130_fd_sc_hs__nand2_1_13 VDD VSS sky130_fd_sc_hs__nand2_1_13/B sky130_fd_sc_hs__nor3_1_7/C
+ sky130_fd_sc_hs__nand2_1_13/A VSS VDD sky130_fd_sc_hs__nand2_1
Xsky130_fd_sc_hs__mux2_1_232 VDD VSS sky130_fd_sc_hs__mux2_1_232/X sky130_fd_sc_hs__buf_16_13/A
+ sky130_fd_sc_hs__or2_1_15/B sky130_fd_sc_hs__a22o_1_67/B2 VSS VDD sky130_fd_sc_hs__mux2_1
Xsky130_fd_sc_hs__nand2_1_24 VDD VSS sky130_fd_sc_hs__nand2_1_24/B sky130_fd_sc_hs__nand2_1_24/Y
+ sky130_fd_sc_hs__nand2_1_24/A VSS VDD sky130_fd_sc_hs__nand2_1
Xsky130_fd_sc_hs__mux2_1_243 VDD VSS sky130_fd_sc_hs__mux2_1_243/X sky130_fd_sc_hs__mux2_1_341/S
+ sky130_fd_sc_hs__dfrtp_2_1/Q sky130_fd_sc_hs__a222o_1_4/C2 VSS VDD sky130_fd_sc_hs__mux2_1
Xsky130_fd_sc_hs__nand2_1_35 VDD VSS sky130_fd_sc_hs__and2_1_9/A sky130_fd_sc_hs__nand2_1_35/Y
+ sky130_fd_sc_hs__nor2_1_26/A VSS VDD sky130_fd_sc_hs__nand2_1
Xsky130_fd_sc_hs__mux2_1_254 VDD VSS sky130_fd_sc_hs__mux2_1_254/X sky130_fd_sc_hs__o21a_1_29/B1
+ sky130_fd_sc_hs__buf_1_133/A sky130_fd_sc_hs__nor2b_1_45/A VSS VDD sky130_fd_sc_hs__mux2_1
Xsky130_fd_sc_hs__nand2_1_46 VDD VSS sky130_fd_sc_hs__and2_1_9/B sky130_fd_sc_hs__nand3b_1_1/C
+ sky130_fd_sc_hs__and2_1_9/A VSS VDD sky130_fd_sc_hs__nand2_1
Xsky130_fd_sc_hs__mux2_1_265 VDD VSS sky130_fd_sc_hs__mux2_1_265/X sky130_fd_sc_hs__buf_8_23/X
+ sky130_fd_sc_hs__mux2_1_265/A0 sky130_fd_sc_hs__a22o_1_62/B2 VSS VDD sky130_fd_sc_hs__mux2_1
Xsky130_fd_sc_hs__nand2_1_57 VDD VSS sky130_fd_sc_hs__nand3_1_18/C sky130_fd_sc_hs__nor2_1_45/B
+ sky130_fd_sc_hs__o32a_1_0/A3 VSS VDD sky130_fd_sc_hs__nand2_1
Xsky130_fd_sc_hs__mux2_1_276 VDD VSS sky130_fd_sc_hs__mux2_1_276/X sky130_fd_sc_hs__or3_1_6/X
+ sky130_fd_sc_hs__a22o_1_84/B2 sky130_fd_sc_hs__mux2_1_276/A1 VSS VDD sky130_fd_sc_hs__mux2_1
Xsky130_fd_sc_hs__nand2_1_68 VDD VSS sky130_fd_sc_hs__nand3_1_17/Y sky130_fd_sc_hs__nor3_1_17/C
+ sky130_fd_sc_hs__nor2_1_40/B VSS VDD sky130_fd_sc_hs__nand2_1
Xsky130_fd_sc_hs__mux2_1_287 VDD VSS sky130_fd_sc_hs__mux2_1_287/X sky130_fd_sc_hs__or3_1_6/X
+ sky130_fd_sc_hs__mux2_1_473/A1 sky130_fd_sc_hs__mux2_1_287/A1 VSS VDD sky130_fd_sc_hs__mux2_1
Xsky130_fd_sc_hs__nand2_1_79 VDD VSS sky130_fd_sc_hs__or2_1_12/B sky130_fd_sc_hs__nand2_1_79/Y
+ sky130_fd_sc_hs__xor2_1_43/A VSS VDD sky130_fd_sc_hs__nand2_1
Xsky130_fd_sc_hs__mux2_1_298 VDD VSS sky130_fd_sc_hs__mux2_1_298/X sky130_fd_sc_hs__buf_8_24/X
+ sky130_fd_sc_hs__a22o_1_61/B2 sky130_fd_sc_hs__mux2_1_298/A1 VSS VDD sky130_fd_sc_hs__mux2_1
Xsky130_fd_sc_hs__dlygate4sd3_1_14 VSS VDD raw_bits_i[4] sky130_fd_sc_hs__buf_1_92/A
+ VSS VDD sky130_fd_sc_hs__dlygate4sd3_1
Xsky130_fd_sc_hs__dlygate4sd3_1_25 VSS VDD raw_bits_i[17] sky130_fd_sc_hs__buf_1_186/A
+ VSS VDD sky130_fd_sc_hs__dlygate4sd3_1
Xsky130_fd_sc_hs__xor3_1_0 VDD VSS sky130_fd_sc_hs__xor3_1_0/B sky130_fd_sc_hs__xor3_1_0/C
+ sky130_fd_sc_hs__xor3_1_0/A sky130_fd_sc_hs__xor3_1_0/X VSS VDD sky130_fd_sc_hs__xor3_1
Xsky130_fd_sc_hs__o21ai_1_14 VDD VSS sky130_fd_sc_hs__o21ai_1_14/Y sky130_fd_sc_hs__buf_8_2/X
+ sky130_fd_sc_hs__buf_8_10/X sky130_fd_sc_hs__maj3_1_5/A VSS VDD sky130_fd_sc_hs__o21ai_1
Xsky130_fd_sc_hs__o21ai_1_25 VDD VSS sky130_fd_sc_hs__o21ai_1_25/Y sky130_fd_sc_hs__o311ai_1_6/Y
+ sky130_fd_sc_hs__buf_16_3/X sky130_fd_sc_hs__o41ai_1_3/A2 VSS VDD sky130_fd_sc_hs__o21ai_1
Xsky130_fd_sc_hs__o21ai_1_36 VDD VSS sky130_fd_sc_hs__o21ai_1_36/Y sky130_fd_sc_hs__nand2_1_92/Y
+ sky130_fd_sc_hs__nor3_1_15/A sky130_fd_sc_hs__and3_1_6/A VSS VDD sky130_fd_sc_hs__o21ai_1
Xsky130_fd_sc_hs__o21ai_1_47 VDD VSS sky130_fd_sc_hs__o21ai_1_47/Y sky130_fd_sc_hs__buf_8_2/X
+ sky130_fd_sc_hs__buf_8_10/A sky130_fd_sc_hs__xor2_1_53/A VSS VDD sky130_fd_sc_hs__o21ai_1
Xsky130_fd_sc_hs__o21ai_1_58 VDD VSS sky130_fd_sc_hs__o21ai_1_58/Y sky130_fd_sc_hs__nor4b_1_1/Y
+ sky130_fd_sc_hs__and2_1_32/B sky130_fd_sc_hs__nor2_4_3/A VSS VDD sky130_fd_sc_hs__o21ai_1
Xsky130_fd_sc_hs__o21ai_1_69 VDD VSS sky130_fd_sc_hs__o21ai_1_69/Y sky130_fd_sc_hs__buf_1_52/A
+ sky130_fd_sc_hs__o21a_1_29/X sky130_fd_sc_hs__or3_1_1/X VSS VDD sky130_fd_sc_hs__o21ai_1
Xsky130_fd_sc_hs__clkbuf_8_12 VDD VSS sky130_fd_sc_hs__nand2_1_200/B sky130_fd_sc_hs__nor2_2_11/Y
+ VSS VDD sky130_fd_sc_hs__clkbuf_8
Xsky130_fd_sc_hs__o211ai_1_14 VDD VSS sky130_fd_sc_hs__a21bo_1_0/X sky130_fd_sc_hs__and3_1_14/C
+ sky130_fd_sc_hs__o21ai_1_95/B1 sky130_fd_sc_hs__xnor2_1_131/Y sky130_fd_sc_hs__o21a_1_31/X
+ VSS VDD sky130_fd_sc_hs__o211ai_1
Xsky130_fd_sc_hs__and4_1_2 VDD VSS sky130_fd_sc_hs__and4_1_2/A sky130_fd_sc_hs__and4_1_2/B
+ sky130_fd_sc_hs__and4_1_2/C sky130_fd_sc_hs__and4_1_2/D sky130_fd_sc_hs__and4_1_2/X
+ VSS VDD sky130_fd_sc_hs__and4_1
Xsky130_fd_sc_hs__dfrtp_1_805 sky130_fd_sc_hs__clkbuf_4_23/A VDD VSS sky130_fd_sc_hs__maj3_1_35/C
+ sky130_fd_sc_hs__clkbuf_2_129/A sky130_fd_sc_hs__mux2_1_239/X VSS VDD sky130_fd_sc_hs__dfrtp_1
Xsky130_fd_sc_hs__dfrtp_1_816 sky130_fd_sc_hs__buf_8_8/A VDD VSS sky130_fd_sc_hs__mux2_1_204/A0
+ sky130_fd_sc_hs__clkinv_1_19/A sky130_fd_sc_hs__mux2_1_204/X VSS VDD sky130_fd_sc_hs__dfrtp_1
Xsky130_fd_sc_hs__dfrtp_1_827 sky130_fd_sc_hs__buf_8_38/A VDD VSS sky130_fd_sc_hs__mux2_1_154/A0
+ sky130_fd_sc_hs__clkinv_1_40/A sky130_fd_sc_hs__mux2_1_154/X VSS VDD sky130_fd_sc_hs__dfrtp_1
Xsky130_fd_sc_hs__a21oi_1_102 VDD VSS sky130_fd_sc_hs__clkinv_1_80/Y sky130_fd_sc_hs__o31a_1_2/A1
+ sky130_fd_sc_hs__and2_1_26/X sky130_fd_sc_hs__xnor2_1_89/Y VSS VDD sky130_fd_sc_hs__a21oi_1
Xsky130_fd_sc_hs__a21oi_1_113 VDD VSS sky130_fd_sc_hs__a31o_1_14/A3 sky130_fd_sc_hs__o221ai_1_1/B1
+ sky130_fd_sc_hs__a31o_1_14/A2 sky130_fd_sc_hs__a31o_1_14/A1 VSS VDD sky130_fd_sc_hs__a21oi_1
Xsky130_fd_sc_hs__a21oi_1_124 VDD VSS sky130_fd_sc_hs__clkinv_1_96/Y sky130_fd_sc_hs__xnor2_1_102/A
+ sky130_fd_sc_hs__or2_1_19/B sky130_fd_sc_hs__or2_1_19/A VSS VDD sky130_fd_sc_hs__a21oi_1
Xsky130_fd_sc_hs__a21oi_1_135 VDD VSS sky130_fd_sc_hs__buf_8_12/A sky130_fd_sc_hs__a21oi_1_135/Y
+ sky130_fd_sc_hs__xor2_1_74/X sky130_fd_sc_hs__maj3_1_48/C VSS VDD sky130_fd_sc_hs__a21oi_1
Xsky130_fd_sc_hs__a21oi_1_146 VDD VSS sky130_fd_sc_hs__nor3_4_9/C sky130_fd_sc_hs__nor2_1_124/A
+ sky130_fd_sc_hs__a22oi_1_61/Y sky130_fd_sc_hs__a22oi_1_68/Y VSS VDD sky130_fd_sc_hs__a21oi_1
Xsky130_fd_sc_hs__a21oi_1_157 VDD VSS sky130_fd_sc_hs__nor2_1_138/Y sky130_fd_sc_hs__dfrtp_1_487/D
+ sky130_fd_sc_hs__o21ai_1_93/Y sky130_fd_sc_hs__buf_8_21/X VSS VDD sky130_fd_sc_hs__a21oi_1
Xsky130_fd_sc_hs__a21oi_1_168 VDD VSS sky130_fd_sc_hs__nor2_1_139/Y sky130_fd_sc_hs__dfrtp_1_494/D
+ sky130_fd_sc_hs__nor2_1_155/Y sky130_fd_sc_hs__o21a_1_26/A2 VSS VDD sky130_fd_sc_hs__a21oi_1
Xsky130_fd_sc_hs__a21oi_1_179 VDD VSS sky130_fd_sc_hs__a21oi_1_174/Y sky130_fd_sc_hs__dfrtp_1_577/D
+ sky130_fd_sc_hs__buf_4_6/X sky130_fd_sc_hs__or3_1_6/A VSS VDD sky130_fd_sc_hs__a21oi_1
Xsky130_fd_sc_hs__clkbuf_2_140 VDD VSS sky130_fd_sc_hs__clkbuf_2_140/X sky130_fd_sc_hs__buf_1_128/A
+ VSS VDD sky130_fd_sc_hs__clkbuf_2
Xsky130_fd_sc_hs__clkbuf_2_151 VDD VSS sky130_fd_sc_hs__clkinv_1_103/A sky130_fd_sc_hs__inv_8_1/A
+ VSS VDD sky130_fd_sc_hs__clkbuf_2
Xsky130_fd_sc_hs__clkbuf_2_162 VDD VSS sky130_fd_sc_hs__clkinv_1_112/A sky130_fd_sc_hs__clkbuf_2_176/A
+ VSS VDD sky130_fd_sc_hs__clkbuf_2
Xsky130_fd_sc_hs__nand2_1_140 VDD VSS sky130_fd_sc_hs__and2_1_34/B sky130_fd_sc_hs__o21a_1_27/B1
+ sky130_fd_sc_hs__and2_1_34/A VSS VDD sky130_fd_sc_hs__nand2_1
Xsky130_fd_sc_hs__clkbuf_2_173 VDD VSS sky130_fd_sc_hs__clkinv_1_127/A sky130_fd_sc_hs__clkbuf_2_176/A
+ VSS VDD sky130_fd_sc_hs__clkbuf_2
Xsky130_fd_sc_hs__nand2_1_151 VDD VSS sky130_fd_sc_hs__nor2b_1_40/Y sky130_fd_sc_hs__mux2i_1_10/S
+ sky130_fd_sc_hs__nand4_1_6/D VSS VDD sky130_fd_sc_hs__nand2_1
Xsky130_fd_sc_hs__clkbuf_2_184 VDD VSS sky130_fd_sc_hs__clkbuf_2_184/X sky130_fd_sc_hs__clkbuf_2_185/X
+ VSS VDD sky130_fd_sc_hs__clkbuf_2
Xsky130_fd_sc_hs__nand2_1_162 VDD VSS sky130_fd_sc_hs__and2_1_37/X sky130_fd_sc_hs__nand2_1_162/Y
+ sky130_fd_sc_hs__nor2b_1_50/Y VSS VDD sky130_fd_sc_hs__nand2_1
Xsky130_fd_sc_hs__clkbuf_2_195 VDD VSS sky130_fd_sc_hs__clkbuf_2_195/X sky130_fd_sc_hs__clkbuf_2_236/A
+ VSS VDD sky130_fd_sc_hs__clkbuf_2
Xsky130_fd_sc_hs__nand2_1_173 VDD VSS sky130_fd_sc_hs__or3_1_2/X sky130_fd_sc_hs__a31o_1_12/A1
+ sky130_fd_sc_hs__nand2b_1_44/Y VSS VDD sky130_fd_sc_hs__nand2_1
Xsky130_fd_sc_hs__nand2_1_184 VDD VSS sky130_fd_sc_hs__a22oi_1_75/Y sky130_fd_sc_hs__nor3_1_49/C
+ sky130_fd_sc_hs__a22oi_1_74/Y VSS VDD sky130_fd_sc_hs__nand2_1
Xsky130_fd_sc_hs__nand2_1_195 VDD VSS sky130_fd_sc_hs__nand2_1_195/B sky130_fd_sc_hs__and2_1_38/B
+ sky130_fd_sc_hs__nand2_1_195/A VSS VDD sky130_fd_sc_hs__nand2_1
Xsky130_fd_sc_hs__maj3_1_0 VDD VSS sky130_fd_sc_hs__maj3_1_0/A sky130_fd_sc_hs__maj3_1_0/B
+ sky130_fd_sc_hs__xor2_1_8/A sky130_fd_sc_hs__maj3_1_0/C VSS VDD sky130_fd_sc_hs__maj3_1
Xsky130_fd_sc_hs__clkinv_1_107 VDD VSS sky130_fd_sc_hs__nor2_1_150/A sky130_fd_sc_hs__o22ai_1_8/A1
+ VSS VDD sky130_fd_sc_hs__clkinv_1
Xsky130_fd_sc_hs__clkinv_1_118 VDD VSS sky130_fd_sc_hs__dfstp_1_1/CLK sky130_fd_sc_hs__clkinv_1_118/Y
+ VSS VDD sky130_fd_sc_hs__clkinv_1
Xsky130_fd_sc_hs__clkinv_1_129 VDD VSS sky130_fd_sc_hs__clkinv_1_129/A sky130_fd_sc_hs__clkinv_1_129/Y
+ VSS VDD sky130_fd_sc_hs__clkinv_1
Xsky130_fd_sc_hs__nor2_2_1 VDD VSS sky130_fd_sc_hs__nor2_2_1/B sky130_fd_sc_hs__nor2_2_1/Y
+ sky130_fd_sc_hs__nor2_2_1/A VSS VDD sky130_fd_sc_hs__nor2_2
Xsky130_fd_sc_hs__buf_8_30 VDD VSS sky130_fd_sc_hs__buf_8_30/X sky130_fd_sc_hs__buf_8_30/A
+ VSS VDD sky130_fd_sc_hs__buf_8
Xsky130_fd_sc_hs__dfrtp_1_602 sky130_fd_sc_hs__clkbuf_4_30/X VDD VSS sky130_fd_sc_hs__mux2_1_308/A0
+ sky130_fd_sc_hs__clkbuf_2_179/X sky130_fd_sc_hs__mux2_1_308/X VSS VDD sky130_fd_sc_hs__dfrtp_1
Xsky130_fd_sc_hs__dfrtp_1_613 sky130_fd_sc_hs__clkbuf_4_31/X VDD VSS sky130_fd_sc_hs__mux2_1_316/A0
+ sky130_fd_sc_hs__clkbuf_2_185/X sky130_fd_sc_hs__mux2_1_316/X VSS VDD sky130_fd_sc_hs__dfrtp_1
Xsky130_fd_sc_hs__dfrtp_1_624 sky130_fd_sc_hs__clkbuf_4_31/X VDD VSS sky130_fd_sc_hs__mux2_1_330/A0
+ sky130_fd_sc_hs__clkbuf_2_192/A sky130_fd_sc_hs__mux2_1_330/X VSS VDD sky130_fd_sc_hs__dfrtp_1
Xsky130_fd_sc_hs__dfrtp_1_635 sky130_fd_sc_hs__clkbuf_4_30/X VDD VSS sky130_fd_sc_hs__mux2_1_345/A0
+ sky130_fd_sc_hs__clkinv_1_145/A sky130_fd_sc_hs__mux2_1_345/X VSS VDD sky130_fd_sc_hs__dfrtp_1
Xsky130_fd_sc_hs__dfrtp_1_646 sky130_fd_sc_hs__clkbuf_4_30/X VDD VSS sky130_fd_sc_hs__mux2_1_317/A0
+ sky130_fd_sc_hs__clkinv_1_130/A sky130_fd_sc_hs__mux2_1_317/X VSS VDD sky130_fd_sc_hs__dfrtp_1
Xsky130_fd_sc_hs__dfrtp_1_657 sky130_fd_sc_hs__clkbuf_4_33/X VDD VSS sky130_fd_sc_hs__mux2_1_364/A0
+ sky130_fd_sc_hs__clkbuf_2_202/X sky130_fd_sc_hs__mux2_1_364/X VSS VDD sky130_fd_sc_hs__dfrtp_1
Xsky130_fd_sc_hs__dfrtp_1_668 sky130_fd_sc_hs__clkbuf_4_35/X VDD VSS sky130_fd_sc_hs__nand4b_1_3/C
+ sky130_fd_sc_hs__clkinv_1_154/A sky130_fd_sc_hs__mux2_1_369/X VSS VDD sky130_fd_sc_hs__dfrtp_1
Xsky130_fd_sc_hs__dfrtp_1_679 sky130_fd_sc_hs__clkbuf_4_35/X VDD VSS sky130_fd_sc_hs__nand3_1_42/A
+ sky130_fd_sc_hs__clkinv_1_154/A sky130_fd_sc_hs__mux2_1_376/X VSS VDD sky130_fd_sc_hs__dfrtp_1
Xsky130_fd_sc_hs__dfrtp_1_9 sky130_fd_sc_hs__clkbuf_4_4/X VDD VSS sky130_fd_sc_hs__dfrtp_1_9/Q
+ sky130_fd_sc_hs__clkbuf_2_3/X sky130_fd_sc_hs__mux2_1_13/X VSS VDD sky130_fd_sc_hs__dfrtp_1
Xsky130_fd_sc_hs__a22oi_1_19 VDD VSS sky130_fd_sc_hs__mux2_1_478/A0 sky130_fd_sc_hs__nand3_1_6/B
+ sky130_fd_sc_hs__a22oi_1_7/B1 sky130_fd_sc_hs__nand2_1_51/B sky130_fd_sc_hs__mux2_1_51/A0
+ VSS VDD sky130_fd_sc_hs__a22oi_1
Xsky130_fd_sc_hs__nor2_1_10 VDD VSS sky130_fd_sc_hs__and3_1_0/X sky130_fd_sc_hs__o21a_1_1/A1
+ sky130_fd_sc_hs__nor2_1_10/A VSS VDD sky130_fd_sc_hs__nor2_1
Xsky130_fd_sc_hs__nor2_1_21 VDD VSS sky130_fd_sc_hs__nor2_1_23/Y sky130_fd_sc_hs__and3_1_1/B
+ sky130_fd_sc_hs__and2_1_6/X VSS VDD sky130_fd_sc_hs__nor2_1
Xsky130_fd_sc_hs__nor2_1_32 VDD VSS sky130_fd_sc_hs__nor2_1_32/B sky130_fd_sc_hs__nor2_1_32/Y
+ sky130_fd_sc_hs__maj3_1_9/X VSS VDD sky130_fd_sc_hs__nor2_1
Xsky130_fd_sc_hs__nor2_1_43 VDD VSS sky130_fd_sc_hs__nor2_2_1/Y sky130_fd_sc_hs__nor2_1_43/Y
+ sky130_fd_sc_hs__buf_1_63/X VSS VDD sky130_fd_sc_hs__nor2_1
Xsky130_fd_sc_hs__nor2_1_54 VDD VSS sky130_fd_sc_hs__nor2_1_54/B sky130_fd_sc_hs__nor2_1_54/Y
+ sky130_fd_sc_hs__o32a_1_0/A2 VSS VDD sky130_fd_sc_hs__nor2_1
Xsky130_fd_sc_hs__nor2_1_65 VDD VSS sky130_fd_sc_hs__nor2_1_82/B sky130_fd_sc_hs__nor2_1_65/Y
+ sky130_fd_sc_hs__xor2_1_51/A VSS VDD sky130_fd_sc_hs__nor2_1
Xsky130_fd_sc_hs__nor2_1_76 VDD VSS sky130_fd_sc_hs__nor2_1_76/B sky130_fd_sc_hs__nor2_1_76/Y
+ sky130_fd_sc_hs__buf_8_19/X VSS VDD sky130_fd_sc_hs__nor2_1
Xsky130_fd_sc_hs__nor2_1_87 VDD VSS sky130_fd_sc_hs__nor2_1_87/B sky130_fd_sc_hs__nor2_1_87/Y
+ sky130_fd_sc_hs__nor3_1_22/A VSS VDD sky130_fd_sc_hs__nor2_1
Xsky130_fd_sc_hs__nor2_1_98 VDD VSS sky130_fd_sc_hs__nor2_1_98/B sky130_fd_sc_hs__nor3_1_24/C
+ sky130_fd_sc_hs__nor2_1_98/A VSS VDD sky130_fd_sc_hs__nor2_1
.ends
