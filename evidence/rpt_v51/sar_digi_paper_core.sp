* SPICE NETLIST
***************************************

.SUBCKT nmvt18_ckt D G S B
.ENDS
***************************************
.SUBCKT nmvt33_ckt D G S B
.ENDS
***************************************
.SUBCKT pmvt18_ckt D G S B
.ENDS
***************************************
.SUBCKT nnt18_ckt D G S B
.ENDS
***************************************
.SUBCKT nnt33_ckt D G S B
.ENDS
***************************************
.SUBCKT n18_ckt D G S B
.ENDS
***************************************
.SUBCKT n18_dnw_ckt D G S B T B2
.ENDS
***************************************
.SUBCKT n18_dnw_4t_ckt D G S B
.ENDS
***************************************
.SUBCKT p18_ckt D G S B
.ENDS
***************************************
.SUBCKT p18_dnw_ckt D G S B B2
.ENDS
***************************************
.SUBCKT p18_dnw_4t_ckt D G S B
.ENDS
***************************************
.SUBCKT n33_ckt D G S B
.ENDS
***************************************
.SUBCKT n33_dnw_ckt D G S B T B2
.ENDS
***************************************
.SUBCKT n33_dnw_4t_ckt D G S B
.ENDS
***************************************
.SUBCKT p33_ckt D G S B
.ENDS
***************************************
.SUBCKT p33_dnw_ckt D G S B B2
.ENDS
***************************************
.SUBCKT p33_dnw_4t_ckt D G S B
.ENDS
***************************************
.SUBCKT pvar18_ckt PLUS MINUS
.ENDS
***************************************
.SUBCKT pvar33_ckt PLUS MINUS
.ENDS
***************************************
.SUBCKT pnp18a4_mis_ckt C B E
.ENDS
***************************************
.SUBCKT pnp18a25_mis_ckt C B E
.ENDS
***************************************
.SUBCKT pnp18a100_mis_ckt C B E
.ENDS
***************************************
.SUBCKT pnp33a4_mis_ckt C B E
.ENDS
***************************************
.SUBCKT pnp33a25_mis_ckt C B E
.ENDS
***************************************
.SUBCKT pnp33a100_mis_ckt C B E
.ENDS
***************************************
.SUBCKT npn18a4_mis_ckt C B E SUB
.ENDS
***************************************
.SUBCKT npn18a25_mis_ckt C B E SUB
.ENDS
***************************************
.SUBCKT npn18a100_mis_ckt C B E SUB
.ENDS
***************************************
.SUBCKT npn33a4_mis_ckt C B E SUB
.ENDS
***************************************
.SUBCKT npn33a25_mis_ckt C B E SUB
.ENDS
***************************************
.SUBCKT npn33a100_mis_ckt C B E SUB
.ENDS
***************************************
.SUBCKT EFUSE_res PLUS MINUS
.ENDS
***************************************
.SUBCKT rnwaa_ckt PLUS MINUS SUB
.ENDS
***************************************
.SUBCKT rnwsti_ckt PLUS MINUS SUB
.ENDS
***************************************
.SUBCKT rpdif_ckt PLUS MINUS SUB
.ENDS
***************************************
.SUBCKT rndif_ckt PLUS MINUS SUB
.ENDS
***************************************
.SUBCKT rppo_ckt PLUS MINUS
.ENDS
***************************************
.SUBCKT rppo_3t_ckt PLUS MINUS SUB
.ENDS
***************************************
.SUBCKT rnpo_ckt PLUS MINUS
.ENDS
***************************************
.SUBCKT rnpo_3t_ckt PLUS MINUS SUB
.ENDS
***************************************
.SUBCKT rpdifsab_ckt PLUS MINUS SUB
.ENDS
***************************************
.SUBCKT rndifsab_ckt PLUS MINUS SUB
.ENDS
***************************************
.SUBCKT rpposab_ckt PLUS MINUS
.ENDS
***************************************
.SUBCKT rpposab_3t_ckt PLUS MINUS SUB
.ENDS
***************************************
.SUBCKT rnposab_ckt PLUS MINUS
.ENDS
***************************************
.SUBCKT rnposab_3t_ckt PLUS MINUS SUB
.ENDS
***************************************
.SUBCKT rhrpo_ckt PLUS MINUS
.ENDS
***************************************
.SUBCKT rhrpo_3t_ckt PLUS MINUS SUB
.ENDS
***************************************
.SUBCKT mim_ckt PLUS MINUS
.ENDS
***************************************
.SUBCKT CLKINVX1 A VDD VSS Y
** N=4 EP=4 IP=0 FDC=2
M0 Y A VSS VSS n18 L=1.8e-07 W=3.6e-07 $X=10000 $Y=9900 $D=6
M1 Y A VDD VDD p18 L=1.8e-07 W=9e-07 $X=8400 $Y=29350 $D=10
.ENDS
***************************************
.SUBCKT NAND2XL B VSS VDD A Y
** N=6 EP=5 IP=0 FDC=4
M0 6 B VSS VSS n18 L=1.8e-07 W=5.6e-07 $X=6200 $Y=11200 $D=6
M1 Y A 6 VSS n18 L=1.8e-07 W=5.6e-07 $X=11800 $Y=11200 $D=6
M2 Y B VDD VDD p18 L=1.8e-07 W=6.4e-07 $X=5500 $Y=29750 $D=10
M3 VDD A Y VDD p18 L=1.8e-07 W=6.4e-07 $X=12700 $Y=29750 $D=10
.ENDS
***************************************
.SUBCKT NOR2XL VDD B A Y VSS
** N=6 EP=5 IP=0 FDC=4
M0 Y B VSS VSS n18 L=1.8e-07 W=4e-07 $X=5000 $Y=11000 $D=6
M1 VSS A Y VSS n18 L=1.8e-07 W=4e-07 $X=13000 $Y=11000 $D=6
M2 6 B VDD VDD p18 L=1.8e-07 W=8.4e-07 $X=6200 $Y=28100 $D=10
M3 Y A 6 VDD p18 L=1.8e-07 W=8.4e-07 $X=11800 $Y=28100 $D=10
.ENDS
***************************************
.SUBCKT INVXL A VDD VSS Y
** N=4 EP=4 IP=0 FDC=2
M0 Y A VSS VSS n18 L=1.8e-07 W=4.2e-07 $X=4600 $Y=13100 $D=6
M1 Y A VDD VDD p18 L=1.8e-07 W=6.4e-07 $X=4600 $Y=27350 $D=10
.ENDS
***************************************
.SUBCKT OAI21XL A1 VSS A0 B0 VDD Y
** N=8 EP=6 IP=0 FDC=6
M0 VSS A1 7 VSS n18 L=1.8e-07 W=5.6e-07 $X=6200 $Y=12050 $D=6
M1 7 A0 VSS VSS n18 L=1.8e-07 W=5.6e-07 $X=12200 $Y=12800 $D=6
M2 Y B0 7 VSS n18 L=1.8e-07 W=4.9e-07 $X=19400 $Y=13500 $D=6
M3 8 A1 VDD VDD p18 L=1.8e-07 W=8.4e-07 $X=6200 $Y=33000 $D=10
M4 Y A0 8 VDD p18 L=1.8e-07 W=8.4e-07 $X=11800 $Y=33000 $D=10
M5 VDD B0 Y VDD p18 L=1.8e-07 W=6.4e-07 $X=19000 $Y=33000 $D=10
.ENDS
***************************************
.SUBCKT AOI21XL A1 A0 VDD B0 5 VSS Y
** N=8 EP=7 IP=0 FDC=6
M0 8 A1 VSS VSS n18 L=1.8e-07 W=5.6e-07 $X=6200 $Y=10050 $D=6
M1 Y A0 8 VSS n18 L=1.8e-07 W=5.6e-07 $X=11800 $Y=10050 $D=6
M2 VSS B0 Y VSS n18 L=1.8e-07 W=4.2e-07 $X=19000 $Y=11450 $D=6
M3 VDD A1 5 VDD p18 L=1.8e-07 W=8.4e-07 $X=6200 $Y=28950 $D=10
M4 5 A0 VDD VDD p18 L=1.8e-07 W=8.4e-07 $X=12200 $Y=28950 $D=10
M5 Y B0 5 VDD p18 L=1.8e-07 W=8.4e-07 $X=18200 $Y=28950 $D=10
.ENDS
***************************************
.SUBCKT DFFSXL CK D 3 4 SN 6 QN VSS Q VDD
** N=24 EP=10 IP=0 FDC=34
M0 VSS CK 4 VSS n18 L=1.8e-07 W=3e-07 $X=6700 $Y=12100 $D=6
M1 15 D VSS VSS n18 L=1.8e-07 W=5.6e-07 $X=16750 $Y=7100 $D=6
M2 3 4 15 VSS n18 L=1.8e-07 W=5.6e-07 $X=22350 $Y=7100 $D=6
M3 16 12 3 VSS n18 L=1.8e-07 W=3e-07 $X=29100 $Y=15100 $D=6
M4 VSS 11 16 VSS n18 L=1.8e-07 W=3e-07 $X=34700 $Y=15100 $D=6
M5 17 SN VSS VSS n18 L=1.8e-07 W=3.6e-07 $X=40800 $Y=14800 $D=6
M6 11 3 17 VSS n18 L=1.8e-07 W=3.6e-07 $X=46400 $Y=14800 $D=6
M7 VSS 4 12 VSS n18 L=1.8e-07 W=3e-07 $X=55600 $Y=7000 $D=6
M8 18 11 VSS VSS n18 L=1.8e-07 W=5.6e-07 $X=61600 $Y=14000 $D=6
M9 13 12 18 VSS n18 L=1.8e-07 W=5.6e-07 $X=67200 $Y=14000 $D=6
M10 19 4 13 VSS n18 L=1.8e-07 W=3e-07 $X=73200 $Y=7800 $D=6
M11 VSS 6 19 VSS n18 L=1.8e-07 W=3e-07 $X=79000 $Y=7800 $D=6
M12 20 13 6 VSS n18 L=1.8e-07 W=3.6e-07 $X=90000 $Y=13600 $D=6
M13 VSS SN 20 VSS n18 L=1.8e-07 W=3.6e-07 $X=95600 $Y=13600 $D=6
M14 QN 6 VSS VSS n18 L=1.8e-07 W=4.2e-07 $X=103250 $Y=7150 $D=6
M15 14 6 VSS VSS n18 L=1.8e-07 W=3e-07 $X=103250 $Y=14900 $D=6
M16 Q 14 VSS VSS n18 L=1.8e-07 W=4.2e-07 $X=116250 $Y=12100 $D=6
M17 VDD CK 4 VDD p18 L=1.8e-07 W=4.2e-07 $X=6400 $Y=31800 $D=10
M18 21 D VDD VDD p18 L=1.8e-07 W=8.4e-07 $X=14200 $Y=27600 $D=10
M19 3 12 21 VDD p18 L=1.8e-07 W=8.4e-07 $X=19800 $Y=27600 $D=10
M20 22 4 3 VDD p18 L=1.8e-07 W=4.2e-07 $X=27400 $Y=31600 $D=10
M21 VDD 11 22 VDD p18 L=1.8e-07 W=4.2e-07 $X=33000 $Y=31600 $D=10
M22 11 SN VDD VDD p18 L=1.8e-07 W=4.2e-07 $X=39000 $Y=31600 $D=10
M23 VDD 3 11 VDD p18 L=1.8e-07 W=4.2e-07 $X=47000 $Y=30600 $D=10
M24 12 4 VDD VDD p18 L=1.8e-07 W=4.2e-07 $X=53000 $Y=30600 $D=10
M25 23 11 VDD VDD p18 L=1.8e-07 W=8.4e-07 $X=65600 $Y=29400 $D=10
M26 13 4 23 VDD p18 L=1.8e-07 W=8.4e-07 $X=71200 $Y=29400 $D=10
M27 24 12 13 VDD p18 L=1.8e-07 W=3e-07 $X=78800 $Y=33700 $D=10
M28 VDD 6 24 VDD p18 L=1.8e-07 W=3e-07 $X=84400 $Y=33700 $D=10
M29 6 13 VDD VDD p18 L=1.8e-07 W=4.2e-07 $X=90400 $Y=31300 $D=10
M30 VDD SN 6 VDD p18 L=1.8e-07 W=4.2e-07 $X=97600 $Y=31300 $D=10
M31 14 6 VDD VDD p18 L=1.8e-07 W=4.2e-07 $X=104800 $Y=31300 $D=10
M32 QN 6 VDD VDD p18 L=1.8e-07 W=6.4e-07 $X=104800 $Y=38300 $D=10
M33 Q 14 VDD VDD p18 L=1.8e-07 W=6.4e-07 $X=117400 $Y=29400 $D=10
.ENDS
***************************************
.SUBCKT NAND2BXL AN VSS B 4 VDD Y
** N=7 EP=6 IP=0 FDC=6
M0 VSS AN 4 VSS n18 L=1.8e-07 W=3e-07 $X=6600 $Y=11550 $D=6
M1 7 B VSS VSS n18 L=1.8e-07 W=5.6e-07 $X=12600 $Y=8950 $D=6
M2 Y 4 7 VSS n18 L=1.8e-07 W=5.6e-07 $X=18200 $Y=8950 $D=6
M3 VDD AN 4 VDD p18 L=1.8e-07 W=4.2e-07 $X=6200 $Y=30700 $D=10
M4 Y B VDD VDD p18 L=1.8e-07 W=6.4e-07 $X=12200 $Y=30700 $D=10
M5 VDD 4 Y VDD p18 L=1.8e-07 W=6.4e-07 $X=19400 $Y=30700 $D=10
.ENDS
***************************************
.SUBCKT XOR2XL B A VSS VDD Y
** N=9 EP=5 IP=0 FDC=12
M0 VSS A 6 VSS n18 L=1.8e-07 W=3e-07 $X=7150 $Y=10800 $D=6
M1 8 B VSS VSS n18 L=1.8e-07 W=3e-07 $X=13650 $Y=10800 $D=6
M2 9 6 8 VSS n18 L=1.8e-07 W=5.6e-07 $X=23900 $Y=10800 $D=6
M3 7 A 9 VSS n18 L=1.8e-07 W=5.6e-07 $X=31200 $Y=10800 $D=6
M4 VSS 8 7 VSS n18 L=1.8e-07 W=3e-07 $X=38800 $Y=12500 $D=6
M5 Y 9 VSS VSS n18 L=1.8e-07 W=4.6e-07 $X=44800 $Y=10900 $D=6
M6 VDD A 6 VDD p18 L=1.8e-07 W=4.2e-07 $X=6200 $Y=33600 $D=10
M7 8 B VDD VDD p18 L=1.8e-07 W=4.6e-07 $X=12900 $Y=33600 $D=10
M8 9 A 8 VDD p18 L=1.8e-07 W=8.4e-07 $X=23900 $Y=28300 $D=10
M9 7 6 9 VDD p18 L=1.8e-07 W=8.4e-07 $X=31200 $Y=28300 $D=10
M10 VDD 8 7 VDD p18 L=1.8e-07 W=4.6e-07 $X=38800 $Y=29600 $D=10
M11 Y 9 VDD VDD p18 L=1.8e-07 W=6.4e-07 $X=44800 $Y=29600 $D=10
.ENDS
***************************************
.SUBCKT CMPR32X1 B A 3 C 5 6 7 CO VSS VDD S
** N=15 EP=11 IP=0 FDC=30
M0 VSS B 14 VSS n18 L=1.8e-07 W=1.2e-06 $X=6200 $Y=6200 $D=6
M1 12 14 VSS VSS n18 L=1.8e-07 W=8.4e-07 $X=14250 $Y=9800 $D=6
M2 6 13 12 VSS n18 L=1.8e-07 W=6.4e-07 $X=21450 $Y=11800 $D=6
M3 13 12 6 VSS n18 L=1.8e-07 W=4.2e-07 $X=31300 $Y=14000 $D=6
M4 VSS A 13 VSS n18 L=1.8e-07 W=6e-07 $X=38550 $Y=12200 $D=6
M5 13 A VSS VSS n18 L=1.8e-07 W=6e-07 $X=44550 $Y=13600 $D=6
M6 7 14 13 VSS n18 L=1.8e-07 W=4.2e-07 $X=52500 $Y=13700 $D=6
M7 14 13 7 VSS n18 L=1.8e-07 W=6.4e-07 $X=60400 $Y=11500 $D=6
M8 5 7 14 VSS n18 L=1.8e-07 W=4.2e-07 $X=72850 $Y=15450 $D=6
M9 3 6 5 VSS n18 L=1.8e-07 W=4.2e-07 $X=80050 $Y=15450 $D=6
M10 VSS C 3 VSS n18 L=1.8e-07 W=4.2e-07 $X=87650 $Y=10800 $D=6
M11 15 C 6 VSS n18 L=1.8e-07 W=4.2e-07 $X=101150 $Y=13050 $D=6
M12 7 3 15 VSS n18 L=1.8e-07 W=4.2e-07 $X=108350 $Y=13050 $D=6
M13 VSS 5 CO VSS n18 L=1.8e-07 W=6e-07 $X=121100 $Y=12200 $D=6
M14 S 15 VSS VSS n18 L=1.8e-07 W=6e-07 $X=129500 $Y=12200 $D=6
M15 VDD B 14 VDD p18 L=1.82027e-07 W=1.79314e-06 $X=5400 $Y=33800 $D=10
M16 12 14 VDD VDD p18 L=1.8e-07 W=1.26e-06 $X=12250 $Y=27100 $D=10
M17 7 13 12 VDD p18 L=1.8e-07 W=9.6e-07 $X=20450 $Y=27200 $D=10
M18 13 12 7 VDD p18 L=1.8e-07 W=6.4e-07 $X=30900 $Y=28200 $D=10
M19 VDD A 13 VDD p18 L=1.8e-07 W=9e-07 $X=40550 $Y=29000 $D=10
M20 13 A VDD VDD p18 L=1.8e-07 W=9e-07 $X=47350 $Y=29000 $D=10
M21 6 14 13 VDD p18 L=1.8e-07 W=6.4e-07 $X=54550 $Y=29200 $D=10
M22 14 13 6 VDD p18 L=1.8e-07 W=9.6e-07 $X=61750 $Y=31000 $D=10
M23 5 6 14 VDD p18 L=1.8e-07 W=6.4e-07 $X=68950 $Y=32650 $D=10
M24 3 7 5 VDD p18 L=1.8e-07 W=6.4e-07 $X=76150 $Y=32650 $D=10
M25 VDD C 3 VDD p18 L=1.8e-07 W=6.4e-07 $X=84750 $Y=33800 $D=10
M26 15 3 6 VDD p18 L=1.8e-07 W=6.4e-07 $X=98350 $Y=30800 $D=10
M27 7 C 15 VDD p18 L=1.8e-07 W=6.4e-07 $X=105550 $Y=30800 $D=10
M28 VDD 5 CO VDD p18 L=1.8e-07 W=9e-07 $X=120950 $Y=27550 $D=10
M29 S 15 VDD VDD p18 L=1.8e-07 W=9e-07 $X=129500 $Y=27550 $D=10
.ENDS
***************************************
.SUBCKT OAI21X1 A1 A0 VSS B0 VDD Y
** N=8 EP=6 IP=0 FDC=6
M0 VSS A1 7 VSS n18 L=1.8e-07 W=8e-07 $X=6200 $Y=7700 $D=6
M1 7 A0 VSS VSS n18 L=1.8e-07 W=8e-07 $X=14200 $Y=7700 $D=6
M2 Y B0 7 VSS n18 L=1.8e-07 W=8e-07 $X=21400 $Y=8950 $D=6
M3 8 A1 VDD VDD p18 L=1.8e-07 W=1.2e-06 $X=6200 $Y=29200 $D=10
M4 Y A0 8 VDD p18 L=1.8e-07 W=1.2e-06 $X=12600 $Y=29200 $D=10
M5 VDD B0 Y VDD p18 L=1.8e-07 W=9e-07 $X=19800 $Y=32200 $D=10
.ENDS
***************************************
.SUBCKT AOI21X1 A1 A0 VDD B0 Y VSS
** N=8 EP=6 IP=0 FDC=6
M0 8 A1 VSS VSS n18 L=1.8e-07 W=8e-07 $X=6200 $Y=8950 $D=6
M1 Y A0 8 VSS n18 L=1.8e-07 W=8e-07 $X=11800 $Y=8950 $D=6
M2 VSS B0 Y VSS n18 L=1.8e-07 W=6e-07 $X=19000 $Y=10950 $D=6
M3 VDD A1 7 VDD p18 L=1.83022e-07 W=1.20314e-06 $X=5400 $Y=33700 $D=10
M4 7 A0 VDD VDD p18 L=1.83022e-07 W=1.20314e-06 $X=11800 $Y=28200 $D=10
M5 Y B0 7 VDD p18 L=1.83022e-07 W=1.20314e-06 $X=18200 $Y=33700 $D=10
.ENDS
***************************************
.SUBCKT XOR2X1 B A VSS VDD Y
** N=9 EP=5 IP=0 FDC=12
M0 VSS A 6 VSS n18 L=1.8e-07 W=3e-07 $X=7150 $Y=10800 $D=6
M1 8 B VSS VSS n18 L=1.8e-07 W=1.2e-06 $X=13650 $Y=5700 $D=6
M2 9 6 8 VSS n18 L=1.8e-07 W=4.8e-07 $X=23900 $Y=11400 $D=6
M3 7 A 9 VSS n18 L=1.8e-07 W=4.8e-07 $X=31600 $Y=11400 $D=6
M4 VSS 8 7 VSS n18 L=1.8e-07 W=4.8e-07 $X=38800 $Y=11400 $D=6
M5 Y 9 VSS VSS n18 L=1.8e-07 W=6e-07 $X=44800 $Y=10200 $D=6
M6 VDD A 6 VDD p18 L=1.8e-07 W=4.2e-07 $X=6200 $Y=33600 $D=10
M7 8 B VDD VDD p18 L=1.8e-07 W=1.64e-06 $X=12900 $Y=28300 $D=10
M8 9 A 8 VDD p18 L=1.8e-07 W=7.2e-07 $X=23900 $Y=28300 $D=10
M9 7 6 9 VDD p18 L=1.8e-07 W=7.2e-07 $X=31600 $Y=28300 $D=10
M10 VDD 8 7 VDD p18 L=1.8e-07 W=7.2e-07 $X=38800 $Y=28300 $D=10
M11 Y 9 VDD VDD p18 L=1.8e-07 W=9e-07 $X=44800 $Y=28300 $D=10
.ENDS
***************************************
.SUBCKT AOI211XL A1 A0 VDD C0 VSS B0 Y
** N=10 EP=7 IP=0 FDC=8
M0 9 A1 VSS VSS n18 L=1.8e-07 W=5.6e-07 $X=6200 $Y=9150 $D=6
M1 Y A0 9 VSS n18 L=1.8e-07 W=5.6e-07 $X=11800 $Y=9150 $D=6
M2 VSS C0 Y VSS n18 L=1.8e-07 W=4.2e-07 $X=19000 $Y=10550 $D=6
M3 Y B0 VSS VSS n18 L=1.8e-07 W=4.2e-07 $X=25000 $Y=10550 $D=6
M4 VDD A1 8 VDD p18 L=1.8e-07 W=9.8e-07 $X=6200 $Y=28600 $D=10
M5 8 A0 VDD VDD p18 L=1.8e-07 W=9.8e-07 $X=12200 $Y=28600 $D=10
M6 10 C0 8 VDD p18 L=1.8e-07 W=9.8e-07 $X=19400 $Y=28600 $D=10
M7 Y B0 10 VDD p18 L=1.8e-07 W=9.8e-07 $X=25000 $Y=28600 $D=10
.ENDS
***************************************
.SUBCKT XNOR2X1 B A VSS VDD Y
** N=9 EP=5 IP=0 FDC=12
M0 VSS A 6 VSS n18 L=1.8e-07 W=3e-07 $X=7150 $Y=10800 $D=6
M1 8 B VSS VSS n18 L=1.8e-07 W=1.2e-06 $X=13650 $Y=5700 $D=6
M2 9 A 8 VSS n18 L=1.8e-07 W=4.8e-07 $X=23900 $Y=11550 $D=6
M3 7 6 9 VSS n18 L=1.8e-07 W=4.8e-07 $X=31200 $Y=11550 $D=6
M4 VSS 8 7 VSS n18 L=1.8e-07 W=4.8e-07 $X=38800 $Y=11550 $D=6
M5 Y 9 VSS VSS n18 L=1.8e-07 W=6e-07 $X=44800 $Y=10350 $D=6
M6 VDD A 6 VDD p18 L=1.8e-07 W=4.2e-07 $X=6200 $Y=33600 $D=10
M7 8 B VDD VDD p18 L=1.82173e-07 W=1.67314e-06 $X=12900 $Y=28250 $D=10
M8 9 6 8 VDD p18 L=1.8e-07 W=7.2e-07 $X=23900 $Y=28300 $D=10
M9 7 A 9 VDD p18 L=1.8e-07 W=7.2e-07 $X=31200 $Y=28300 $D=10
M10 VDD 8 7 VDD p18 L=1.8e-07 W=7.2e-07 $X=38800 $Y=27000 $D=10
M11 Y 9 VDD VDD p18 L=1.8e-07 W=9e-07 $X=44800 $Y=28300 $D=10
.ENDS
***************************************
.SUBCKT OR2XL A B VSS VDD Y
** N=7 EP=5 IP=0 FDC=6
M0 6 A VSS VSS n18 L=1.8e-07 W=3e-07 $X=4100 $Y=10450 $D=6
M1 VSS B 6 VSS n18 L=1.8e-07 W=3e-07 $X=12100 $Y=15100 $D=6
M2 Y 6 VSS VSS n18 L=1.8e-07 W=4.2e-07 $X=18100 $Y=13900 $D=6
M3 7 A 6 VDD p18 L=1.8e-07 W=5.6e-07 $X=6400 $Y=33600 $D=10
M4 VDD B 7 VDD p18 L=1.8e-07 W=5.6e-07 $X=12000 $Y=33600 $D=10
M5 Y 6 VDD VDD p18 L=1.8e-07 W=6.4e-07 $X=18000 $Y=31500 $D=10
.ENDS
***************************************
.SUBCKT XNOR2XL B 2 A VSS VDD Y
** N=9 EP=6 IP=0 FDC=12
M0 VSS A 2 VSS n18 L=1.8e-07 W=3e-07 $X=6600 $Y=10800 $D=6
M1 7 B VSS VSS n18 L=1.8e-07 W=3e-07 $X=13650 $Y=10800 $D=6
M2 9 A 7 VSS n18 L=1.8e-07 W=5.6e-07 $X=23900 $Y=10800 $D=6
M3 8 2 9 VSS n18 L=1.8e-07 W=5.6e-07 $X=31200 $Y=10800 $D=6
M4 VSS 7 8 VSS n18 L=1.8e-07 W=3e-07 $X=38800 $Y=12300 $D=6
M5 Y 9 VSS VSS n18 L=1.8e-07 W=4.2e-07 $X=44800 $Y=11100 $D=6
M6 VDD A 2 VDD p18 L=1.8e-07 W=4.2e-07 $X=6200 $Y=33600 $D=10
M7 7 B VDD VDD p18 L=1.8e-07 W=4.2e-07 $X=12900 $Y=33600 $D=10
M8 9 2 7 VDD p18 L=1.8e-07 W=8.4e-07 $X=23900 $Y=29400 $D=10
M9 8 A 9 VDD p18 L=1.8e-07 W=8.4e-07 $X=31200 $Y=29400 $D=10
M10 VDD 7 8 VDD p18 L=1.8e-07 W=4.2e-07 $X=38800 $Y=29400 $D=10
M11 Y 9 VDD VDD p18 L=1.8e-07 W=6.4e-07 $X=44800 $Y=29400 $D=10
.ENDS
***************************************
.SUBCKT OAI2BB1XL A1N A0N B0 VSS Y VDD
** N=9 EP=6 IP=0 FDC=8
M0 8 A1N 7 VSS n18 L=1.8e-07 W=3.6e-07 $X=6600 $Y=8950 $D=6
M1 VSS A0N 8 VSS n18 L=1.8e-07 W=3.6e-07 $X=12200 $Y=8950 $D=6
M2 9 B0 VSS VSS n18 L=1.8e-07 W=5.6e-07 $X=19400 $Y=12600 $D=6
M3 Y 7 9 VSS n18 L=1.8e-07 W=5.6e-07 $X=25000 $Y=12600 $D=6
M4 7 A1N VDD VDD p18 L=1.8e-07 W=4.2e-07 $X=4600 $Y=31500 $D=10
M5 VDD A0N 7 VDD p18 L=1.8e-07 W=4.2e-07 $X=12600 $Y=31500 $D=10
M6 Y B0 VDD VDD p18 L=1.8e-07 W=6.4e-07 $X=18650 $Y=32150 $D=10
M7 VDD 7 Y VDD p18 L=1.8e-07 W=6.4e-07 $X=25850 $Y=32150 $D=10
.ENDS
***************************************
.SUBCKT OAI2BB1X1 A1N A0N B0 VSS Y VDD
** N=9 EP=6 IP=0 FDC=8
M0 8 A1N 7 VSS n18 L=1.8e-07 W=3.6e-07 $X=6600 $Y=8950 $D=6
M1 VSS A0N 8 VSS n18 L=1.8e-07 W=3.6e-07 $X=12200 $Y=8950 $D=6
M2 9 B0 VSS VSS n18 L=1.8e-07 W=8e-07 $X=19400 $Y=10200 $D=6
M3 Y 7 9 VSS n18 L=1.8e-07 W=8e-07 $X=25000 $Y=10200 $D=6
M4 7 A1N VDD VDD p18 L=1.8e-07 W=4e-07 $X=4600 $Y=31600 $D=10
M5 VDD A0N 7 VDD p18 L=1.8e-07 W=4e-07 $X=12600 $Y=31600 $D=10
M6 Y B0 VDD VDD p18 L=1.8e-07 W=9e-07 $X=18650 $Y=30850 $D=10
M7 VDD 7 Y VDD p18 L=1.8e-07 W=9e-07 $X=25850 $Y=30850 $D=10
.ENDS
***************************************
.SUBCKT ICV_1 1 2 3 4 5 6 7 8 9 10 11 12 13 14 15
*.CALIBRE ICV_CELL 9
** N=18 EP=15 IP=20 FDC=68
X0 3 4 5 16 7 6 8 1 9 2 DFFSXL $T=0 0 0 0 $X=-4300 $Y=-4000
X1 10 11 12 17 13 18 14 1 15 2 DFFSXL $T=132000 0 0 0 $X=127700 $Y=-4000
.ENDS
***************************************
.SUBCKT AOI222XL C0 C1 VDD B1 B0 A0 A1 Y VSS
** N=14 EP=9 IP=0 FDC=12
M0 12 C0 Y VSS n18 L=1.8e-07 W=5.6e-07 $X=6200 $Y=9000 $D=6
M1 VSS C1 12 VSS n18 L=1.8e-07 W=5.6e-07 $X=11800 $Y=9000 $D=6
M2 13 B1 VSS VSS n18 L=1.8e-07 W=5.6e-07 $X=20650 $Y=9000 $D=6
M3 Y B0 13 VSS n18 L=1.8e-07 W=5.6e-07 $X=27350 $Y=9000 $D=6
M4 14 A0 Y VSS n18 L=1.8e-07 W=5.6e-07 $X=36250 $Y=9000 $D=6
M5 VSS A1 14 VSS n18 L=1.8e-07 W=5.6e-07 $X=41900 $Y=9000 $D=6
M6 10 C0 VDD VDD p18 L=1.8e-07 W=9.6e-07 $X=4600 $Y=29200 $D=10
M7 VDD C1 10 VDD p18 L=1.8e-07 W=9.6e-07 $X=11800 $Y=29200 $D=10
M8 10 B1 11 VDD p18 L=1.8e-07 W=9.6e-07 $X=23600 $Y=27400 $D=10
M9 11 B0 10 VDD p18 L=1.8e-07 W=9.6e-07 $X=30800 $Y=27400 $D=10
M10 Y A0 11 VDD p18 L=1.8e-07 W=9.6e-07 $X=36850 $Y=27400 $D=10
M11 11 A1 Y VDD p18 L=1.8e-07 W=9.6e-07 $X=44050 $Y=27400 $D=10
.ENDS
***************************************
.SUBCKT AOI222X1 C0 C1 VDD B1 B0 A0 Y A1 VSS
** N=14 EP=9 IP=0 FDC=12
M0 12 C0 Y VSS n18 L=1.8e-07 W=8e-07 $X=6200 $Y=8950 $D=6
M1 VSS C1 12 VSS n18 L=1.8e-07 W=8e-07 $X=11800 $Y=8950 $D=6
M2 13 B1 VSS VSS n18 L=1.8e-07 W=8e-07 $X=21250 $Y=8950 $D=6
M3 Y B0 13 VSS n18 L=1.8e-07 W=8e-07 $X=26850 $Y=8950 $D=6
M4 14 A0 Y VSS n18 L=1.8e-07 W=8e-07 $X=34550 $Y=8950 $D=6
M5 VSS A1 14 VSS n18 L=1.8e-07 W=8e-07 $X=41250 $Y=8950 $D=6
M6 11 C0 VDD VDD p18 L=1.826e-07 W=1.39814e-06 $X=5400 $Y=31050 $D=10
M7 VDD C1 11 VDD p18 L=1.826e-07 W=1.39814e-06 $X=11800 $Y=36450 $D=10
M8 11 B1 10 VDD p18 L=1.826e-07 W=1.39814e-06 $X=25250 $Y=27800 $D=10
M9 10 B0 11 VDD p18 L=1.826e-07 W=1.39814e-06 $X=31650 $Y=33200 $D=10
M10 Y A0 10 VDD p18 L=1.826e-07 W=1.39814e-06 $X=38050 $Y=27800 $D=10
M11 10 A1 Y VDD p18 L=1.826e-07 W=1.39814e-06 $X=44450 $Y=33200 $D=10
.ENDS
***************************************
.SUBCKT BUFXL A VSS VDD Y
** N=5 EP=4 IP=0 FDC=4
M0 VSS A 5 VSS n18 L=1.8e-07 W=3e-07 $X=6600 $Y=11900 $D=6
M1 Y 5 VSS VSS n18 L=1.8e-07 W=4.2e-07 $X=12600 $Y=10000 $D=6
M2 VDD A 5 VDD p18 L=1.8e-07 W=4.2e-07 $X=6200 $Y=27200 $D=10
M3 Y 5 VDD VDD p18 L=1.8e-07 W=6.4e-07 $X=12200 $Y=27200 $D=10
.ENDS
***************************************
.SUBCKT NAND3XL C VSS B VDD A Y
** N=8 EP=6 IP=0 FDC=6
M0 7 C VSS VSS n18 L=1.8e-07 W=6.6e-07 $X=7200 $Y=8950 $D=6
M1 8 B 7 VSS n18 L=1.8e-07 W=6.6e-07 $X=12800 $Y=8950 $D=6
M2 Y A 8 VSS n18 L=1.8e-07 W=6.6e-07 $X=18400 $Y=8950 $D=6
M3 VDD C Y VDD p18 L=1.8e-07 W=6.4e-07 $X=4100 $Y=38800 $D=10
M4 VDD B Y VDD p18 L=1.8e-07 W=6.4e-07 $X=11500 $Y=27400 $D=10
M5 Y A VDD VDD p18 L=1.8e-07 W=6.4e-07 $X=18400 $Y=27400 $D=10
.ENDS
***************************************
.SUBCKT NAND4X1 D VSS C B A Y VDD
** N=10 EP=7 IP=0 FDC=8
M0 8 D VSS VSS n18 L=1.8e-07 W=1.04e-06 $X=6750 $Y=5700 $D=6
M1 9 C 8 VSS n18 L=1.8e-07 W=1.04e-06 $X=12350 $Y=5700 $D=6
M2 10 B 9 VSS n18 L=1.8e-07 W=1.04e-06 $X=17950 $Y=5700 $D=6
M3 Y A 10 VSS n18 L=1.8e-07 W=1.04e-06 $X=23550 $Y=5700 $D=6
M4 Y D VDD VDD p18 L=1.84272e-07 W=9.57279e-07 $X=5100 $Y=30550 $D=10
M5 VDD C Y VDD p18 L=1.84272e-07 W=9.57279e-07 $X=11600 $Y=35350 $D=10
M6 Y B VDD VDD p18 L=1.84272e-07 W=9.57279e-07 $X=18700 $Y=30550 $D=10
M7 VDD A Y VDD p18 L=1.84272e-07 W=9.57279e-07 $X=25200 $Y=35350 $D=10
.ENDS
***************************************
.SUBCKT AOI22XL B1 VDD B0 A0 A1 Y VSS
** N=10 EP=7 IP=0 FDC=8
M0 9 B1 VSS VSS n18 L=1.8e-07 W=5.6e-07 $X=6600 $Y=10200 $D=6
M1 Y B0 9 VSS n18 L=1.8e-07 W=5.6e-07 $X=12200 $Y=10200 $D=6
M2 10 A0 Y VSS n18 L=1.8e-07 W=5.6e-07 $X=19400 $Y=10200 $D=6
M3 VSS A1 10 VSS n18 L=1.8e-07 W=5.6e-07 $X=25000 $Y=10200 $D=6
M4 VDD B1 8 VDD p18 L=1.8e-07 W=8.4e-07 $X=6200 $Y=28900 $D=10
M5 8 B0 VDD VDD p18 L=1.8e-07 W=8.4e-07 $X=12200 $Y=28900 $D=10
M6 Y A0 8 VDD p18 L=1.8e-07 W=8.4e-07 $X=18200 $Y=28900 $D=10
M7 8 A1 Y VDD p18 L=1.8e-07 W=8.4e-07 $X=25400 $Y=28900 $D=10
.ENDS
***************************************
.SUBCKT NAND4XL D VSS C B Y A VDD
** N=10 EP=7 IP=0 FDC=8
M0 8 D VSS VSS n18 L=1.8e-07 W=7.2e-07 $X=6750 $Y=10550 $D=6
M1 9 C 8 VSS n18 L=1.8e-07 W=7.2e-07 $X=12350 $Y=10550 $D=6
M2 10 B 9 VSS n18 L=1.8e-07 W=7.2e-07 $X=17950 $Y=10550 $D=6
M3 Y A 10 VSS n18 L=1.8e-07 W=7.2e-07 $X=23550 $Y=10550 $D=6
M4 Y D VDD VDD p18 L=1.8e-07 W=6.4e-07 $X=5100 $Y=30550 $D=10
M5 VDD C Y VDD p18 L=1.8e-07 W=6.4e-07 $X=12300 $Y=30550 $D=10
M6 Y B VDD VDD p18 L=1.8e-07 W=6.4e-07 $X=18900 $Y=30550 $D=10
M7 VDD A Y VDD p18 L=1.8e-07 W=6.4e-07 $X=26100 $Y=30550 $D=10
.ENDS
***************************************
.SUBCKT AND3XL A B C VSS VDD 6 Y
** N=9 EP=7 IP=0 FDC=8
M0 8 A 6 VSS n18 L=1.8e-07 W=4.4e-07 $X=6600 $Y=10200 $D=6
M1 9 B 8 VSS n18 L=1.8e-07 W=4.4e-07 $X=12200 $Y=10200 $D=6
M2 VSS C 9 VSS n18 L=1.8e-07 W=4.4e-07 $X=17800 $Y=10200 $D=6
M3 Y 6 VSS VSS n18 L=1.8e-07 W=4.6e-07 $X=24100 $Y=10900 $D=6
M4 VDD A 6 VDD p18 L=1.8e-07 W=4e-07 $X=6800 $Y=39750 $D=10
M5 VDD B 6 VDD p18 L=1.8e-07 W=4e-07 $X=11200 $Y=32650 $D=10
M6 VDD C 6 VDD p18 L=1.8e-07 W=4e-07 $X=20300 $Y=27450 $D=10
M7 Y 6 VDD VDD p18 L=1.8e-07 W=6.4e-07 $X=24600 $Y=36650 $D=10
.ENDS
***************************************
.SUBCKT AND3X4 A B C Y VSS VDD
** N=9 EP=6 IP=0 FDC=10
M0 8 A 7 VSS n18 L=1.8e-07 W=1.26e-06 $X=6350 $Y=5700 $D=6
M1 9 B 8 VSS n18 L=1.8e-07 W=1.26e-06 $X=11950 $Y=5700 $D=6
M2 VSS C 9 VSS n18 L=1.8e-07 W=1.26e-06 $X=17550 $Y=5700 $D=6
M3 Y 7 VSS VSS n18 L=1.82972e-07 W=1.22314e-06 $X=24200 $Y=11800 $D=6
M4 VSS 7 Y VSS n18 L=1.82972e-07 W=1.22314e-06 $X=30650 $Y=5700 $D=6
M5 VDD A 7 VDD p18 L=1.82609e-07 W=1.39314e-06 $X=5400 $Y=35350 $D=10
M6 7 B VDD VDD p18 L=1.82609e-07 W=1.39314e-06 $X=11800 $Y=27850 $D=10
M7 VDD C 7 VDD p18 L=1.82609e-07 W=1.39314e-06 $X=18200 $Y=35500 $D=10
M8 Y 7 VDD VDD p18 L=1.82044e-07 W=1.77814e-06 $X=25150 $Y=27250 $D=10
M9 VDD 7 Y VDD p18 L=1.82044e-07 W=1.77814e-06 $X=31600 $Y=35500 $D=10
.ENDS
***************************************
.SUBCKT CLKBUFX3 A Y VSS VDD
** N=5 EP=4 IP=0 FDC=6
M0 VSS A 5 VSS n18 L=1.8e-07 W=3.4e-07 $X=6600 $Y=10650 $D=6
M1 Y 5 VSS VSS n18 L=1.8e-07 W=5.2e-07 $X=12600 $Y=10650 $D=6
M2 VSS 5 Y VSS n18 L=1.8e-07 W=5e-07 $X=19800 $Y=10850 $D=6
M3 VDD A 5 VDD p18 L=1.8e-07 W=9e-07 $X=6200 $Y=28850 $D=10
M4 Y 5 VDD VDD p18 L=1.8e-07 W=1.32e-06 $X=12200 $Y=26650 $D=10
M5 VDD 5 Y VDD p18 L=1.8e-07 W=1.32e-06 $X=19400 $Y=27000 $D=10
.ENDS
***************************************
.SUBCKT CLKINVX4 A Y VDD VSS
** N=4 EP=4 IP=0 FDC=4
M0 Y A VSS VSS n18 L=1.8e-07 W=6.8e-07 $X=8200 $Y=11400 $D=6
M1 VSS A Y VSS n18 L=1.8e-07 W=6.8e-07 $X=15400 $Y=11400 $D=6
M2 Y A VDD VDD p18 L=1.8e-07 W=1.77e-06 $X=8200 $Y=27000 $D=10
M3 VDD A Y VDD p18 L=1.8e-07 W=1.77e-06 $X=15400 $Y=27000 $D=10
.ENDS
***************************************
.SUBCKT CLKBUFX2 A VDD VSS Y
** N=5 EP=4 IP=0 FDC=4
M0 VSS A 5 VSS n18 L=1.8e-07 W=3e-07 $X=7600 $Y=12350 $D=6
M1 Y 5 VSS VSS n18 L=1.8e-07 W=6.4e-07 $X=13600 $Y=8950 $D=6
M2 VDD A 5 VDD p18 L=1.8e-07 W=7.8e-07 $X=7200 $Y=27100 $D=10
M3 Y 5 VDD VDD p18 L=1.8e-07 W=1.76e-06 $X=13200 $Y=27100 $D=10
.ENDS
***************************************
.SUBCKT AND2X2 A VDD B 4 VSS Y
** N=7 EP=6 IP=0 FDC=6
M0 7 A 4 VSS n18 L=1.8e-07 W=6.2e-07 $X=6200 $Y=12100 $D=6
M1 VSS B 7 VSS n18 L=1.8e-07 W=6.2e-07 $X=12000 $Y=12100 $D=6
M2 Y 4 VSS VSS n18 L=1.8e-07 W=1.2e-06 $X=18000 $Y=6300 $D=6
M3 4 A VDD VDD p18 L=1.8e-07 W=7e-07 $X=4800 $Y=27000 $D=10
M4 VDD B 4 VDD p18 L=1.8e-07 W=7e-07 $X=12000 $Y=27000 $D=10
M5 Y 4 VDD VDD p18 L=1.8e-07 W=1.7e-06 $X=18000 $Y=27000 $D=10
.ENDS
***************************************
.SUBCKT BUFX1 A VSS VDD Y
** N=5 EP=4 IP=0 FDC=4
M0 VSS A 5 VSS n18 L=1.8e-07 W=3e-07 $X=6600 $Y=11900 $D=6
M1 Y 5 VSS VSS n18 L=1.8e-07 W=6e-07 $X=12600 $Y=9100 $D=6
M2 VDD A 5 VDD p18 L=1.8e-07 W=4.2e-07 $X=6200 $Y=27200 $D=10
M3 Y 5 VDD VDD p18 L=1.8e-07 W=9e-07 $X=12200 $Y=27200 $D=10
.ENDS
***************************************
.SUBCKT NAND4BXL D C B Y AN VDD VSS
** N=11 EP=7 IP=0 FDC=10
M0 9 D VSS VSS n18 L=1.8e-07 W=7.2e-07 $X=4600 $Y=10200 $D=6
M1 10 C 9 VSS n18 L=1.8e-07 W=7.2e-07 $X=10200 $Y=10200 $D=6
M2 11 B 10 VSS n18 L=1.8e-07 W=7.2e-07 $X=15800 $Y=10200 $D=6
M3 Y 8 11 VSS n18 L=1.8e-07 W=7.2e-07 $X=21400 $Y=10200 $D=6
M4 8 AN VSS VSS n18 L=1.8e-07 W=3e-07 $X=31850 $Y=10250 $D=6
M5 Y D VDD VDD p18 L=1.8e-07 W=6.4e-07 $X=4600 $Y=33450 $D=10
M6 VDD C Y VDD p18 L=1.8e-07 W=6.4e-07 $X=11800 $Y=33450 $D=10
M7 Y B VDD VDD p18 L=1.8e-07 W=6.4e-07 $X=17850 $Y=33450 $D=10
M8 VDD 8 Y VDD p18 L=1.8e-07 W=6.4e-07 $X=25050 $Y=33450 $D=10
M9 8 AN VDD VDD p18 L=1.8e-07 W=4.2e-07 $X=31150 $Y=33450 $D=10
.ENDS
***************************************
.SUBCKT AND4XL A B C D VSS VDD Y
** N=11 EP=7 IP=0 FDC=10
M0 9 A 8 VSS n18 L=1.8e-07 W=4.8e-07 $X=6600 $Y=9150 $D=6
M1 10 B 9 VSS n18 L=1.8e-07 W=4.8e-07 $X=12200 $Y=9150 $D=6
M2 11 C 10 VSS n18 L=1.8e-07 W=4.8e-07 $X=17800 $Y=9150 $D=6
M3 VSS D 11 VSS n18 L=1.8e-07 W=4.8e-07 $X=23400 $Y=9150 $D=6
M4 Y 8 VSS VSS n18 L=1.8e-07 W=4.2e-07 $X=31400 $Y=9750 $D=6
M5 VDD A 8 VDD p18 L=1.8e-07 W=4e-07 $X=4800 $Y=39400 $D=10
M6 VDD B 8 VDD p18 L=1.8e-07 W=4e-07 $X=10000 $Y=30400 $D=10
M7 8 C VDD VDD p18 L=1.8e-07 W=4e-07 $X=16000 $Y=30400 $D=10
M8 VDD D 8 VDD p18 L=1.8e-07 W=4e-07 $X=24000 $Y=30400 $D=10
M9 Y 8 VDD VDD p18 L=1.8e-07 W=6.4e-07 $X=31200 $Y=30400 $D=10
.ENDS
***************************************
.SUBCKT CLKINVX3 A VDD Y VSS
** N=4 EP=4 IP=0 FDC=4
M0 Y A VSS VSS n18 L=1.8e-07 W=5.1e-07 $X=4600 $Y=13100 $D=6
M1 VSS A Y VSS n18 L=1.8e-07 W=5.1e-07 $X=11800 $Y=13100 $D=6
M2 Y A VDD VDD p18 L=1.8e-07 W=1.23e-06 $X=4600 $Y=27000 $D=10
M3 VDD A Y VDD p18 L=1.8e-07 W=1.47e-06 $X=11800 $Y=27000 $D=10
.ENDS
***************************************
.SUBCKT AOI22X1 B1 B0 VDD A0 A1 Y VSS
** N=10 EP=7 IP=0 FDC=8
M0 9 B1 VSS VSS n18 L=1.8e-07 W=8e-07 $X=6200 $Y=8950 $D=6
M1 Y B0 9 VSS n18 L=1.8e-07 W=8e-07 $X=11800 $Y=8950 $D=6
M2 10 A0 Y VSS n18 L=1.8e-07 W=8e-07 $X=19000 $Y=7050 $D=6
M3 VSS A1 10 VSS n18 L=1.8e-07 W=8e-07 $X=24600 $Y=7050 $D=6
M4 VDD B1 8 VDD p18 L=1.8e-07 W=1.2e-06 $X=6200 $Y=28150 $D=10
M5 8 B0 VDD VDD p18 L=1.8e-07 W=1.2e-06 $X=12200 $Y=28150 $D=10
M6 Y A0 8 VDD p18 L=1.83022e-07 W=1.20314e-06 $X=18600 $Y=28950 $D=10
M7 8 A1 Y VDD p18 L=1.83022e-07 W=1.20314e-06 $X=25000 $Y=34450 $D=10
.ENDS
***************************************
.SUBCKT CLKBUFX4 A Y VSS VDD
** N=5 EP=4 IP=0 FDC=6
M0 VSS A 5 VSS n18 L=1.8e-07 W=4.4e-07 $X=6200 $Y=11900 $D=6
M1 Y 5 VSS VSS n18 L=1.8e-07 W=6.8e-07 $X=14200 $Y=10900 $D=6
M2 VSS 5 Y VSS n18 L=1.8e-07 W=6.8e-07 $X=21400 $Y=10900 $D=6
M3 VDD A 5 VDD p18 L=1.8e-07 W=1.16e-06 $X=6200 $Y=27000 $D=10
M4 Y 5 VDD VDD p18 L=1.8e-07 W=1.76e-06 $X=14200 $Y=27000 $D=10
M5 VDD 5 Y VDD p18 L=1.8e-07 W=1.76e-06 $X=21400 $Y=27000 $D=10
.ENDS
***************************************
.SUBCKT ICV_2 1 2 3 4 5 6 7 8 9 10 11 12 13 14 15 16 17 18 19 20
+ 21 22 23 24 25 26 27 28 29 30 31 32 33 34 35 36 37 38 39 40
+ 41 42 43 44 47 48 50 52 53 54 57 60 61 63 64 65 66 67 71 72
+ 73 74 78 79 81 82 83 85 86 87 88 89 90 91 92 93 94 96 97 98
+ 99 100 101 102 103 104 106 109 110 112 113 114 115 116 117 118 119 120 121 122
+ 123 124 126 127 131 132 133 134 136 138 140 141 143 150 151 153 156 158 162 163
+ 164 165 166 167 168 169 170 171 172 173 174 175 176 177 178 179 180 181 182 183
+ 184 185 186 187 188 189 190 191 192 193 194 195 196 197 199 200 201 202 203 204
+ 205 206 207 208 209 210 211 212 213 214 215 216 217 219 220 221 222 223 224 225
+ 226 227 228 229 230 231 232 233 234 235 236 237 238 239 240 241 242 243 244 245
+ 246 247 248 249 250 251 253 254 255
*.CALIBRE ICV_CELL 2
** N=1089 EP=209 IP=3064 FDC=5834
M0 195 356 273 195 n18 L=1.8e-07 W=2.8e-07 $X=1319600 $Y=3667500 $D=6
M1 195 649 560 195 n18 L=1.8e-07 W=4.2e-07 $X=3781400 $Y=3685100 $D=6
M2 1089 250 649 195 n18 L=1.8e-07 W=3.6e-07 $X=3790350 $Y=3692450 $D=6
M3 195 249 1089 195 n18 L=1.8e-07 W=3.6e-07 $X=3795950 $Y=3692450 $D=6
M4 651 249 195 195 n18 L=1.8e-07 W=4.2e-07 $X=3801950 $Y=3689750 $D=6
M5 557 250 651 195 n18 L=1.8e-07 W=5.6e-07 $X=3809550 $Y=3688900 $D=6
M6 650 652 557 195 n18 L=1.8e-07 W=5.6e-07 $X=3817150 $Y=3685150 $D=6
M7 195 250 652 195 n18 L=1.8e-07 W=3e-07 $X=3833800 $Y=3690900 $D=6
M8 650 651 195 195 n18 L=1.8e-07 W=4.2e-07 $X=3839800 $Y=3690700 $D=6
M9 64 356 273 64 p18 L=1.8e-07 W=7e-07 $X=1323000 $Y=3641400 $D=10
M10 64 649 560 64 p18 L=1.8e-07 W=6.4e-07 $X=3783850 $Y=3712250 $D=10
M11 649 250 64 64 p18 L=1.8e-07 W=4.2e-07 $X=3789950 $Y=3712250 $D=10
M12 64 249 649 64 p18 L=1.8e-07 W=4.2e-07 $X=3797150 $Y=3712250 $D=10
M13 651 249 64 64 p18 L=1.8e-07 W=6.4e-07 $X=3803150 $Y=3712250 $D=10
M14 557 652 651 64 p18 L=1.8e-07 W=8.4e-07 $X=3810350 $Y=3712250 $D=10
M15 650 250 557 64 p18 L=1.8e-07 W=8.4e-07 $X=3819600 $Y=3712250 $D=10
M16 64 250 652 64 p18 L=1.8e-07 W=4.2e-07 $X=3833800 $Y=3713700 $D=10
M17 650 651 64 64 p18 L=1.8e-07 W=6.4e-07 $X=3839800 $Y=3713700 $D=10
X18 201 64 195 124 CLKINVX1 $T=3907200 4082400 0 180 $X=3883100 $Y=4026600
X19 254 64 195 120 CLKINVX1 $T=4026000 4082400 0 180 $X=4001900 $Y=4026600
X20 354 195 64 30 574 NAND2XL $T=1287000 4082400 0 180 $X=1262900 $Y=4026600
X21 355 195 64 30 576 NAND2XL $T=1320000 4082400 1 0 $X=1315700 $Y=4026600
X22 361 195 64 30 577 NAND2XL $T=1405800 4082400 0 180 $X=1381700 $Y=4026600
X23 578 195 64 83 579 NAND2XL $T=1834800 3780000 1 0 $X=1830500 $Y=3724200
X24 377 195 64 83 642 NAND2XL $T=1874400 3679200 0 180 $X=1850300 $Y=3623400
X25 79 195 64 83 580 NAND2XL $T=1874400 3880800 1 180 $X=1850300 $Y=3876800
X26 641 195 64 83 381 NAND2XL $T=1900800 3880800 1 0 $X=1896500 $Y=3825000
X27 260 195 64 83 261 NAND2XL $T=1907400 3981600 0 0 $X=1903100 $Y=3977600
X28 380 195 64 83 382 NAND2XL $T=1927200 4183200 0 0 $X=1922900 $Y=4179200
X29 389 195 64 88 82 NAND2XL $T=1953600 3880800 1 180 $X=1929500 $Y=3876800
X30 91 195 64 88 585 NAND2XL $T=2032800 3780000 1 180 $X=2008700 $Y=3776000
X31 399 195 64 342 400 NAND2XL $T=2541000 3981600 1 0 $X=2536700 $Y=3925800
X32 126 195 64 362 404 NAND2XL $T=2620200 3880800 1 180 $X=2596100 $Y=3876800
X33 404 195 64 401 411 NAND2XL $T=2626800 4082400 0 180 $X=2602700 $Y=4026600
X34 102 195 64 391 590 NAND2XL $T=2620200 3780000 1 0 $X=2615900 $Y=3724200
X35 104 195 64 266 106 NAND2XL $T=2640000 3679200 1 0 $X=2635700 $Y=3623400
X36 99 195 64 126 274 NAND2XL $T=2646600 3679200 0 0 $X=2642300 $Y=3675200
X37 266 195 64 413 416 NAND2XL $T=2659800 3780000 0 0 $X=2655500 $Y=3776000
X38 416 195 64 418 596 NAND2XL $T=2673000 3880800 0 0 $X=2668700 $Y=3876800
X39 186 195 64 399 425 NAND2XL $T=2686200 3780000 0 0 $X=2681900 $Y=3776000
X40 412 195 64 415 591 NAND2XL $T=2686200 3981600 1 0 $X=2681900 $Y=3925800
X41 414 195 64 423 595 NAND2XL $T=2699400 3880800 1 0 $X=2695100 $Y=3825000
X42 594 195 64 422 429 NAND2XL $T=2706000 3780000 1 0 $X=2701700 $Y=3724200
X43 115 195 64 268 428 NAND2XL $T=2725800 3981600 0 180 $X=2701700 $Y=3925800
X44 114 195 64 333 270 NAND2XL $T=2745600 3981600 0 0 $X=2741300 $Y=3977600
X45 112 195 64 430 438 NAND2XL $T=2785200 3880800 0 180 $X=2761100 $Y=3825000
X46 274 195 64 432 442 NAND2XL $T=2772000 3679200 0 0 $X=2767700 $Y=3675200
X47 436 195 64 440 445 NAND2XL $T=2778600 3981600 0 0 $X=2774300 $Y=3977600
X48 112 195 64 427 113 NAND2XL $T=2785200 3880800 1 0 $X=2780900 $Y=3825000
X49 439 195 64 273 436 NAND2XL $T=2805000 3880800 1 180 $X=2780900 $Y=3876800
X50 275 195 64 441 443 NAND2XL $T=2811600 4082400 1 180 $X=2787500 $Y=4078400
X51 112 195 64 277 455 NAND2XL $T=2831400 3780000 1 180 $X=2807300 $Y=3776000
X52 112 195 64 279 232 NAND2XL $T=2831400 3880800 1 0 $X=2827100 $Y=3825000
X53 450 195 64 116 451 NAND2XL $T=2851200 3880800 1 180 $X=2827100 $Y=3876800
X54 112 195 64 278 121 NAND2XL $T=2877600 3880800 0 180 $X=2853500 $Y=3825000
X55 93 195 64 450 458 NAND2XL $T=2877600 3880800 1 180 $X=2853500 $Y=3876800
X56 112 195 64 281 280 NAND2XL $T=2897400 3981600 0 180 $X=2873300 $Y=3925800
X57 295 195 64 367 467 NAND2XL $T=2884200 4082400 0 0 $X=2879900 $Y=4078400
X58 464 195 64 602 453 NAND2XL $T=2910600 4183200 1 180 $X=2886500 $Y=4179200
X59 112 195 64 603 282 NAND2XL $T=2923800 3981600 0 180 $X=2899700 $Y=3925800
X60 397 195 64 439 461 NAND2XL $T=2910600 3880800 0 0 $X=2906300 $Y=3876800
X61 118 195 64 115 285 NAND2XL $T=2923800 3679200 0 0 $X=2919500 $Y=3675200
X62 460 195 64 190 462 NAND2XL $T=2950200 4082400 0 180 $X=2926100 $Y=4026600
X63 457 195 64 449 469 NAND2XL $T=2943600 4183200 1 0 $X=2939300 $Y=4127400
X64 467 195 64 469 473 NAND2XL $T=2950200 4082400 1 0 $X=2945900 $Y=4026600
X65 461 195 64 466 476 NAND2XL $T=2970000 3880800 0 0 $X=2965700 $Y=3876800
X66 467 195 64 457 479 NAND2XL $T=2970000 4082400 0 0 $X=2965700 $Y=4078400
X67 300 195 64 57 286 NAND2XL $T=2989800 4183200 0 180 $X=2965700 $Y=4127400
X68 405 195 64 114 287 NAND2XL $T=3003000 3679200 0 180 $X=2978900 $Y=3623400
X69 473 195 64 478 645 NAND2XL $T=3003000 4082400 0 180 $X=2978900 $Y=4026600
X70 483 195 64 487 490 NAND2XL $T=3022800 3880800 1 0 $X=3018500 $Y=3825000
X71 112 195 64 608 289 NAND2XL $T=3042600 3981600 0 0 $X=3038300 $Y=3977600
X72 92 195 64 295 494 NAND2XL $T=3062400 4082400 1 0 $X=3058100 $Y=4026600
X73 500 195 64 39 480 NAND2XL $T=3082200 4183200 0 180 $X=3058100 $Y=4127400
X74 262 195 64 300 495 NAND2XL $T=3069000 4082400 0 0 $X=3064700 $Y=4078400
X75 112 195 64 491 290 NAND2XL $T=3075600 3981600 0 0 $X=3071300 $Y=3977600
X76 480 195 64 489 499 NAND2XL $T=3075600 4183200 0 0 $X=3071300 $Y=4179200
X77 112 195 64 294 293 NAND2XL $T=3102000 3981600 0 0 $X=3097700 $Y=3977600
X78 291 195 64 500 502 NAND2XL $T=3121800 4082400 0 0 $X=3117500 $Y=4078400
X79 501 195 64 301 296 NAND2XL $T=3148200 4082400 0 180 $X=3124100 $Y=4026600
X80 112 195 64 299 614 NAND2XL $T=3154800 3981600 0 0 $X=3150500 $Y=3977600
X81 263 195 64 460 505 NAND2XL $T=3181200 4082400 1 0 $X=3176900 $Y=4026600
X82 502 195 64 506 510 NAND2XL $T=3220800 4183200 1 0 $X=3216500 $Y=4127400
X83 505 195 64 619 514 NAND2XL $T=3253800 3981600 1 180 $X=3229700 $Y=3977600
X84 93 195 64 303 624 NAND2XL $T=3293400 3780000 1 0 $X=3289100 $Y=3724200
X85 494 195 64 512 530 NAND2XL $T=3319800 4082400 0 0 $X=3315500 $Y=4078400
X86 624 195 64 522 140 NAND2XL $T=3326400 3679200 0 0 $X=3322100 $Y=3675200
X87 93 195 64 305 527 NAND2XL $T=3326400 3780000 1 0 $X=3322100 $Y=3724200
X88 398 195 64 307 306 NAND2XL $T=3339600 3780000 0 0 $X=3335300 $Y=3776000
X89 185 195 64 515 531 NAND2XL $T=3352800 3880800 1 0 $X=3348500 $Y=3825000
X90 522 195 64 626 138 NAND2XL $T=3385800 3679200 1 0 $X=3381500 $Y=3623400
X91 396 195 64 477 537 NAND2XL $T=3385800 3981600 1 0 $X=3381500 $Y=3925800
X92 123 195 64 310 546 NAND2XL $T=3392400 3780000 0 0 $X=3388100 $Y=3776000
X93 375 195 64 529 535 NAND2XL $T=3392400 3981600 0 0 $X=3388100 $Y=3977600
X94 527 195 64 627 536 NAND2XL $T=3399000 3780000 1 0 $X=3394700 $Y=3724200
X95 531 195 64 533 540 NAND2XL $T=3425400 3880800 1 0 $X=3421100 $Y=3825000
X96 535 195 64 630 543 NAND2XL $T=3451800 3981600 0 0 $X=3447500 $Y=3977600
X97 544 195 64 541 629 NAND2XL $T=3478200 3880800 0 180 $X=3454100 $Y=3825000
X98 536 195 64 314 631 NAND2XL $T=3478200 3780000 1 0 $X=3473900 $Y=3724200
X99 543 195 64 548 648 NAND2XL $T=3478200 3981600 0 0 $X=3473900 $Y=3977600
X100 546 195 64 195 554 NAND2XL $T=3511200 3780000 0 0 $X=3506900 $Y=3776000
X101 537 195 64 549 551 NAND2XL $T=3511200 3981600 1 0 $X=3506900 $Y=3925800
X102 554 195 64 316 635 NAND2XL $T=3583800 3780000 0 0 $X=3579500 $Y=3776000
X103 248 195 64 557 319 NAND2XL $T=3755400 3679200 1 180 $X=3731300 $Y=3675200
X104 560 195 64 563 564 NAND2XL $T=3828000 3780000 1 0 $X=3823700 $Y=3724200
X105 251 195 64 320 565 NAND2XL $T=3874200 3679200 1 180 $X=3850100 $Y=3675200
X106 567 195 64 566 636 NAND2XL $T=3874200 3880800 0 180 $X=3850100 $Y=3825000
X107 321 195 64 638 567 NAND2XL $T=3933600 3780000 1 180 $X=3909500 $Y=3776000
X108 558 195 64 202 321 NAND2XL $T=3966600 3780000 1 0 $X=3962300 $Y=3724200
X109 64 399 342 264 195 NOR2XL $T=2521200 3981600 0 180 $X=2497100 $Y=3925800
X110 64 126 362 402 195 NOR2XL $T=2600400 3880800 1 180 $X=2576300 $Y=3876800
X111 64 102 391 406 195 NOR2XL $T=2613600 3780000 0 180 $X=2589500 $Y=3724200
X112 64 266 413 408 195 NOR2XL $T=2620200 3880800 0 180 $X=2596100 $Y=3825000
X113 64 264 402 412 195 NOR2XL $T=2607000 3981600 0 0 $X=2602700 $Y=3977600
X114 64 99 126 420 195 NOR2XL $T=2620200 3679200 0 0 $X=2615900 $Y=3675200
X115 64 406 408 415 195 NOR2XL $T=2633400 3880800 0 0 $X=2629100 $Y=3876800
X116 64 186 399 417 195 NOR2XL $T=2640000 3780000 1 0 $X=2635700 $Y=3724200
X117 64 104 266 187 195 NOR2XL $T=2666400 3679200 0 0 $X=2662100 $Y=3675200
X118 64 417 420 422 195 NOR2XL $T=2666400 3780000 1 0 $X=2662100 $Y=3724200
X119 64 596 267 426 195 NOR2XL $T=2699400 3880800 0 0 $X=2695100 $Y=3876800
X120 64 188 187 594 195 NOR2XL $T=2706000 3679200 1 0 $X=2701700 $Y=3623400
X121 64 114 333 431 195 NOR2XL $T=2739000 3981600 1 180 $X=2714900 $Y=3977600
X122 64 115 268 269 195 NOR2XL $T=2752200 3981600 0 180 $X=2728100 $Y=3925800
X123 64 439 273 435 195 NOR2XL $T=2778600 3880800 1 180 $X=2754500 $Y=3876800
X124 64 269 431 441 195 NOR2XL $T=2765400 4082400 0 0 $X=2761100 $Y=4078400
X125 64 444 435 275 195 NOR2XL $T=2798400 3981600 0 180 $X=2774300 $Y=3925800
X126 64 450 116 444 195 NOR2XL $T=2831400 3880800 1 180 $X=2807300 $Y=3876800
X127 64 453 443 598 195 NOR2XL $T=2844600 4183200 1 180 $X=2820500 $Y=4179200
X128 64 295 367 454 195 NOR2XL $T=2884200 4082400 1 180 $X=2860100 $Y=4078400
X129 64 118 115 465 195 NOR2XL $T=2877600 3679200 0 0 $X=2873300 $Y=3675200
X130 64 93 450 283 195 NOR2XL $T=2884200 3880800 1 0 $X=2879900 $Y=3825000
X131 64 460 190 459 195 NOR2XL $T=2923800 4082400 0 180 $X=2899700 $Y=4026600
X132 64 459 454 602 195 NOR2XL $T=2923800 4183200 0 180 $X=2899700 $Y=4127400
X133 64 397 439 606 195 NOR2XL $T=2917200 3880800 1 0 $X=2912900 $Y=3825000
X134 64 405 114 470 195 NOR2XL $T=2956800 3679200 1 0 $X=2952500 $Y=3623400
X135 64 283 606 483 195 NOR2XL $T=2956800 3880800 1 0 $X=2952500 $Y=3825000
X136 64 474 288 464 195 NOR2XL $T=3009600 4183200 1 180 $X=2985500 $Y=4179200
X137 64 479 463 484 195 NOR2XL $T=2996400 4082400 0 0 $X=2992100 $Y=4078400
X138 64 300 57 474 195 NOR2XL $T=3016200 4183200 0 180 $X=2992100 $Y=4127400
X139 64 465 470 487 195 NOR2XL $T=3022800 3780000 1 0 $X=3018500 $Y=3724200
X140 64 500 39 288 195 NOR2XL $T=3055800 4183200 0 180 $X=3031700 $Y=4127400
X141 64 296 490 612 195 NOR2XL $T=3108600 3981600 0 180 $X=3084500 $Y=3925800
X142 64 291 500 498 195 NOR2XL $T=3088800 4183200 1 0 $X=3084500 $Y=4127400
X143 64 262 300 497 195 NOR2XL $T=3095400 4082400 1 0 $X=3091100 $Y=4026600
X144 64 131 127 192 195 NOR2XL $T=3141600 3679200 0 180 $X=3117500 $Y=3623400
X145 64 497 498 501 195 NOR2XL $T=3121800 4183200 1 0 $X=3117500 $Y=4127400
X146 64 92 295 298 195 NOR2XL $T=3128400 3981600 0 0 $X=3124100 $Y=3977600
X147 64 131 233 617 195 NOR2XL $T=3161400 3679200 1 0 $X=3157100 $Y=3623400
X148 64 263 460 616 195 NOR2XL $T=3194400 3981600 0 0 $X=3190100 $Y=3977600
X149 64 131 303 508 195 NOR2XL $T=3207600 3679200 0 0 $X=3203300 $Y=3675200
X150 64 131 310 620 195 NOR2XL $T=3214200 3780000 1 0 $X=3209900 $Y=3724200
X151 64 616 298 301 195 NOR2XL $T=3220800 4082400 1 0 $X=3216500 $Y=4026600
X152 64 131 515 621 195 NOR2XL $T=3253800 3780000 0 0 $X=3249500 $Y=3776000
X153 64 131 477 516 195 NOR2XL $T=3253800 3880800 1 0 $X=3249500 $Y=3825000
X154 64 514 520 623 195 NOR2XL $T=3280200 3981600 0 0 $X=3275900 $Y=3977600
X155 64 185 515 311 195 NOR2XL $T=3333000 3880800 1 0 $X=3328700 $Y=3825000
X156 64 131 529 304 195 NOR2XL $T=3359400 3981600 0 180 $X=3335300 $Y=3925800
X157 64 131 307 525 195 NOR2XL $T=3366000 3880800 1 180 $X=3341900 $Y=3876800
X158 64 93 305 309 195 NOR2XL $T=3352800 3780000 1 0 $X=3348500 $Y=3724200
X159 64 131 305 526 195 NOR2XL $T=3379200 3981600 0 180 $X=3355100 $Y=3925800
X160 64 398 307 532 195 NOR2XL $T=3366000 3780000 0 0 $X=3361700 $Y=3776000
X161 64 375 529 534 195 NOR2XL $T=3366000 3981600 0 0 $X=3361700 $Y=3977600
X162 64 532 309 626 195 NOR2XL $T=3412200 3679200 1 180 $X=3388100 $Y=3675200
X163 64 396 477 539 195 NOR2XL $T=3392400 3880800 0 0 $X=3388100 $Y=3876800
X164 64 123 310 538 195 NOR2XL $T=3418800 3780000 0 0 $X=3414500 $Y=3776000
X165 64 534 539 541 195 NOR2XL $T=3438600 3981600 1 0 $X=3434300 $Y=3925800
X166 64 311 538 544 195 NOR2XL $T=3451800 3780000 0 0 $X=3447500 $Y=3776000
X167 64 540 552 553 195 NOR2XL $T=3537600 3880800 1 0 $X=3533300 $Y=3825000
X168 64 551 545 634 195 NOR2XL $T=3544200 3981600 1 0 $X=3539900 $Y=3925800
X169 64 248 557 556 195 NOR2XL $T=3762000 3780000 0 180 $X=3737900 $Y=3724200
X170 64 560 563 568 195 NOR2XL $T=3801600 3780000 1 0 $X=3797300 $Y=3724200
X171 64 568 569 637 195 NOR2XL $T=3880800 3780000 1 0 $X=3876500 $Y=3724200
X172 64 558 202 569 195 NOR2XL $T=3966600 3780000 0 180 $X=3942500 $Y=3724200
X173 640 64 195 413 INVXL $T=1353000 3780000 0 0 $X=1348700 $Y=3776000
X174 217 64 195 367 INVXL $T=1458600 3981600 0 0 $X=1454300 $Y=3977600
X175 402 64 195 401 INVXL $T=2567400 3981600 1 180 $X=2549900 $Y=3977600
X176 103 64 195 410 INVXL $T=2640000 4082400 0 180 $X=2622500 $Y=4026600
X177 408 64 195 418 INVXL $T=2659800 3880800 0 0 $X=2655500 $Y=3876800
X178 420 64 195 432 INVXL $T=2692800 3780000 1 0 $X=2688500 $Y=3724200
X179 270 64 195 276 INVXL $T=2752200 4082400 0 0 $X=2747900 $Y=4078400
X180 271 64 195 433 INVXL $T=2758800 4183200 1 0 $X=2754500 $Y=4127400
X181 435 64 195 440 INVXL $T=2765400 3981600 1 0 $X=2761100 $Y=3925800
X182 454 64 195 457 INVXL $T=2890800 4183200 1 0 $X=2886500 $Y=4127400
X183 602 64 195 604 INVXL $T=2910600 4183200 0 0 $X=2906300 $Y=4179200
X184 449 64 195 463 INVXL $T=2930400 4183200 1 0 $X=2926100 $Y=4127400
X185 284 64 195 644 INVXL $T=2930400 4183200 0 0 $X=2926100 $Y=4179200
X186 606 64 195 466 INVXL $T=2943600 3880800 1 0 $X=2939300 $Y=3825000
X187 288 64 195 489 INVXL $T=3022800 4183200 1 0 $X=3018500 $Y=4127400
X188 447 64 195 485 INVXL $T=3082200 3880800 0 180 $X=3064700 $Y=3825000
X189 502 64 195 504 INVXL $T=3187800 4183200 1 0 $X=3183500 $Y=4127400
X190 498 64 195 506 INVXL $T=3201000 4183200 1 0 $X=3196700 $Y=4127400
X191 616 64 195 619 INVXL $T=3220800 3981600 0 0 $X=3216500 $Y=3977600
X192 298 64 195 512 INVXL $T=3253800 4082400 1 0 $X=3249500 $Y=4026600
X193 494 64 195 622 INVXL $T=3267000 4082400 1 0 $X=3262700 $Y=4026600
X194 624 64 195 625 INVXL $T=3326400 3679200 1 0 $X=3322100 $Y=3623400
X195 493 64 195 521 INVXL $T=3326400 4082400 1 0 $X=3322100 $Y=4026600
X196 311 64 195 533 INVXL $T=3379200 3880800 1 0 $X=3374900 $Y=3825000
X197 309 64 195 627 INVXL $T=3385800 3780000 1 0 $X=3381500 $Y=3724200
X198 534 64 195 630 INVXL $T=3432000 4082400 1 0 $X=3427700 $Y=4026600
X199 538 64 195 195 INVXL $T=3471600 3780000 0 0 $X=3467300 $Y=3776000
X200 546 64 195 547 INVXL $T=3478200 3880800 1 0 $X=3473900 $Y=3825000
X201 523 64 195 316 INVXL $T=3491400 3780000 0 0 $X=3487100 $Y=3776000
X202 539 64 195 549 INVXL $T=3498000 3981600 1 0 $X=3493700 $Y=3925800
X203 559 64 195 562 INVXL $T=3781800 3780000 1 0 $X=3777500 $Y=3724200
X204 569 64 195 638 INVXL $T=3946800 3780000 1 180 $X=3929300 $Y=3776000
X205 404 195 264 400 64 407 OAI21XL $T=2567400 3981600 0 0 $X=2563100 $Y=3977600
X206 416 195 406 590 64 265 OAI21XL $T=2653200 3880800 0 180 $X=2622500 $Y=3825000
X207 408 195 267 416 64 423 OAI21XL $T=2666400 3880800 1 0 $X=2662100 $Y=3825000
X208 106 195 188 230 64 592 OAI21XL $T=2673000 3679200 1 0 $X=2668700 $Y=3623400
X209 591 195 103 419 64 271 OAI21XL $T=2673000 3981600 0 0 $X=2668700 $Y=3977600
X210 274 195 417 425 64 272 OAI21XL $T=2712600 3780000 0 0 $X=2708300 $Y=3776000
X211 431 195 433 270 64 593 OAI21XL $T=2745600 4183200 0 180 $X=2714900 $Y=4127400
X212 414 195 423 595 64 427 OAI21XL $T=2752200 3880800 0 180 $X=2721500 $Y=3825000
X213 270 195 269 428 64 270 OAI21XL $T=2745600 4082400 1 0 $X=2741300 $Y=4026600
X214 429 195 231 421 64 447 OAI21XL $T=2772000 3679200 1 0 $X=2767700 $Y=3623400
X215 443 195 433 448 64 449 OAI21XL $T=2791800 4183200 1 0 $X=2787500 $Y=4127400
X216 436 195 444 451 64 599 OAI21XL $T=2805000 3981600 1 0 $X=2800700 $Y=3925800
X217 448 195 453 601 64 600 OAI21XL $T=2877600 4183200 1 180 $X=2846900 $Y=4179200
X218 467 195 459 462 64 284 OAI21XL $T=2917200 4082400 0 0 $X=2912900 $Y=4078400
X219 461 195 283 458 64 468 OAI21XL $T=2937000 3880800 0 0 $X=2932700 $Y=3876800
X220 604 195 463 644 64 471 OAI21XL $T=2950200 4183200 0 0 $X=2945900 $Y=4179200
X221 480 195 474 286 64 605 OAI21XL $T=2996400 4284000 0 180 $X=2965700 $Y=4228200
X222 287 195 465 285 64 475 OAI21XL $T=3003000 3679200 1 180 $X=2972300 $Y=3675200
X223 470 195 485 287 64 610 OAI21XL $T=3009600 3679200 0 0 $X=3005300 $Y=3675200
X224 473 195 478 645 64 608 OAI21XL $T=3009600 4082400 1 0 $X=3005300 $Y=4026600
X225 490 195 485 292 64 493 OAI21XL $T=3049200 3981600 1 0 $X=3044900 $Y=3925800
X226 296 195 292 297 64 496 OAI21XL $T=3121800 3981600 1 0 $X=3117500 $Y=3925800
X227 502 195 497 495 64 613 OAI21XL $T=3181200 4183200 0 180 $X=3150500 $Y=4127400
X228 494 195 616 505 64 503 OAI21XL $T=3220800 4082400 1 180 $X=3190100 $Y=4078400
X229 306 195 309 527 64 308 OAI21XL $T=3379200 3679200 1 180 $X=3348500 $Y=3675200
X230 546 195 311 531 64 313 OAI21XL $T=3418800 3880800 0 180 $X=3388100 $Y=3825000
X231 532 195 196 306 64 314 OAI21XL $T=3418800 3679200 0 0 $X=3414500 $Y=3675200
X232 534 195 537 535 64 628 OAI21XL $T=3418800 3981600 0 0 $X=3414500 $Y=3977600
X233 629 195 523 312 64 141 OAI21XL $T=3465000 3780000 0 180 $X=3434300 $Y=3724200
X234 539 195 545 537 64 548 OAI21XL $T=3465000 3981600 1 0 $X=3460700 $Y=3925800
X235 536 195 314 631 64 550 OAI21XL $T=3498000 3679200 0 0 $X=3493700 $Y=3675200
X236 543 195 548 648 64 632 OAI21XL $T=3504600 3981600 0 0 $X=3500300 $Y=3977600
X237 197 195 550 315 64 151 OAI21XL $T=3524400 3679200 0 0 $X=3520100 $Y=3675200
X238 554 195 316 635 64 633 OAI21XL $T=3550800 3780000 0 0 $X=3546500 $Y=3776000
X239 556 195 199 319 64 559 OAI21XL $T=3682800 3780000 1 0 $X=3678500 $Y=3724200
X240 568 195 562 564 64 566 OAI21XL $T=3880800 3780000 0 180 $X=3850100 $Y=3724200
X241 567 195 566 636 64 320 OAI21XL $T=3874200 3780000 0 0 $X=3869900 $Y=3776000
X242 564 195 569 321 64 639 OAI21XL $T=3913800 3780000 1 0 $X=3909500 $Y=3724200
X243 412 410 64 407 653 195 267 AOI21XL $T=2633400 3981600 0 0 $X=2629100 $Y=3977600
X244 407 415 64 265 654 195 419 AOI21XL $T=2646600 3981600 1 0 $X=2642300 $Y=3925800
X245 272 594 64 592 655 195 421 AOI21XL $T=2719200 3679200 1 180 $X=2688500 $Y=3675200
X246 596 267 64 426 596 195 430 AOI21XL $T=2752200 3880800 1 180 $X=2721500 $Y=3876800
X247 422 109 64 272 656 195 110 AOI21XL $T=2745600 3679200 0 0 $X=2741300 $Y=3675200
X248 270 275 64 599 657 195 448 AOI21XL $T=2824800 4082400 0 0 $X=2820500 $Y=4078400
X249 284 464 64 605 658 195 601 AOI21XL $T=2943600 4284000 0 180 $X=2912900 $Y=4228200
X250 475 483 64 468 659 195 292 AOI21XL $T=2996400 3880800 1 0 $X=2992100 $Y=3825000
X251 479 463 64 484 660 195 491 AOI21XL $T=3029400 4082400 0 0 $X=3025100 $Y=4078400
X252 447 612 64 496 661 195 236 AOI21XL $T=3128400 3880800 1 180 $X=3097700 $Y=3876800
X253 503 501 64 613 662 195 297 AOI21XL $T=3181200 4082400 1 180 $X=3150500 $Y=4078400
X254 506 517 64 504 663 195 511 AOI21XL $T=3280200 4183200 0 180 $X=3249500 $Y=4127400
X255 239 240 64 241 664 195 523 AOI21XL $T=3286800 3679200 1 0 $X=3282500 $Y=3623400
X256 512 493 64 622 665 195 520 AOI21XL $T=3319800 4082400 0 180 $X=3289100 $Y=4026600
X257 514 520 64 623 666 195 307 AOI21XL $T=3306600 3981600 0 0 $X=3302300 $Y=3977600
X258 522 308 64 625 667 195 242 AOI21XL $T=3379200 3679200 0 180 $X=3348500 $Y=3623400
X259 626 141 64 308 668 195 243 AOI21XL $T=3405600 3679200 1 0 $X=3401300 $Y=3623400
X260 313 541 64 628 669 195 312 AOI21XL $T=3458400 3880800 1 180 $X=3427700 $Y=3876800
X261 544 316 64 313 670 195 545 AOI21XL $T=3504600 3880800 1 180 $X=3473900 $Y=3876800
X262 195 316 64 547 671 195 552 AOI21XL $T=3498000 3880800 1 0 $X=3493700 $Y=3825000
X263 551 545 64 634 672 195 317 AOI21XL $T=3550800 3880800 0 0 $X=3546500 $Y=3876800
X264 559 637 64 639 673 195 255 AOI21XL $T=3907200 3679200 0 0 $X=3902900 $Y=3675200
X265 6 40 675 674 64 676 8 195 677 64 DFFSXL $T=396000 3679200 0 0 $X=391700 $Y=3675200
X266 6 54 679 678 64 680 204 195 681 64 DFFSXL $T=396000 3780000 0 0 $X=391700 $Y=3776000
X267 6 21 683 682 64 684 205 195 685 64 DFFSXL $T=415800 3679200 1 0 $X=411500 $Y=3623400
X268 10 40 687 686 64 688 28 195 689 64 DFFSXL $T=541200 3780000 1 0 $X=536900 $Y=3724200
X269 10 169 691 690 64 692 327 195 693 64 DFFSXL $T=554400 3679200 0 0 $X=550100 $Y=3675200
X270 13 34 695 694 64 696 15 195 697 64 DFFSXL $T=666600 3880800 0 0 $X=662300 $Y=3876800
X271 10 74 699 698 64 700 207 195 701 64 DFFSXL $T=686400 3679200 1 0 $X=682100 $Y=3623400
X272 14 74 703 702 64 704 27 195 705 64 DFFSXL $T=699600 4082400 1 0 $X=695300 $Y=4026600
X273 13 54 54 706 64 707 328 195 708 64 DFFSXL $T=732600 3780000 0 0 $X=728300 $Y=3776000
X274 13 21 710 709 64 711 208 195 712 64 DFFSXL $T=785400 3780000 1 0 $X=781100 $Y=3724200
X275 14 65 714 713 64 715 326 195 716 64 DFFSXL $T=818400 3981600 1 0 $X=814100 $Y=3925800
X276 13 23 718 717 64 719 209 195 720 64 DFFSXL $T=825000 3679200 1 0 $X=820700 $Y=3623400
X277 14 169 722 721 64 723 334 195 724 64 DFFSXL $T=831600 3981600 0 0 $X=827300 $Y=3977600
X278 14 21 726 725 64 727 210 195 728 64 DFFSXL $T=924000 3780000 0 0 $X=919700 $Y=3776000
X279 14 19 730 729 64 731 24 195 732 64 DFFSXL $T=937200 4082400 1 0 $X=932900 $Y=4026600
X280 14 40 734 733 339 735 31 195 736 64 DFFSXL $T=943800 4082400 0 0 $X=939500 $Y=4078400
X281 14 61 738 737 339 739 340 195 740 64 DFFSXL $T=950400 4183200 1 0 $X=946100 $Y=4127400
X282 13 90 742 741 64 743 211 195 744 64 DFFSXL $T=970200 3679200 1 0 $X=965900 $Y=3623400
X283 13 40 746 745 339 747 29 195 748 64 DFFSXL $T=990000 3981600 1 0 $X=985700 $Y=3925800
X284 13 19 750 749 339 751 25 195 752 64 DFFSXL $T=996600 3981600 0 0 $X=992300 $Y=3977600
X285 13 43 754 753 339 755 570 195 756 64 DFFSXL $T=1009800 3679200 0 0 $X=1005500 $Y=3675200
X286 10 34 758 757 339 759 338 195 760 64 DFFSXL $T=1049400 3780000 0 0 $X=1045100 $Y=3776000
X287 13 1 762 761 339 763 575 195 764 64 DFFSXL $T=1075800 4082400 1 0 $X=1071500 $Y=4026600
X288 10 61 766 765 339 767 571 195 768 64 DFFSXL $T=1082400 4082400 0 0 $X=1078100 $Y=4078400
X289 10 19 770 769 339 771 32 195 772 64 DFFSXL $T=1089000 4183200 1 0 $X=1084700 $Y=4127400
X290 14 43 774 773 339 775 343 195 776 64 DFFSXL $T=1148400 3679200 0 0 $X=1144100 $Y=3675200
X291 10 1 778 777 339 779 354 195 780 64 DFFSXL $T=1221000 4183200 0 0 $X=1216700 $Y=4179200
X292 13 73 782 781 339 783 257 195 784 64 DFFSXL $T=1247400 3981600 0 0 $X=1243100 $Y=3977600
X293 37 23 786 785 339 787 347 195 788 64 DFFSXL $T=1313400 3780000 1 0 $X=1309100 $Y=3724200
X294 37 34 790 789 339 791 216 195 792 64 DFFSXL $T=1333200 3679200 0 0 $X=1328900 $Y=3675200
X295 10 97 97 793 339 794 47 195 795 64 DFFSXL $T=1359600 4183200 1 0 $X=1355300 $Y=4127400
X296 37 40 797 796 339 798 364 195 799 64 DFFSXL $T=1366200 3880800 0 0 $X=1361900 $Y=3876800
X297 37 43 801 800 339 802 337 195 803 64 DFFSXL $T=1379400 3981600 1 0 $X=1375100 $Y=3925800
X298 37 74 805 804 64 806 363 195 807 64 DFFSXL $T=1445400 3780000 0 0 $X=1441100 $Y=3776000
X299 37 73 73 808 64 809 348 195 810 64 DFFSXL $T=1485000 3880800 1 0 $X=1480700 $Y=3825000
X300 52 169 812 811 178 813 350 195 814 64 DFFSXL $T=1491600 3679200 1 0 $X=1487300 $Y=3623400
X301 37 35 816 815 64 817 360 195 818 64 DFFSXL $T=1491600 4082400 0 0 $X=1487300 $Y=4078400
X302 37 65 820 819 64 821 365 195 822 64 DFFSXL $T=1498200 3981600 0 0 $X=1493900 $Y=3977600
X303 37 66 824 823 64 825 366 195 826 64 DFFSXL $T=1498200 4183200 1 0 $X=1493900 $Y=4127400
X304 37 97 828 827 64 829 359 195 830 64 DFFSXL $T=1498200 4183200 0 0 $X=1493900 $Y=4179200
X305 72 23 832 831 64 833 374 195 834 64 DFFSXL $T=1623600 4082400 1 0 $X=1619300 $Y=4026600
X306 72 66 836 835 64 837 259 195 838 64 DFFSXL $T=1630200 3981600 1 0 $X=1625900 $Y=3925800
X307 72 73 840 839 64 841 383 195 842 64 DFFSXL $T=1643400 4082400 0 0 $X=1639100 $Y=4078400
X308 72 97 844 843 64 845 219 195 846 64 DFFSXL $T=1650000 3880800 1 0 $X=1645700 $Y=3825000
X309 72 35 848 847 64 849 370 195 850 64 DFFSXL $T=1656600 4284000 1 0 $X=1652300 $Y=4228200
X310 72 74 852 851 64 853 372 195 854 64 DFFSXL $T=1696200 3780000 1 0 $X=1691900 $Y=3724200
X311 78 73 856 855 64 857 641 195 858 64 DFFSXL $T=1775400 3880800 1 0 $X=1771100 $Y=3825000
X312 78 35 860 859 64 861 583 195 862 64 DFFSXL $T=1775400 3981600 0 0 $X=1771100 $Y=3977600
X313 78 97 864 863 64 865 85 195 866 64 DFFSXL $T=1775400 4082400 1 0 $X=1771100 $Y=4026600
X314 78 23 868 867 64 869 380 195 870 64 DFFSXL $T=1795200 4183200 0 0 $X=1790900 $Y=4179200
X315 78 21 872 871 178 873 377 195 874 64 DFFSXL $T=1834800 3679200 0 0 $X=1830500 $Y=3675200
X316 89 74 876 875 64 877 393 195 878 64 DFFSXL $T=1947000 3780000 1 0 $X=1942700 $Y=3724200
X317 89 35 880 879 64 881 394 195 882 64 DFFSXL $T=1960200 4082400 1 0 $X=1955900 $Y=4026600
X318 89 43 884 883 64 885 586 195 886 64 DFFSXL $T=1966800 3981600 0 0 $X=1962500 $Y=3977600
X319 89 23 888 887 64 889 587 195 890 64 DFFSXL $T=1966800 4183200 1 0 $X=1962500 $Y=4127400
X320 89 66 892 891 178 893 588 195 894 64 DFFSXL $T=1973400 3679200 0 0 $X=1969100 $Y=3675200
X321 89 73 896 895 64 897 589 195 898 64 DFFSXL $T=1973400 3880800 1 0 $X=1969100 $Y=3825000
X322 89 90 900 899 64 901 94 195 902 64 DFFSXL $T=1973400 3880800 0 0 $X=1969100 $Y=3876800
X323 98 74 904 903 64 905 93 195 906 64 DFFSXL $T=2079000 3780000 0 0 $X=2074700 $Y=3776000
X324 96 43 908 907 64 909 384 195 910 64 DFFSXL $T=2138400 4183200 1 0 $X=2134100 $Y=4127400
X325 96 97 912 911 64 913 225 195 914 64 DFFSXL $T=2158200 3981600 0 0 $X=2153900 $Y=3977600
X326 96 74 916 915 64 917 379 195 918 64 DFFSXL $T=2164800 3880800 1 0 $X=2160500 $Y=3825000
X327 96 66 920 919 64 921 386 195 922 64 DFFSXL $T=2171400 3679200 0 0 $X=2167100 $Y=3675200
X328 98 66 924 923 64 925 291 195 926 64 DFFSXL $T=2184600 3780000 1 0 $X=2180300 $Y=3724200
X329 226 43 928 927 64 929 375 195 930 64 DFFSXL $T=2283600 4082400 0 0 $X=2279300 $Y=4078400
X330 98 73 932 931 64 933 397 195 934 64 DFFSXL $T=2303400 3780000 0 0 $X=2299100 $Y=3776000
X331 98 1 936 935 64 937 186 195 938 64 DFFSXL $T=2310000 3780000 1 0 $X=2305700 $Y=3724200
X332 98 35 940 939 64 941 262 195 942 64 DFFSXL $T=2409000 3981600 0 0 $X=2404700 $Y=3977600
X333 98 23 944 943 64 945 263 195 946 64 DFFSXL $T=2409000 4082400 1 0 $X=2404700 $Y=4026600
X334 98 97 948 947 64 949 100 195 950 64 DFFSXL $T=2415600 3880800 0 0 $X=2411300 $Y=3876800
X335 98 65 952 951 64 953 405 195 954 64 DFFSXL $T=2461800 3780000 1 0 $X=2457500 $Y=3724200
X336 98 34 956 955 64 957 101 195 958 64 DFFSXL $T=2461800 3780000 0 0 $X=2457500 $Y=3776000
X337 122 438 960 959 64 961 266 195 235 64 DFFSXL $T=2831400 3679200 1 0 $X=2827100 $Y=3623400
X338 122 280 963 962 64 964 439 195 507 64 DFFSXL $T=2851200 3780000 1 0 $X=2846900 $Y=3724200
X339 122 282 966 965 64 967 450 195 481 64 DFFSXL $T=2877600 3780000 0 0 $X=2873300 $Y=3776000
X340 122 455 969 968 132 970 399 195 615 64 DFFSXL $T=3082200 3679200 0 0 $X=3077900 $Y=3675200
X341 122 290 972 971 132 973 295 195 509 64 DFFSXL $T=3102000 3780000 0 0 $X=3097700 $Y=3776000
X342 122 293 975 974 132 976 300 195 302 64 DFFSXL $T=3108600 3880800 1 0 $X=3104300 $Y=3825000
X343 122 289 978 977 132 979 460 195 647 64 DFFSXL $T=3154800 3880800 0 0 $X=3150500 $Y=3876800
X344 122 614 981 980 132 982 500 195 646 64 DFFSXL $T=3161400 3981600 1 0 $X=3157100 $Y=3925800
X345 158 565 984 983 132 985 253 195 986 64 DFFSXL $T=3867600 3679200 1 0 $X=3863300 $Y=3623400
X346 264 195 400 987 64 409 NAND2BXL $T=2580600 4082400 1 0 $X=2576300 $Y=4026600
X347 406 195 590 988 64 414 NAND2BXL $T=2633400 3780000 0 0 $X=2629100 $Y=3776000
X348 269 195 428 989 64 424 NAND2BXL $T=2739000 4082400 0 180 $X=2708300 $Y=4026600
X349 431 195 270 990 64 434 NAND2BXL $T=2725800 4183200 0 0 $X=2721500 $Y=4179200
X350 187 195 106 991 64 189 NAND2BXL $T=2732400 3679200 1 0 $X=2728100 $Y=3623400
X351 417 195 425 992 64 597 NAND2BXL $T=2758800 3780000 0 0 $X=2754500 $Y=3776000
X352 444 195 451 993 64 456 NAND2BXL $T=2844600 3981600 1 0 $X=2840300 $Y=3925800
X353 283 195 458 994 64 472 NAND2BXL $T=2950200 3981600 1 0 $X=2945900 $Y=3925800
X354 459 195 462 995 64 478 NAND2BXL $T=2950200 3981600 0 0 $X=2945900 $Y=3977600
X355 465 195 285 285 64 482 NAND2BXL $T=2989800 3780000 1 0 $X=2985500 $Y=3724200
X356 470 195 287 996 64 609 NAND2BXL $T=3009600 3679200 1 0 $X=3005300 $Y=3623400
X357 475 195 486 997 64 488 NAND2BXL $T=3009600 3780000 0 0 $X=3005300 $Y=3776000
X358 474 195 286 998 64 611 NAND2BXL $T=3009600 4284000 1 0 $X=3005300 $Y=4228200
X359 485 195 487 999 64 486 NAND2BXL $T=3069000 3780000 1 180 $X=3038300 $Y=3776000
X360 497 195 495 1000 64 618 NAND2BXL $T=3181200 4183200 0 0 $X=3176900 $Y=4179200
X361 503 195 513 1001 64 517 NAND2BXL $T=3247200 4082400 0 0 $X=3242900 $Y=4078400
X362 521 195 301 1002 64 513 NAND2BXL $T=3306600 4082400 1 180 $X=3275900 $Y=4078400
X363 532 195 306 1003 64 542 NAND2BXL $T=3451800 3679200 0 0 $X=3447500 $Y=3675200
X364 556 195 319 1004 64 555 NAND2BXL $T=3676200 3780000 0 180 $X=3645500 $Y=3724200
X365 568 195 564 1005 64 561 NAND2BXL $T=3854400 3780000 1 180 $X=3823700 $Y=3776000
X366 434 433 195 64 278 XOR2XL $T=2758800 4183200 0 0 $X=2754500 $Y=4179200
X367 609 485 195 64 237 XOR2XL $T=3049200 3679200 1 0 $X=3044900 $Y=3623400
X368 542 196 195 64 244 XOR2XL $T=3478200 3679200 1 0 $X=3473900 $Y=3623400
X369 199 555 195 64 200 XOR2XL $T=3676200 3679200 0 0 $X=3671900 $Y=3675200
X370 562 561 195 64 156 XOR2XL $T=3768600 3780000 0 0 $X=3764300 $Y=3776000
X371 150 194 1007 153 1006 1008 558 558 195 64 563 CMPR32X1 $T=3630000 3679200 1 0 $X=3625700 $Y=3623400
X372 197 632 195 528 64 143 OAI21X1 $T=3550800 3780000 0 180 $X=3513500 $Y=3724200
X373 197 633 195 518 64 245 OAI21X1 $T=3550800 3679200 0 0 $X=3546500 $Y=3675200
X374 197 318 195 519 64 246 OAI21X1 $T=3583800 3679200 0 0 $X=3579500 $Y=3675200
X375 197 317 195 524 64 247 OAI21X1 $T=3583800 3780000 1 0 $X=3579500 $Y=3724200
X376 271 598 64 600 119 195 AOI21X1 $T=2831400 4183200 1 0 $X=2827100 $Y=4127400
X377 540 552 64 553 318 195 AOI21X1 $T=3564000 3880800 1 0 $X=3559700 $Y=3825000
X378 618 511 195 64 303 XOR2X1 $T=3227400 4183200 0 0 $X=3223100 $Y=4179200
X379 530 521 195 64 529 XOR2X1 $T=3352800 4082400 1 0 $X=3348500 $Y=4026600
X380 615 133 64 134 195 617 238 AOI211XL $T=3201000 3679200 1 0 $X=3196700 $Y=3623400
X381 302 133 64 134 195 508 193 AOI211XL $T=3240600 3679200 1 0 $X=3236300 $Y=3623400
X382 191 133 64 134 195 620 518 AOI211XL $T=3240600 3679200 0 0 $X=3236300 $Y=3675200
X383 507 133 64 134 195 621 519 AOI211XL $T=3247200 3780000 1 0 $X=3242900 $Y=3724200
X384 509 133 64 134 195 304 528 AOI211XL $T=3286800 3780000 0 0 $X=3282500 $Y=3776000
X385 481 133 64 134 195 516 524 AOI211XL $T=3286800 3880800 1 0 $X=3282500 $Y=3825000
X386 647 133 64 134 195 525 136 AOI211XL $T=3300000 3880800 0 0 $X=3295700 $Y=3876800
X387 646 133 64 134 195 526 315 AOI211XL $T=3300000 3981600 1 0 $X=3295700 $Y=3925800
X388 409 403 195 64 277 XNOR2X1 $T=2620200 4082400 0 0 $X=2615900 $Y=4078400
X389 597 437 195 64 233 XNOR2X1 $T=2785200 3780000 1 0 $X=2780900 $Y=3724200
X390 442 109 195 64 234 XNOR2X1 $T=2805000 3679200 0 0 $X=2800700 $Y=3675200
X391 456 452 195 64 603 XNOR2X1 $T=2871000 3981600 0 0 $X=2866700 $Y=3977600
X392 472 607 195 64 477 XNOR2X1 $T=3042600 3981600 0 180 $X=2985500 $Y=3925800
X393 476 488 195 64 515 XNOR2X1 $T=3042600 3880800 0 0 $X=3038300 $Y=3876800
X394 482 610 195 64 310 XNOR2X1 $T=3049200 3780000 1 0 $X=3044900 $Y=3724200
X395 611 492 195 64 294 XNOR2X1 $T=3062400 4284000 1 0 $X=3058100 $Y=4228200
X396 510 517 195 64 305 XNOR2X1 $T=3286800 4183200 1 0 $X=3282500 $Y=4127400
X397 341 20 195 64 342 OR2XL $T=1102200 3880800 1 0 $X=1097900 $Y=3825000
X398 358 38 195 64 362 OR2XL $T=1386000 3679200 1 0 $X=1381700 $Y=3623400
X399 643 223 195 64 391 OR2XL $T=1953600 3679200 1 0 $X=1949300 $Y=3623400
X400 303 93 195 64 522 OR2XL $T=3286800 3679200 0 0 $X=3282500 $Y=3675200
X401 411 1009 410 195 64 117 XNOR2XL $T=2646600 4082400 1 0 $X=2642300 $Y=4026600
X402 424 1010 593 195 64 279 XNOR2XL $T=2686200 4082400 0 0 $X=2681900 $Y=4078400
X403 445 1011 446 195 64 281 XNOR2XL $T=2824800 4082400 1 0 $X=2820500 $Y=4026600
X404 499 1012 471 195 64 299 XNOR2XL $T=3121800 4183200 0 0 $X=3117500 $Y=4179200
X405 410 401 404 195 403 64 OAI2BB1XL $T=2600400 4082400 1 180 $X=2563100 $Y=4078400
X406 109 432 274 195 437 64 OAI2BB1XL $T=2745600 3780000 1 0 $X=2741300 $Y=3724200
X407 446 440 436 195 452 64 OAI2BB1XL $T=2805000 3981600 0 0 $X=2800700 $Y=3977600
X408 488 466 461 195 607 64 OAI2BB1XL $T=3036000 3880800 1 180 $X=2998700 $Y=3876800
X409 471 489 480 195 492 64 OAI2BB1XL $T=3022800 4183200 0 0 $X=3018500 $Y=4179200
X410 441 271 276 195 446 64 OAI2BB1X1 $T=2785200 4082400 1 0 $X=2780900 $Y=4026600
X411 195 64 10 54 1013 1014 64 322 1015 10 65 1016 64 325 1017 ICV_1 $T=429000 3880800 1 0 $X=424700 $Y=3825000
X412 195 64 13 65 1018 1019 64 324 1020 13 7 1021 64 332 1022 ICV_1 $T=547800 3981600 1 0 $X=543500 $Y=3925800
X413 195 64 14 7 1023 1024 64 329 1025 14 1 1026 64 335 1027 ICV_1 $T=633600 4082400 0 0 $X=629300 $Y=4078400
X414 195 64 14 54 1028 1029 64 330 1030 14 34 1031 64 336 1032 ICV_1 $T=792000 3880800 1 0 $X=787700 $Y=3825000
X415 195 64 14 90 1033 1034 64 26 1035 14 73 1036 339 349 1037 ICV_1 $T=1009800 3780000 1 0 $X=1005500 $Y=3724200
X416 195 64 13 61 1038 1039 339 573 1040 13 169 1041 339 351 1042 ICV_1 $T=1115400 3981600 1 0 $X=1111100 $Y=3925800
X417 195 64 10 73 1043 1044 339 355 1045 10 7 7 339 361 1046 ICV_1 $T=1227600 4082400 0 0 $X=1223300 $Y=4078400
X418 195 64 37 54 1047 1048 64 177 1049 52 61 1050 64 346 1051 ICV_1 $T=1438800 3780000 1 0 $X=1434500 $Y=3724200
X419 195 64 37 61 1052 1053 64 258 1054 72 43 1055 64 369 1056 ICV_1 $T=1504800 3880800 0 0 $X=1500500 $Y=3876800
X420 195 64 52 65 1057 1058 64 368 1059 78 74 1060 64 578 1061 ICV_1 $T=1570800 3679200 0 0 $X=1566500 $Y=3675200
X421 195 64 72 7 1062 1063 64 87 1064 78 66 1065 64 260 1066 ICV_1 $T=1650000 4183200 1 0 $X=1645700 $Y=4127400
X422 195 64 96 23 1067 1068 64 385 1069 226 35 1070 64 93 1071 ICV_1 $T=2151600 4082400 1 0 $X=2147300 $Y=4026600
X423 195 64 96 90 1072 1073 64 389 1074 226 74 1075 64 396 1076 ICV_1 $T=2158200 3981600 1 0 $X=2153900 $Y=3925800
X424 195 64 226 23 1077 1078 64 398 1079 98 90 1080 64 228 1081 ICV_1 $T=2303400 3880800 1 0 $X=2299100 $Y=3825000
X425 195 64 98 54 1082 1083 64 227 1084 98 21 1085 64 229 1086 ICV_1 $T=2382600 3679200 1 0 $X=2378300 $Y=3623400
X426 30 325 64 326 16 16 324 323 195 AOI222XL $T=726000 3780000 1 180 $X=668900 $Y=3776000
X427 22 322 64 328 16 16 330 331 195 AOI222XL $T=719400 3679200 0 0 $X=715100 $Y=3675200
X428 16 212 64 570 172 16 343 213 195 AOI222XL $T=1115400 3679200 1 0 $X=1111100 $Y=3623400
X429 16 174 64 340 16 16 573 345 195 AOI222XL $T=1174800 3679200 1 0 $X=1170500 $Y=3623400
X430 36 175 64 575 16 16 335 572 195 AOI222XL $T=1280400 3880800 0 180 $X=1223300 $Y=3825000
X431 36 214 64 349 16 172 257 353 195 AOI222XL $T=1313400 3679200 0 180 $X=1256300 $Y=3623400
X432 36 176 64 332 16 16 329 357 195 AOI222XL $T=1339800 3880800 1 180 $X=1282700 $Y=3876800
X433 182 586 64 92 93 93 375 375 195 AOI222XL $T=2079000 3981600 1 0 $X=2074700 $Y=3925800
X434 182 588 64 291 93 93 93 378 195 AOI222XL $T=2092200 3679200 1 0 $X=2087900 $Y=3623400
X435 182 589 64 397 93 93 185 392 195 AOI222XL $T=2092200 3780000 1 0 $X=2087900 $Y=3724200
X436 182 394 64 262 93 93 93 390 195 AOI222XL $T=2092200 4082400 1 0 $X=2087900 $Y=4026600
X437 182 587 64 263 93 93 398 388 195 AOI222XL $T=2092200 4082400 0 0 $X=2087900 $Y=4078400
X438 182 183 64 93 405 93 184 395 195 AOI222XL $T=2151600 3679200 1 0 $X=2147300 $Y=3623400
X439 182 393 64 93 93 93 93 396 195 AOI222X1 $T=2158200 3880800 1 180 $X=2101100 $Y=3876800
X440 331 195 64 173 BUFXL $T=930600 3780000 1 0 $X=926300 $Y=3724200
X441 395 195 64 224 BUFXL $T=2072400 3679200 0 180 $X=2041700 $Y=3623400
X442 344 195 345 64 18 268 NAND3XL $T=1174800 3880800 0 180 $X=1144100 $Y=3825000
X443 375 195 580 64 581 50 NAND3XL $T=1867800 3981600 1 0 $X=1863500 $Y=3925800
X444 585 195 390 64 387 60 NAND3XL $T=1980000 3981600 0 180 $X=1949300 $Y=3925800
X445 392 195 381 64 584 371 NAND3XL $T=1986600 3780000 1 180 $X=1955900 $Y=3776000
X446 206 195 323 12 5 333 64 NAND4X1 $T=620400 3679200 1 0 $X=616100 $Y=3623400
X447 582 195 382 388 11 171 64 NAND4X1 $T=1920600 4082400 0 0 $X=1916300 $Y=4078400
X448 327 64 30 16 334 256 195 AOI22XL $T=811800 3679200 0 0 $X=807500 $Y=3675200
X449 338 64 22 16 336 17 195 AOI22XL $T=976800 3679200 1 180 $X=939500 $Y=3675200
X450 350 64 36 16 351 352 195 AOI22XL $T=1267200 3780000 0 0 $X=1262900 $Y=3776000
X451 81 64 83 36 368 220 195 AOI22XL $T=1828200 3679200 0 180 $X=1790900 $Y=3623400
X452 379 64 88 86 372 373 195 AOI22XL $T=1907400 3780000 1 180 $X=1870100 $Y=3776000
X453 384 64 88 86 369 581 195 AOI22XL $T=1933800 3880800 1 180 $X=1896500 $Y=3876800
X454 370 64 86 83 583 387 195 AOI22XL $T=1907400 3981600 1 0 $X=1903100 $Y=3925800
X455 385 64 88 86 374 582 195 AOI22XL $T=1940400 4082400 0 180 $X=1903100 $Y=4026600
X456 386 64 88 86 259 376 195 AOI22XL $T=1947000 3780000 1 180 $X=1909700 $Y=3776000
X457 181 64 88 86 383 584 195 AOI22XL $T=1953600 3880800 0 180 $X=1916300 $Y=3825000
X458 179 195 642 221 643 222 64 NAND4XL $T=1914000 3679200 1 0 $X=1909700 $Y=3623400
X459 378 261 376 195 64 1087 180 AND3XL $T=1900800 3780000 0 180 $X=1863500 $Y=3724200
X460 93 579 373 2 195 64 AND3X4 $T=1854600 3780000 1 180 $X=1810700 $Y=3776000
X461 371 67 195 64 CLKBUFX3 $T=1782000 3780000 1 180 $X=1751300 $Y=3776000
X462 44 64 64 195 CLKINVX4 $T=1313400 3679200 1 180 $X=1282700 $Y=3675200
X463 44 64 64 195 CLKINVX4 $T=1650000 3679200 0 180 $X=1619300 $Y=3623400
X464 337 64 195 165 CLKBUFX2 $T=976800 3880800 1 180 $X=946100 $Y=3876800
X465 347 64 195 166 CLKBUFX2 $T=1227600 3981600 1 180 $X=1196900 $Y=3977600
X466 348 64 195 163 CLKBUFX2 $T=1247400 3780000 1 180 $X=1216700 $Y=3776000
X467 360 64 195 168 CLKBUFX2 $T=1412400 4183200 1 180 $X=1381700 $Y=4179200
X468 363 64 195 164 CLKBUFX2 $T=1438800 3880800 0 180 $X=1408100 $Y=3825000
X469 365 64 195 170 CLKBUFX2 $T=1445400 3981600 1 180 $X=1414700 $Y=3977600
X470 364 64 195 48 CLKBUFX2 $T=1452000 3679200 0 180 $X=1421300 $Y=3623400
X471 366 64 195 167 CLKBUFX2 $T=1452000 4183200 1 180 $X=1421300 $Y=4179200
X472 258 64 195 162 CLKBUFX2 $T=1597200 3780000 0 0 $X=1592900 $Y=3776000
X473 71 64 53 1088 195 37 AND2X2 $T=1498200 3679200 0 0 $X=1493900 $Y=3675200
X474 359 195 64 203 BUFX1 $T=1372800 4284000 0 180 $X=1342100 $Y=4228200
X475 574 572 33 341 9 64 195 NAND4BXL $T=1221000 3880800 1 180 $X=1177100 $Y=3876800
X476 577 357 63 358 3 64 195 NAND4BXL $T=1386000 3880800 0 180 $X=1342100 $Y=3825000
X477 4 41 256 352 195 64 640 AND4XL $T=1306800 3780000 0 0 $X=1302500 $Y=3776000
X478 353 215 576 42 195 64 356 AND4XL $T=1339800 3679200 1 0 $X=1335500 $Y=3623400
X479 44 64 339 195 CLKINVX3 $T=1300200 3780000 0 180 $X=1276100 $Y=3724200
X480 571 30 64 36 346 344 195 AOI22X1 $T=1188000 3780000 0 0 $X=1183700 $Y=3776000
X481 172 16 195 64 CLKBUFX4 $T=924000 3679200 1 180 $X=886700 $Y=3675200
.ENDS
***************************************
.SUBCKT ADDFHXL A B CI CO VDD VSS S
** N=17 EP=7 IP=0 FDC=32
M0 VSS A 9 VSS n18 L=1.8e-07 W=3e-07 $X=6600 $Y=5700 $D=6
M1 VSS A 8 VSS n18 L=1.8e-07 W=3e-07 $X=10650 $Y=12700 $D=6
M2 10 8 VSS VSS n18 L=1.8e-07 W=3e-07 $X=16650 $Y=10400 $D=6
M3 11 B 10 VSS n18 L=1.8e-07 W=5.6e-07 $X=24250 $Y=9100 $D=6
M4 9 12 11 VSS n18 L=1.8e-07 W=5.6e-07 $X=31450 $Y=9100 $D=6
M5 13 B 9 VSS n18 L=1.8e-07 W=5.6e-07 $X=38650 $Y=9100 $D=6
M6 10 12 13 VSS n18 L=1.8e-07 W=5.6e-07 $X=45850 $Y=9100 $D=6
M7 12 B VSS VSS n18 L=1.8e-07 W=3e-07 $X=68950 $Y=10850 $D=6
M8 15 11 12 VSS n18 L=1.8e-07 W=5.6e-07 $X=76550 $Y=10850 $D=6
M9 16 13 15 VSS n18 L=1.8e-07 W=5.6e-07 $X=86550 $Y=13150 $D=6
M10 17 11 16 VSS n18 L=1.8e-07 W=5.6e-07 $X=93750 $Y=13150 $D=6
M11 14 13 17 VSS n18 L=1.8e-07 W=5.6e-07 $X=100950 $Y=13150 $D=6
M12 VSS 16 14 VSS n18 L=1.8e-07 W=3e-07 $X=109000 $Y=13150 $D=6
M13 16 CI VSS VSS n18 L=1.8e-07 W=3e-07 $X=115000 $Y=13150 $D=6
M14 VSS 15 CO VSS n18 L=1.8e-07 W=4.2e-07 $X=129650 $Y=12450 $D=6
M15 S 17 VSS VSS n18 L=1.8e-07 W=4.2e-07 $X=137200 $Y=12450 $D=6
M16 VDD A 9 VDD p18 L=1.8e-07 W=4.2e-07 $X=6200 $Y=37200 $D=10
M17 VDD A 8 VDD p18 L=1.8e-07 W=4.2e-07 $X=10250 $Y=29200 $D=10
M18 10 8 VDD VDD p18 L=1.8e-07 W=4.2e-07 $X=16250 $Y=30850 $D=10
M19 11 12 10 VDD p18 L=1.8e-07 W=8.4e-07 $X=23450 $Y=30850 $D=10
M20 9 B 11 VDD p18 L=1.8e-07 W=8.4e-07 $X=30650 $Y=30850 $D=10
M21 13 12 9 VDD p18 L=1.8e-07 W=8.4e-07 $X=37850 $Y=30850 $D=10
M22 10 B 13 VDD p18 L=1.8e-07 W=8.4e-07 $X=45050 $Y=30850 $D=10
M23 12 B VDD VDD p18 L=1.8e-07 W=4.2e-07 $X=61000 $Y=32950 $D=10
M24 15 13 12 VDD p18 L=1.8e-07 W=8.4e-07 $X=75000 $Y=32950 $D=10
M25 16 11 15 VDD p18 L=1.8e-07 W=8.4e-07 $X=82200 $Y=32950 $D=10
M26 17 13 16 VDD p18 L=1.8e-07 W=8.4e-07 $X=90400 $Y=32950 $D=10
M27 14 11 17 VDD p18 L=1.8e-07 W=8.4e-07 $X=97600 $Y=32950 $D=10
M28 VDD 16 14 VDD p18 L=1.8e-07 W=4.2e-07 $X=104800 $Y=32950 $D=10
M29 16 CI VDD VDD p18 L=1.8e-07 W=4.2e-07 $X=112950 $Y=33550 $D=10
M30 VDD 15 CO VDD p18 L=1.8e-07 W=6.4e-07 $X=128800 $Y=29300 $D=10
M31 S 17 VDD VDD p18 L=1.8e-07 W=6.4e-07 $X=137200 $Y=29300 $D=10
.ENDS
***************************************
.SUBCKT DFFSX1 CK D 3 SN 5 QN VSS Q VDD
** N=24 EP=9 IP=0 FDC=34
M0 VSS CK 12 VSS n18 L=1.8e-07 W=4e-07 $X=6700 $Y=11600 $D=6
M1 15 D VSS VSS n18 L=1.8e-07 W=3e-07 $X=16850 $Y=8400 $D=6
M2 3 12 15 VSS n18 L=1.8e-07 W=3e-07 $X=22450 $Y=8400 $D=6
M3 16 11 3 VSS n18 L=1.8e-07 W=3e-07 $X=29200 $Y=15000 $D=6
M4 VSS 10 16 VSS n18 L=1.8e-07 W=3e-07 $X=34800 $Y=15000 $D=6
M5 17 SN VSS VSS n18 L=1.8e-07 W=3e-07 $X=40800 $Y=15000 $D=6
M6 10 3 17 VSS n18 L=1.8e-07 W=3e-07 $X=46400 $Y=15000 $D=6
M7 VSS 12 11 VSS n18 L=1.8e-07 W=3e-07 $X=55600 $Y=7000 $D=6
M8 18 10 VSS VSS n18 L=1.8e-07 W=4e-07 $X=61600 $Y=14100 $D=6
M9 13 11 18 VSS n18 L=1.8e-07 W=4e-07 $X=67200 $Y=14100 $D=6
M10 19 12 13 VSS n18 L=1.8e-07 W=3e-07 $X=73200 $Y=7350 $D=6
M11 VSS 14 19 VSS n18 L=1.8e-07 W=3e-07 $X=79000 $Y=7350 $D=6
M12 20 13 14 VSS n18 L=1.8e-07 W=5.8e-07 $X=90000 $Y=12500 $D=6
M13 VSS SN 20 VSS n18 L=1.8e-07 W=5.8e-07 $X=95600 $Y=12500 $D=6
M14 QN 14 VSS VSS n18 L=1.8e-07 W=5.6e-07 $X=103250 $Y=5800 $D=6
M15 5 14 VSS VSS n18 L=1.8e-07 W=3e-07 $X=103250 $Y=14900 $D=6
M16 Q 5 VSS VSS n18 L=1.8e-07 W=6e-07 $X=116250 $Y=11200 $D=6
M17 VDD CK 12 VDD p18 L=1.8e-07 W=6e-07 $X=6400 $Y=33200 $D=10
M18 21 D VDD VDD p18 L=1.8e-07 W=4.2e-07 $X=14200 $Y=28450 $D=10
M19 3 11 21 VDD p18 L=1.8e-07 W=4.2e-07 $X=19800 $Y=28450 $D=10
M20 22 12 3 VDD p18 L=1.8e-07 W=4.2e-07 $X=27400 $Y=31400 $D=10
M21 VDD 10 22 VDD p18 L=1.8e-07 W=4.2e-07 $X=33000 $Y=31400 $D=10
M22 10 SN VDD VDD p18 L=1.8e-07 W=3.2e-07 $X=39000 $Y=31400 $D=10
M23 VDD 3 10 VDD p18 L=1.8e-07 W=3.2e-07 $X=47000 $Y=31400 $D=10
M24 11 12 VDD VDD p18 L=1.8e-07 W=4.2e-07 $X=53000 $Y=30400 $D=10
M25 23 10 VDD VDD p18 L=1.8e-07 W=6e-07 $X=65600 $Y=32700 $D=10
M26 13 12 23 VDD p18 L=1.8e-07 W=6e-07 $X=71200 $Y=32700 $D=10
M27 24 11 13 VDD p18 L=1.8e-07 W=3e-07 $X=78800 $Y=33700 $D=10
M28 VDD 14 24 VDD p18 L=1.8e-07 W=3e-07 $X=84400 $Y=33700 $D=10
M29 14 13 VDD VDD p18 L=1.8e-07 W=6.6e-07 $X=90400 $Y=29200 $D=10
M30 VDD SN 14 VDD p18 L=1.8e-07 W=6.6e-07 $X=97600 $Y=29000 $D=10
M31 5 14 VDD VDD p18 L=1.8e-07 W=4.2e-07 $X=104800 $Y=29000 $D=10
M32 QN 14 VDD VDD p18 L=1.8e-07 W=8.6e-07 $X=104800 $Y=36000 $D=10
M33 Q 5 VDD VDD p18 L=1.8e-07 W=9e-07 $X=117400 $Y=28100 $D=10
.ENDS
***************************************
.SUBCKT CLKINVX8 A VSS Y VDD
** N=4 EP=4 IP=0 FDC=7
M0 Y A VSS VSS n18 L=1.85682e-07 W=9.59706e-07 $X=5800 $Y=11200 $D=6
M1 VSS A Y VSS n18 L=1.85682e-07 W=9.59706e-07 $X=13450 $Y=6500 $D=6
M2 Y A VSS VSS n18 L=1.85682e-07 W=9.59706e-07 $X=20250 $Y=11200 $D=6
M3 Y A VDD VDD p18 L=1.84048e-07 W=1.79627e-06 $X=5000 $Y=27200 $D=10
M4 VDD A Y VDD p18 L=1.84048e-07 W=1.79627e-06 $X=12200 $Y=36300 $D=10
M5 Y A VDD VDD p18 L=1.84048e-07 W=1.79627e-06 $X=19400 $Y=27200 $D=10
M6 VDD A Y VDD p18 L=1.84048e-07 W=1.79627e-06 $X=26600 $Y=36300 $D=10
.ENDS
***************************************
.SUBCKT OAI211XL A1 A0 VSS C0 VDD B0 Y
** N=10 EP=7 IP=0 FDC=8
M0 VSS A1 8 VSS n18 L=1.8e-07 W=6.6e-07 $X=6200 $Y=7600 $D=6
M1 8 A0 VSS VSS n18 L=1.8e-07 W=6.6e-07 $X=14200 $Y=7600 $D=6
M2 9 C0 8 VSS n18 L=1.8e-07 W=6.6e-07 $X=21400 $Y=7600 $D=6
M3 Y B0 9 VSS n18 L=1.8e-07 W=6.6e-07 $X=27400 $Y=10400 $D=6
M4 10 A1 VDD VDD p18 L=1.8e-07 W=8.4e-07 $X=6200 $Y=31000 $D=10
M5 Y A0 10 VDD p18 L=1.8e-07 W=8.4e-07 $X=12600 $Y=31000 $D=10
M6 VDD C0 Y VDD p18 L=1.8e-07 W=6.4e-07 $X=19800 $Y=33000 $D=10
M7 Y B0 VDD VDD p18 L=1.8e-07 W=6.4e-07 $X=27800 $Y=33000 $D=10
.ENDS
***************************************
.SUBCKT INVX4 A Y VSS VDD
** N=4 EP=4 IP=0 FDC=4
M0 Y A VSS VSS n18 L=1.8e-07 W=1.2e-06 $X=6650 $Y=6200 $D=6
M1 VSS A Y VSS n18 L=1.8e-07 W=1.2e-06 $X=13850 $Y=6200 $D=6
M2 Y A VDD VDD p18 L=1.8e-07 W=1.74e-06 $X=6650 $Y=27300 $D=10
M3 VDD A Y VDD p18 L=1.8e-07 W=1.74e-06 $X=13850 $Y=27300 $D=10
.ENDS
***************************************
.SUBCKT NAND2X1 B VSS A VDD Y
** N=6 EP=5 IP=0 FDC=4
M0 6 B VSS VSS n18 L=1.8e-07 W=7.8e-07 $X=6200 $Y=8950 $D=6
M1 Y A 6 VSS n18 L=1.8e-07 W=7.8e-07 $X=11800 $Y=8950 $D=6
M2 Y B VDD VDD p18 L=1.8e-07 W=9e-07 $X=5350 $Y=27150 $D=10
M3 VDD A Y VDD p18 L=1.8e-07 W=9e-07 $X=12600 $Y=27150 $D=10
.ENDS
***************************************
.SUBCKT NAND3X1 C VSS B VDD A Y
** N=8 EP=6 IP=0 FDC=6
M0 7 C VSS VSS n18 L=1.8e-07 W=9.6e-07 $X=7200 $Y=5700 $D=6
M1 8 B 7 VSS n18 L=1.8e-07 W=9.6e-07 $X=12800 $Y=5700 $D=6
M2 Y A 8 VSS n18 L=1.8e-07 W=9.6e-07 $X=18400 $Y=5700 $D=6
M3 Y C VDD VDD p18 L=1.84493e-07 W=1.01142e-06 $X=4600 $Y=30300 $D=10
M4 VDD B Y VDD p18 L=1.84493e-07 W=1.01142e-06 $X=11250 $Y=35300 $D=10
M5 Y A VDD VDD p18 L=1.84493e-07 W=1.01142e-06 $X=18400 $Y=30300 $D=10
.ENDS
***************************************
.SUBCKT NOR3XL C VDD B VSS A Y
** N=8 EP=6 IP=0 FDC=6
M0 Y C VSS VSS n18 L=1.8e-07 W=4.2e-07 $X=4600 $Y=11450 $D=6
M1 VSS B Y VSS n18 L=1.8e-07 W=4.2e-07 $X=11800 $Y=11450 $D=6
M2 Y A VSS VSS n18 L=1.8e-07 W=4.2e-07 $X=18400 $Y=11450 $D=6
M3 7 C VDD VDD p18 L=1.8e-07 W=9.8e-07 $X=6200 $Y=29050 $D=10
M4 8 B 7 VDD p18 L=1.8e-07 W=9.8e-07 $X=12350 $Y=29050 $D=10
M5 Y A 8 VDD p18 L=1.8e-07 W=9.8e-07 $X=18200 $Y=29050 $D=10
.ENDS
***************************************
.SUBCKT OR3X1 A B C VDD VSS Y
** N=9 EP=6 IP=0 FDC=8
M0 VSS A 7 VSS n18 L=1.8e-07 W=3e-07 $X=7000 $Y=12300 $D=6
M1 7 B VSS VSS n18 L=1.8e-07 W=3e-07 $X=13200 $Y=12300 $D=6
M2 VSS C 7 VSS n18 L=1.8e-07 W=3e-07 $X=21700 $Y=12300 $D=6
M3 Y 7 VSS VSS n18 L=1.8e-07 W=6e-07 $X=29400 $Y=9300 $D=6
M4 8 A 7 VDD p18 L=1.8e-07 W=6.6e-07 $X=8200 $Y=31700 $D=10
M5 9 B 8 VDD p18 L=1.8e-07 W=6.6e-07 $X=13800 $Y=31700 $D=10
M6 VDD C 9 VDD p18 L=1.8e-07 W=6.6e-07 $X=19400 $Y=31700 $D=10
M7 Y 7 VDD VDD p18 L=1.8e-07 W=9e-07 $X=28900 $Y=28300 $D=10
.ENDS
***************************************
.SUBCKT INVX1 A VSS VDD Y
** N=4 EP=4 IP=0 FDC=2
M0 Y A VSS VSS n18 L=1.8e-07 W=6e-07 $X=4600 $Y=12200 $D=6
M1 Y A VDD VDD p18 L=1.8e-07 W=9e-07 $X=4600 $Y=27000 $D=10
.ENDS
***************************************
.SUBCKT AND2XL A B VDD VSS Y
** N=7 EP=5 IP=0 FDC=6
M0 7 A 6 VSS n18 L=1.8e-07 W=3.2e-07 $X=5700 $Y=15050 $D=6
M1 VSS B 7 VSS n18 L=1.8e-07 W=3.2e-07 $X=11300 $Y=15050 $D=6
M2 Y 6 VSS VSS n18 L=1.8e-07 W=4.2e-07 $X=17300 $Y=14050 $D=6
M3 VDD A 6 VDD p18 L=1.8e-07 W=4.2e-07 $X=4200 $Y=39900 $D=10
M4 VDD B 6 VDD p18 L=1.8e-07 W=4.2e-07 $X=9400 $Y=30600 $D=10
M5 Y 6 VDD VDD p18 L=1.8e-07 W=6.4e-07 $X=16500 $Y=30600 $D=10
.ENDS
***************************************
.SUBCKT OR4X1 A B C 4 D VDD VSS Y
** N=11 EP=8 IP=0 FDC=10
M0 4 A VSS VSS n18 L=1.8e-07 W=3e-07 $X=4200 $Y=8900 $D=6
M1 VSS B 4 VSS n18 L=1.8e-07 W=3e-07 $X=11400 $Y=15400 $D=6
M2 4 C VSS VSS n18 L=1.8e-07 W=3e-07 $X=17400 $Y=11400 $D=6
M3 VSS D 4 VSS n18 L=1.8e-07 W=3e-07 $X=25400 $Y=11400 $D=6
M4 Y 4 VSS VSS n18 L=1.8e-07 W=6e-07 $X=31400 $Y=8400 $D=6
M5 9 A 4 VDD p18 L=1.8e-07 W=7.6e-07 $X=6800 $Y=32450 $D=10
M6 10 B 9 VDD p18 L=1.8e-07 W=7.6e-07 $X=12400 $Y=32450 $D=10
M7 11 C 10 VDD p18 L=1.8e-07 W=7.6e-07 $X=18000 $Y=32450 $D=10
M8 VDD D 11 VDD p18 L=1.8e-07 W=7.6e-07 $X=23600 $Y=32450 $D=10
M9 Y 4 VDD VDD p18 L=1.8e-07 W=9e-07 $X=29600 $Y=32450 $D=10
.ENDS
***************************************
.SUBCKT NOR4BXL AN VDD D C B Y VSS
** N=11 EP=7 IP=0 FDC=10
M0 VSS AN 8 VSS n18 L=1.8e-07 W=3e-07 $X=6600 $Y=10600 $D=6
M1 Y D VSS VSS n18 L=1.8e-07 W=4.2e-07 $X=12600 $Y=10550 $D=6
M2 VSS C Y VSS n18 L=1.8e-07 W=4.2e-07 $X=19800 $Y=10550 $D=6
M3 Y B VSS VSS n18 L=1.8e-07 W=4.2e-07 $X=25800 $Y=10550 $D=6
M4 VSS 8 Y VSS n18 L=1.8e-07 W=4.2e-07 $X=33000 $Y=10550 $D=6
M5 VDD AN 8 VDD p18 L=1.8e-07 W=4.2e-07 $X=6200 $Y=29850 $D=10
M6 9 D VDD VDD p18 L=1.8e-07 W=1.16e-06 $X=13200 $Y=29850 $D=10
M7 10 C 9 VDD p18 L=1.8e-07 W=1.16e-06 $X=18800 $Y=29850 $D=10
M8 11 B 10 VDD p18 L=1.8e-07 W=1.16e-06 $X=24600 $Y=29850 $D=10
M9 Y 8 11 VDD p18 L=1.8e-07 W=1.16e-06 $X=30200 $Y=29850 $D=10
.ENDS
***************************************
.SUBCKT NOR2BXL AN VDD B Y VSS
** N=7 EP=5 IP=0 FDC=6
M0 VSS AN 6 VSS n18 L=1.8e-07 W=3e-07 $X=6600 $Y=13200 $D=6
M1 Y B VSS VSS n18 L=1.8e-07 W=4.2e-07 $X=12700 $Y=10900 $D=6
M2 VSS 6 Y VSS n18 L=1.8e-07 W=4.2e-07 $X=19900 $Y=10900 $D=6
M3 VDD AN 6 VDD p18 L=1.8e-07 W=4.2e-07 $X=6200 $Y=29300 $D=10
M4 7 B VDD VDD p18 L=1.8e-07 W=8.4e-07 $X=12800 $Y=29300 $D=10
M5 Y 6 7 VDD p18 L=1.8e-07 W=8.4e-07 $X=18400 $Y=29300 $D=10
.ENDS
***************************************
.SUBCKT NAND3BXL AN VSS C B VDD Y
** N=9 EP=6 IP=0 FDC=8
M0 VSS AN 7 VSS n18 L=1.8e-07 W=3e-07 $X=6600 $Y=10550 $D=6
M1 8 C VSS VSS n18 L=1.8e-07 W=6.6e-07 $X=13200 $Y=5700 $D=6
M2 9 B 8 VSS n18 L=1.8e-07 W=6.6e-07 $X=18800 $Y=5700 $D=6
M3 Y 7 9 VSS n18 L=1.8e-07 W=6.6e-07 $X=24400 $Y=5700 $D=6
M4 VDD AN 7 VDD p18 L=1.8e-07 W=4.2e-07 $X=6200 $Y=31700 $D=10
M5 Y C VDD VDD p18 L=1.8e-07 W=6.4e-07 $X=12200 $Y=30600 $D=10
M6 VDD B Y VDD p18 L=1.8e-07 W=6.4e-07 $X=19400 $Y=30600 $D=10
M7 Y 7 VDD VDD p18 L=1.8e-07 W=6.4e-07 $X=25400 $Y=30600 $D=10
.ENDS
***************************************
.SUBCKT ICV_3 1 2 3 4 5 6 7 8 9 10 11 12 13 14 15 16 18 19 20 22
+ 23 24 25 26 28 29 32 33 34 35 36 37 38 40 41 42 43 44 45 47
+ 48 49 50 51 53 54 55 56 58 59 60 61 63 64 65 66 67 68 69 70
+ 71 72 73 74 75 76 77 78 79 80 82 83 84 85 86 91 92 93 94 95
+ 96 97 99 102 104 105 107 108 113 114 115 116 117 118 119 120 123 124 125 127
+ 128 129 131 132 133 134 135 136 137 138 140 141 142 143 145 146 147 148 149 150
+ 151 152 153 154 155 156 157 158 160 161 162 165 166 168 169 170 171 172 173 175
+ 176 177 179 181 182 183 184 188 191 192 193 195 196 197 200 201 203 204 205 206
+ 208 210 211 223 224 225 227 228 233 236 238 239 240 241 242 243 244 246 247 248
+ 249 250 251 252 253 254 255 256 257 258 259 260 261 262 263 264 265 266 267 269
+ 270 271 272 273 274 275 276 277 278 279 280 281 282 283 284 285 286 287 288 289
+ 290 291 292 293 294 295 296 297 298 299 300 301 302 303 304 305 306 307 308 309
+ 310 311 312 313 314 315 316 317 319 320 321 322 323 324 325 326 327 328 329 330
+ 331 332 333 334 335 336 337 338 339 340 341 342 343 344 345 346 347 348 349 350
+ 351 352 353 354 355 356 357 358 359 360 361 362 363 364 365 366 367 368 369 370
+ 371 372 373 374 375 376 377 378 379 380 381 382 383 384 385 386 387 388 389 390
+ 391 392 393 394 395 397 398 399 400 401
*.CALIBRE ICV_CELL 2
** N=1425 EP=330 IP=3631 FDC=7829
M0 1420 44 53 335 n18 L=1.8e-07 W=8e-07 $X=448500 $Y=3281700 $D=6
M1 335 464 1420 335 n18 L=1.8e-07 W=8e-07 $X=454100 $Y=3281700 $D=6
M2 1421 464 335 335 n18 L=1.8e-07 W=8e-07 $X=462100 $Y=3284950 $D=6
M3 53 44 1421 335 n18 L=1.8e-07 W=8e-07 $X=467700 $Y=3284950 $D=6
M4 335 739 53 335 n18 L=1.8e-07 W=1.2e-06 $X=480450 $Y=3281700 $D=6
M5 53 20 335 335 n18 L=1.8e-07 W=1.2e-06 $X=488500 $Y=3281700 $D=6
M6 335 823 5 335 n18 L=1.8e-07 W=1.2e-06 $X=1941600 $Y=3258000 $D=6
M7 1422 762 335 335 n18 L=1.8e-07 W=7.6e-07 $X=1947600 $Y=3258000 $D=6
M8 1423 551 1422 335 n18 L=1.8e-07 W=7.6e-07 $X=1953200 $Y=3258000 $D=6
M9 823 419 1423 335 n18 L=1.8e-07 W=7.6e-07 $X=1958800 $Y=3258000 $D=6
M10 14 464 817 14 p18 L=1.826e-07 W=1.39814e-06 $X=447650 $Y=3309200 $D=10
M11 817 464 14 14 p18 L=1.826e-07 W=1.39814e-06 $X=454050 $Y=3303800 $D=10
M12 14 44 817 14 p18 L=1.826e-07 W=1.39814e-06 $X=460450 $Y=3309200 $D=10
M13 817 44 14 14 p18 L=1.826e-07 W=1.39814e-06 $X=466900 $Y=3303800 $D=10
M14 1424 20 817 14 p18 L=1.8e-07 W=1.4e-06 $X=474100 $Y=3303450 $D=10
M15 53 739 1424 14 p18 L=1.8e-07 W=1.4e-06 $X=479700 $Y=3303450 $D=10
M16 1425 739 53 14 p18 L=1.8e-07 W=1.4e-06 $X=486900 $Y=3303450 $D=10
M17 817 20 1425 14 p18 L=1.8e-07 W=1.4e-06 $X=492500 $Y=3303450 $D=10
M18 14 823 5 14 p18 L=1.82016e-07 W=1.80314e-06 $X=1939400 $Y=3231300 $D=10
M19 823 762 14 14 p18 L=1.8e-07 W=7.2e-07 $X=1946200 $Y=3238650 $D=10
M20 14 551 823 14 p18 L=1.8e-07 W=7.2e-07 $X=1953400 $Y=3238650 $D=10
M21 823 419 14 14 p18 L=1.8e-07 W=7.2e-07 $X=1960000 $Y=3239200 $D=10
X22 735 335 14 44 467 NAND2XL $T=389400 3376800 1 0 $X=385100 $Y=3321000
X23 494 335 14 41 500 NAND2XL $T=877800 3276000 1 180 $X=853700 $Y=3272000
X24 73 335 14 56 408 NAND2XL $T=1161600 3578400 0 180 $X=1137500 $Y=3522600
X25 517 335 14 68 509 NAND2XL $T=1181400 3477600 0 180 $X=1157300 $Y=3421800
X26 526 335 14 51 755 NAND2XL $T=1273800 3175200 1 180 $X=1249700 $Y=3171200
X27 756 335 14 55 527 NAND2XL $T=1339800 3276000 1 180 $X=1315700 $Y=3272000
X28 531 335 14 55 411 NAND2XL $T=1372800 3276000 1 180 $X=1348700 $Y=3272000
X29 413 335 14 55 353 NAND2XL $T=1372800 3578400 1 0 $X=1368500 $Y=3522600
X30 529 335 14 55 75 NAND2XL $T=1405800 3376800 1 180 $X=1381700 $Y=3372800
X31 538 335 14 55 85 NAND2XL $T=1623600 3578400 0 180 $X=1599500 $Y=3522600
X32 537 335 14 55 108 NAND2XL $T=1623600 3578400 1 0 $X=1619300 $Y=3522600
X33 417 335 14 125 547 NAND2XL $T=1894200 3175200 0 0 $X=1889900 $Y=3171200
X34 761 335 14 125 760 NAND2XL $T=1947000 3276000 1 180 $X=1922900 $Y=3272000
X35 570 335 14 410 571 NAND2XL $T=2521200 3477600 0 0 $X=2516900 $Y=3473600
X36 579 335 14 572 577 NAND2XL $T=2560800 3578400 0 180 $X=2536700 $Y=3522600
X37 424 335 14 513 425 NAND2XL $T=2620200 3376800 0 0 $X=2615900 $Y=3372800
X38 425 335 14 771 581 NAND2XL $T=2659800 3376800 0 0 $X=2655500 $Y=3372800
X39 287 335 14 156 289 NAND2XL $T=2659800 3578400 0 0 $X=2655500 $Y=3574400
X40 278 335 14 579 582 NAND2XL $T=2673000 3578400 1 0 $X=2668700 $Y=3522600
X41 504 335 14 587 580 NAND2XL $T=2712600 3276000 1 0 $X=2708300 $Y=3220200
X42 148 335 14 570 589 NAND2XL $T=2719200 3477600 1 0 $X=2714900 $Y=3421800
X43 168 335 14 588 772 NAND2XL $T=2778600 3376800 0 180 $X=2754500 $Y=3321000
X44 567 335 14 424 595 NAND2XL $T=2778600 3175200 0 0 $X=2774300 $Y=3171200
X45 168 335 14 583 774 NAND2XL $T=2798400 3477600 0 180 $X=2774300 $Y=3421800
X46 168 335 14 575 596 NAND2XL $T=2798400 3376800 1 0 $X=2794100 $Y=3321000
X47 587 335 14 152 597 NAND2XL $T=2818200 3276000 1 0 $X=2813900 $Y=3220200
X48 168 335 14 171 599 NAND2XL $T=2818200 3477600 1 0 $X=2813900 $Y=3421800
X49 280 335 14 432 604 NAND2XL $T=2897400 3175200 1 0 $X=2893100 $Y=3119400
X50 428 335 14 177 602 NAND2XL $T=2923800 3276000 0 180 $X=2899700 $Y=3220200
X51 430 335 14 609 430 NAND2XL $T=2943600 3477600 1 0 $X=2939300 $Y=3421800
X52 778 335 14 613 612 NAND2XL $T=2950200 3578400 1 0 $X=2945900 $Y=3522600
X53 778 335 14 616 431 NAND2XL $T=2970000 3578400 1 0 $X=2965700 $Y=3522600
X54 168 335 14 605 780 NAND2XL $T=2976600 3074400 0 0 $X=2972300 $Y=3070400
X55 179 335 14 184 616 NAND2XL $T=2976600 3477600 0 0 $X=2972300 $Y=3473600
X56 429 335 14 291 617 NAND2XL $T=2976600 3578400 0 0 $X=2972300 $Y=3574400
X57 778 335 14 621 781 NAND2XL $T=2996400 3578400 1 0 $X=2992100 $Y=3522600
X58 286 335 14 611 626 NAND2XL $T=3003000 3276000 1 0 $X=2998700 $Y=3220200
X59 154 335 14 295 297 NAND2XL $T=3009600 3074400 0 0 $X=3005300 $Y=3070400
X60 617 335 14 613 783 NAND2XL $T=3022800 3578400 0 0 $X=3018500 $Y=3574400
X61 566 335 14 294 782 NAND2XL $T=3049200 3477600 1 0 $X=3044900 $Y=3421800
X62 626 335 14 625 627 NAND2XL $T=3055800 3276000 1 0 $X=3051500 $Y=3220200
X63 297 335 14 299 633 NAND2XL $T=3082200 3074400 0 0 $X=3077900 $Y=3070400
X64 782 335 14 623 631 NAND2XL $T=3082200 3477600 1 0 $X=3077900 $Y=3421800
X65 607 335 14 627 634 NAND2XL $T=3095400 3276000 1 0 $X=3091100 $Y=3220200
X66 426 335 14 615 635 NAND2XL $T=3128400 3376800 1 180 $X=3104300 $Y=3372800
X67 631 335 14 434 826 NAND2XL $T=3121800 3477600 1 0 $X=3117500 $Y=3421800
X68 285 335 14 301 639 NAND2XL $T=3128400 3578400 1 0 $X=3124100 $Y=3522600
X69 561 335 14 591 644 NAND2XL $T=3181200 3578400 1 0 $X=3176900 $Y=3522600
X70 550 335 14 792 443 NAND2XL $T=3253800 3175200 1 180 $X=3229700 $Y=3171200
X71 568 335 14 197 658 NAND2XL $T=3260400 3074400 0 0 $X=3256100 $Y=3070400
X72 794 335 14 659 827 NAND2XL $T=3306600 3578400 0 180 $X=3282500 $Y=3522600
X73 443 335 14 662 795 NAND2XL $T=3293400 3276000 1 0 $X=3289100 $Y=3220200
X74 639 335 14 793 794 NAND2XL $T=3293400 3578400 0 0 $X=3289100 $Y=3574400
X75 304 335 14 445 446 NAND2XL $T=3319800 3175200 1 0 $X=3315500 $Y=3119400
X76 385 335 14 384 386 NAND2XL $T=3372600 3074400 0 0 $X=3368300 $Y=3070400
X77 675 335 14 673 449 NAND2XL $T=3577200 3578400 0 180 $X=3553100 $Y=3522600
X78 449 335 14 676 803 NAND2XL $T=3623400 3578400 1 0 $X=3619100 $Y=3522600
X79 322 335 14 804 682 NAND2XL $T=3722400 3578400 1 180 $X=3698300 $Y=3574400
X80 322 335 14 392 686 NAND2XL $T=3781800 3578400 0 0 $X=3777500 $Y=3574400
X81 322 335 14 394 805 NAND2XL $T=3834600 3578400 1 180 $X=3810500 $Y=3574400
X82 322 335 14 692 806 NAND2XL $T=3933600 3578400 0 180 $X=3909500 $Y=3522600
X83 691 335 14 681 701 NAND2XL $T=3966600 3276000 0 0 $X=3962300 $Y=3272000
X84 322 335 14 702 690 NAND2XL $T=3999600 3276000 1 0 $X=3995300 $Y=3220200
X85 322 335 14 703 324 NAND2XL $T=4039200 3276000 0 180 $X=4015100 $Y=3220200
X86 699 335 14 708 705 NAND2XL $T=4072200 3276000 1 180 $X=4048100 $Y=3272000
X87 707 335 14 704 830 NAND2XL $T=4085400 3477600 0 180 $X=4061300 $Y=3421800
X88 322 335 14 711 706 NAND2XL $T=4111800 3276000 0 180 $X=4087700 $Y=3220200
X89 322 335 14 716 689 NAND2XL $T=4125000 3175200 1 0 $X=4120700 $Y=3119400
X90 700 335 14 698 717 NAND2XL $T=4125000 3376800 0 0 $X=4120700 $Y=3372800
X91 809 335 14 697 723 NAND2XL $T=4131600 3477600 0 0 $X=4127300 $Y=3473600
X92 327 335 14 712 398 NAND2XL $T=4138200 3074400 0 0 $X=4133900 $Y=3070400
X93 808 335 14 810 721 NAND2XL $T=4144800 3175200 0 0 $X=4140500 $Y=3171200
X94 710 335 14 331 728 NAND2XL $T=4191000 3074400 0 0 $X=4186700 $Y=3070400
X95 722 335 14 812 731 NAND2XL $T=4197600 3376800 1 0 $X=4193300 $Y=3321000
X96 723 335 14 725 811 NAND2XL $T=4197600 3477600 0 0 $X=4193300 $Y=3473600
X97 815 335 14 452 732 NAND2XL $T=4276800 3276000 0 180 $X=4252700 $Y=3220200
X98 721 335 14 816 815 NAND2XL $T=4290000 3175200 1 180 $X=4265900 $Y=3171200
X99 14 570 410 421 335 NOR2XL $T=2541000 3477600 0 0 $X=2536700 $Y=3473600
X100 14 579 572 574 335 NOR2XL $T=2580600 3578400 1 0 $X=2576300 $Y=3522600
X101 14 574 421 769 335 NOR2XL $T=2580600 3578400 0 0 $X=2576300 $Y=3574400
X102 14 424 513 422 335 NOR2XL $T=2653200 3376800 0 180 $X=2629100 $Y=3321000
X103 14 278 579 770 335 NOR2XL $T=2640000 3578400 1 0 $X=2635700 $Y=3522600
X104 14 287 156 288 335 NOR2XL $T=2640000 3578400 0 0 $X=2635700 $Y=3574400
X105 14 580 581 584 335 NOR2XL $T=2686200 3376800 0 0 $X=2681900 $Y=3372800
X106 14 148 570 593 335 NOR2XL $T=2686200 3477600 1 0 $X=2681900 $Y=3421800
X107 14 770 593 427 335 NOR2XL $T=2745600 3477600 1 0 $X=2741300 $Y=3421800
X108 14 567 424 775 335 NOR2XL $T=2778600 3175200 1 0 $X=2774300 $Y=3119400
X109 14 280 432 606 335 NOR2XL $T=2917200 3175200 1 0 $X=2912900 $Y=3119400
X110 14 431 629 431 335 NOR2XL $T=3069000 3578400 1 0 $X=3064700 $Y=3522600
X111 14 428 191 785 335 NOR2XL $T=3128400 3175200 1 0 $X=3124100 $Y=3119400
X112 14 426 615 433 335 NOR2XL $T=3128400 3376800 0 0 $X=3124100 $Y=3372800
X113 14 191 591 438 335 NOR2XL $T=3154800 3477600 1 180 $X=3130700 $Y=3473600
X114 14 285 301 645 335 NOR2XL $T=3135000 3578400 0 0 $X=3130700 $Y=3574400
X115 14 191 432 786 335 NOR2XL $T=3148200 3276000 1 0 $X=3143900 $Y=3220200
X116 14 191 611 787 335 NOR2XL $T=3148200 3276000 0 0 $X=3143900 $Y=3272000
X117 14 191 615 640 335 NOR2XL $T=3148200 3376800 0 0 $X=3143900 $Y=3372800
X118 14 191 294 788 335 NOR2XL $T=3154800 3477600 0 0 $X=3150500 $Y=3473600
X119 14 191 301 643 335 NOR2XL $T=3154800 3578400 1 0 $X=3150500 $Y=3522600
X120 14 550 792 442 335 NOR2XL $T=3207600 3175200 0 0 $X=3203300 $Y=3171200
X121 14 561 591 653 335 NOR2XL $T=3207600 3578400 1 0 $X=3203300 $Y=3522600
X122 14 191 792 791 335 NOR2XL $T=3253800 3175200 0 180 $X=3229700 $Y=3119400
X123 14 191 197 790 335 NOR2XL $T=3240600 3074400 0 0 $X=3236300 $Y=3070400
X124 14 568 197 656 335 NOR2XL $T=3253800 3175200 1 0 $X=3249500 $Y=3119400
X125 14 645 653 382 335 NOR2XL $T=3253800 3578400 0 0 $X=3249500 $Y=3574400
X126 14 442 656 445 335 NOR2XL $T=3273600 3276000 1 0 $X=3269300 $Y=3220200
X127 14 446 206 798 335 NOR2XL $T=3359400 3578400 1 0 $X=3355100 $Y=3522600
X128 14 691 681 696 335 NOR2XL $T=3940200 3276000 0 0 $X=3935900 $Y=3272000
X129 14 699 708 713 335 NOR2XL $T=4085400 3276000 0 0 $X=4081100 $Y=3272000
X130 14 700 698 715 335 NOR2XL $T=4098600 3376800 0 0 $X=4094300 $Y=3372800
X131 14 809 697 714 335 NOR2XL $T=4111800 3477600 0 0 $X=4107500 $Y=3473600
X132 14 327 712 397 335 NOR2XL $T=4118400 3074400 0 0 $X=4114100 $Y=3070400
X133 14 808 810 724 335 NOR2XL $T=4151400 3175200 1 0 $X=4147100 $Y=3119400
X134 14 696 713 722 335 NOR2XL $T=4151400 3276000 0 0 $X=4147100 $Y=3272000
X135 14 710 331 726 335 NOR2XL $T=4164600 3074400 0 0 $X=4160300 $Y=3070400
X136 14 714 715 812 335 NOR2XL $T=4191000 3477600 1 0 $X=4186700 $Y=3421800
X137 14 726 724 332 335 NOR2XL $T=4250400 3175200 1 0 $X=4246100 $Y=3119400
X138 151 14 335 532 INVXL $T=2131800 3376800 0 0 $X=2127500 $Y=3372800
X139 423 14 335 573 INVXL $T=2620200 3376800 1 180 $X=2602700 $Y=3372800
X140 422 14 335 771 INVXL $T=2640000 3376800 0 0 $X=2635700 $Y=3372800
X141 375 14 335 165 INVXL $T=2758800 3578400 0 0 $X=2754500 $Y=3574400
X142 173 14 335 293 INVXL $T=2838000 3074400 0 0 $X=2833700 $Y=3070400
X143 592 14 335 601 INVXL $T=2857800 3477600 1 0 $X=2853500 $Y=3421800
X144 776 14 335 428 INVXL $T=2864400 3276000 1 0 $X=2860100 $Y=3220200
X145 617 14 335 621 INVXL $T=2996400 3578400 0 0 $X=2992100 $Y=3574400
X146 622 14 335 624 INVXL $T=3069000 3578400 0 180 $X=3051500 $Y=3522600
X147 626 14 335 628 INVXL $T=3062400 3276000 0 0 $X=3058100 $Y=3272000
X148 782 14 335 784 INVXL $T=3062400 3477600 0 0 $X=3058100 $Y=3473600
X149 188 14 335 300 INVXL $T=3121800 3074400 0 0 $X=3117500 $Y=3070400
X150 195 14 335 441 INVXL $T=3227400 3578400 1 0 $X=3223100 $Y=3522600
X151 442 14 335 662 INVXL $T=3260400 3276000 1 0 $X=3256100 $Y=3220200
X152 645 14 335 793 INVXL $T=3273600 3578400 0 0 $X=3269300 $Y=3574400
X153 443 14 335 664 INVXL $T=3313200 3276000 1 0 $X=3308900 $Y=3220200
X154 668 14 335 667 INVXL $T=3405600 3276000 1 180 $X=3388100 $Y=3272000
X155 387 14 335 308 INVXL $T=3425400 3578400 0 180 $X=3407900 $Y=3522600
X156 449 14 335 801 INVXL $T=3583800 3578400 0 0 $X=3579500 $Y=3574400
X157 714 14 335 725 INVXL $T=4210800 3477600 1 0 $X=4206500 $Y=3421800
X158 399 14 335 729 INVXL $T=4230600 3477600 1 180 $X=4213100 $Y=3473600
X159 724 14 335 816 INVXL $T=4270200 3175200 1 0 $X=4265900 $Y=3119400
X160 721 14 335 451 INVXL $T=4296600 3175200 0 180 $X=4279100 $Y=3119400
X161 421 335 573 571 14 576 OAI21XL $T=2626800 3477600 0 180 $X=2596100 $Y=3421800
X162 571 335 574 577 14 768 OAI21XL $T=2626800 3578400 0 180 $X=2596100 $Y=3522600
X163 580 335 422 425 14 423 OAI21XL $T=2673000 3477600 0 180 $X=2642300 $Y=3421800
X164 589 335 770 582 14 585 OAI21XL $T=2732400 3477600 1 180 $X=2701700 $Y=3473600
X165 374 335 166 162 14 590 OAI21XL $T=2752200 3578400 1 180 $X=2721500 $Y=3574400
X166 597 335 775 595 14 592 OAI21XL $T=2831400 3175200 1 180 $X=2800700 $Y=3171200
X167 587 335 152 597 14 776 OAI21XL $T=2838000 3175200 0 0 $X=2833700 $Y=3171200
X168 428 335 177 602 14 603 OAI21XL $T=2877600 3175200 0 0 $X=2873300 $Y=3171200
X169 593 335 601 589 14 609 OAI21XL $T=2897400 3477600 1 0 $X=2893100 $Y=3421800
X170 602 335 606 604 14 607 OAI21XL $T=2910600 3175200 0 0 $X=2906300 $Y=3171200
X171 430 335 609 430 14 615 OAI21XL $T=3003000 3477600 0 180 $X=2972300 $Y=3421800
X172 607 335 627 634 14 638 OAI21XL $T=3121800 3276000 1 0 $X=3117500 $Y=3220200
X173 433 335 630 635 14 434 OAI21XL $T=3121800 3276000 0 0 $X=3117500 $Y=3272000
X174 631 335 434 826 14 642 OAI21XL $T=3148200 3477600 1 0 $X=3143900 $Y=3421800
X175 645 335 644 639 14 303 OAI21XL $T=3214200 3578400 0 0 $X=3209900 $Y=3574400
X176 200 335 632 440 14 670 OAI21XL $T=3253800 3477600 1 180 $X=3223100 $Y=3473600
X177 653 335 441 644 14 659 OAI21XL $T=3247200 3578400 1 0 $X=3242900 $Y=3522600
X178 443 335 656 658 14 660 OAI21XL $T=3267000 3175200 0 0 $X=3262700 $Y=3171200
X179 200 335 638 654 14 655 OAI21XL $T=3293400 3276000 1 180 $X=3262700 $Y=3272000
X180 200 335 828 646 14 665 OAI21XL $T=3280200 3376800 1 0 $X=3275900 $Y=3321000
X181 200 335 642 649 14 305 OAI21XL $T=3313200 3376800 1 180 $X=3282500 $Y=3372800
X182 794 335 659 827 14 666 OAI21XL $T=3313200 3578400 1 0 $X=3308900 $Y=3522600
X183 200 335 636 302 14 447 OAI21XL $T=3333000 3578400 0 0 $X=3328700 $Y=3574400
X184 200 335 797 651 14 211 OAI21XL $T=3346200 3175200 0 0 $X=3341900 $Y=3171200
X185 446 335 204 444 14 669 OAI21XL $T=3379200 3477600 1 180 $X=3348500 $Y=3473600
X186 206 335 308 204 14 668 OAI21XL $T=3405600 3578400 1 180 $X=3374900 $Y=3574400
X187 200 335 799 652 14 310 OAI21XL $T=3405600 3074400 0 0 $X=3401300 $Y=3070400
X188 200 335 800 389 14 311 OAI21XL $T=3504600 3578400 1 180 $X=3473900 $Y=3574400
X189 200 335 314 201 14 448 OAI21XL $T=3524400 3578400 0 0 $X=3520100 $Y=3574400
X190 707 335 704 830 14 829 OAI21XL $T=4059000 3477600 0 180 $X=4028300 $Y=3421800
X191 713 335 450 705 14 709 OAI21XL $T=4125000 3276000 0 0 $X=4120700 $Y=3272000
X192 705 335 696 701 14 718 OAI21XL $T=4125000 3376800 1 0 $X=4120700 $Y=3321000
X193 723 335 715 717 14 720 OAI21XL $T=4171200 3477600 0 180 $X=4140500 $Y=3421800
X194 721 335 726 728 14 814 OAI21XL $T=4210800 3175200 1 0 $X=4206500 $Y=3119400
X195 815 335 452 732 14 711 OAI21XL $T=4243800 3276000 0 180 $X=4213100 $Y=3220200
X196 731 335 399 727 14 236 OAI21XL $T=4250400 3376800 0 180 $X=4219700 $Y=3321000
X197 404 44 14 250 831 335 250 AOI21XL $T=488400 3074400 0 0 $X=484100 $Y=3070400
X198 525 55 14 754 832 335 511 AOI21XL $T=1247400 3276000 1 180 $X=1216700 $Y=3272000
X199 759 55 14 539 833 335 34 AOI21XL $T=1683000 3578400 0 180 $X=1652300 $Y=3522600
X200 423 769 14 768 834 335 157 AOI21XL $T=2626800 3578400 1 180 $X=2596100 $Y=3574400
X201 580 581 14 584 835 335 588 AOI21XL $T=2712600 3376800 0 0 $X=2708300 $Y=3372800
X202 592 427 14 585 836 335 375 AOI21XL $T=2745600 3477600 0 0 $X=2741300 $Y=3473600
X203 613 624 14 621 837 335 629 AOI21XL $T=3022800 3578400 1 0 $X=3018500 $Y=3522600
X204 625 607 14 628 838 335 630 AOI21XL $T=3082200 3276000 0 0 $X=3077900 $Y=3272000
X205 623 434 14 784 839 335 622 AOI21XL $T=3115200 3477600 1 180 $X=3084500 $Y=3473600
X206 431 629 14 431 840 335 632 AOI21XL $T=3128400 3578400 0 180 $X=3097700 $Y=3522600
X207 304 660 14 383 841 335 444 AOI21XL $T=3286800 3074400 0 0 $X=3282500 $Y=3070400
X208 662 668 14 664 842 335 796 AOI21XL $T=3333000 3276000 1 0 $X=3328700 $Y=3220200
X209 802 676 14 801 843 335 317 AOI21XL $T=3630000 3578400 1 180 $X=3599300 $Y=3574400
X210 322 829 14 325 844 335 688 AOI21XL $T=3993000 3477600 0 180 $X=3962300 $Y=3421800
X211 720 722 14 718 845 335 727 AOI21XL $T=4158000 3376800 1 0 $X=4153700 $Y=3321000
X212 812 729 14 720 846 335 450 AOI21XL $T=4204200 3376800 1 180 $X=4173500 $Y=3372800
X213 333 332 14 814 847 335 400 AOI21XL $T=4250400 3074400 1 180 $X=4219700 $Y=3070400
X214 816 452 14 451 848 335 730 AOI21XL $T=4257000 3175200 1 180 $X=4226300 $Y=3171200
X215 241 54 850 849 14 851 453 335 852 14 DFFSXL $T=33000 3276000 0 0 $X=28700 $Y=3272000
X216 241 82 854 853 14 855 454 335 856 14 DFFSXL $T=52800 3175200 1 0 $X=48500 $Y=3119400
X217 9 242 858 857 14 859 464 335 860 14 DFFSXL $T=151800 3477600 1 0 $X=147500 $Y=3421800
X218 12 10 862 861 14 863 461 335 864 14 DFFSXL $T=171600 3578400 0 0 $X=167300 $Y=3574400
X219 12 54 866 865 14 867 463 335 868 14 DFFSXL $T=178200 3578400 1 0 $X=173900 $Y=3522600
X220 9 7 870 869 14 871 465 335 872 14 DFFSXL $T=211200 3276000 0 0 $X=206900 $Y=3272000
X221 12 242 874 873 14 875 472 335 876 14 DFFSXL $T=310200 3477600 1 0 $X=305900 $Y=3421800
X222 12 99 878 877 14 879 469 335 880 14 DFFSXL $T=310200 3477600 0 0 $X=305900 $Y=3473600
X223 16 133 882 881 14 883 470 335 884 14 DFFSXL $T=316800 3175200 1 0 $X=312500 $Y=3119400
X224 12 133 886 885 14 887 471 335 888 14 DFFSXL $T=316800 3376800 0 0 $X=312500 $Y=3372800
X225 12 32 890 889 14 891 480 335 892 14 DFFSXL $T=429000 3376800 1 0 $X=424700 $Y=3321000
X226 12 7 894 893 14 895 488 335 896 14 DFFSXL $T=547800 3376800 0 0 $X=543500 $Y=3372800
X227 12 24 898 897 14 899 818 335 900 14 DFFSXL $T=561000 3276000 0 0 $X=556700 $Y=3272000
X228 16 242 902 901 14 903 482 335 904 14 DFFSXL $T=574200 3578400 1 0 $X=569900 $Y=3522600
X229 16 7 906 905 14 907 484 335 908 14 DFFSXL $T=580800 3477600 0 0 $X=576500 $Y=3473600
X230 12 38 910 909 14 911 493 335 912 14 DFFSXL $T=613800 3175200 1 0 $X=609500 $Y=3119400
X231 16 24 914 913 14 915 742 335 916 14 DFFSXL $T=633600 3477600 1 0 $X=629300 $Y=3421800
X232 16 38 918 917 14 919 744 335 920 14 DFFSXL $T=699600 3376800 1 0 $X=695300 $Y=3321000
X233 9 38 922 921 14 923 745 335 924 14 DFFSXL $T=752400 3175200 1 0 $X=748100 $Y=3119400
X234 40 24 926 925 14 927 497 335 928 14 DFFSXL $T=805200 3376800 0 0 $X=800900 $Y=3372800
X235 40 7 930 929 14 931 502 335 932 14 DFFSXL $T=805200 3477600 1 0 $X=800900 $Y=3421800
X236 9 80 934 933 14 935 747 335 936 14 DFFSXL $T=851400 3175200 0 0 $X=847100 $Y=3171200
X237 36 38 938 937 14 939 748 335 940 14 DFFSXL $T=910800 3578400 1 0 $X=906500 $Y=3522600
X238 50 7 942 941 14 943 749 335 944 14 DFFSXL $T=970200 3376800 0 0 $X=965900 $Y=3372800
X239 36 7 946 945 14 947 517 335 948 14 DFFSXL $T=1029600 3477600 0 0 $X=1025300 $Y=3473600
X240 40 45 950 949 14 951 751 335 952 14 DFFSXL $T=1089000 3376800 1 0 $X=1084700 $Y=3321000
X241 40 1 954 953 14 955 352 335 956 14 DFFSXL $T=1207800 3477600 1 0 $X=1203500 $Y=3421800
X242 77 7 958 957 14 959 524 335 960 14 DFFSXL $T=1214400 3578400 0 0 $X=1210100 $Y=3574400
X243 49 38 962 961 14 963 72 335 964 14 DFFSXL $T=1240800 3376800 1 0 $X=1236500 $Y=3321000
X244 49 7 966 965 14 967 756 335 968 14 DFFSXL $T=1247400 3376800 0 0 $X=1243100 $Y=3372800
X245 49 1 970 969 14 971 529 335 972 14 DFFSXL $T=1260600 3074400 0 0 $X=1256300 $Y=3070400
X246 40 54 974 973 14 975 495 335 976 14 DFFSXL $T=1280400 3477600 0 0 $X=1276100 $Y=3473600
X247 49 45 978 977 14 979 525 335 980 14 DFFSXL $T=1306800 3276000 1 0 $X=1302500 $Y=3220200
X248 40 10 982 981 119 983 523 335 984 14 DFFSXL $T=1333200 3477600 1 0 $X=1328900 $Y=3421800
X249 40 532 986 985 119 987 988 335 83 14 DFFSXL $T=1432200 3276000 0 0 $X=1427900 $Y=3272000
X250 40 23 990 989 119 991 359 335 992 14 DFFSXL $T=1438800 3477600 0 0 $X=1434500 $Y=3473600
X251 95 23 994 993 119 995 530 335 996 14 DFFSXL $T=1452000 3376800 0 0 $X=1447700 $Y=3372800
X252 40 99 998 997 119 999 535 335 1000 14 DFFSXL $T=1458600 3578400 0 0 $X=1454300 $Y=3574400
X253 49 93 1002 1001 119 1003 531 335 1004 14 DFFSXL $T=1557600 3276000 0 0 $X=1553300 $Y=3272000
X254 49 99 1006 1005 119 1007 536 335 1008 14 DFFSXL $T=1564200 3477600 0 0 $X=1559900 $Y=3473600
X255 49 267 1010 1009 14 1011 1012 335 759 14 DFFSXL $T=1570800 3276000 1 0 $X=1566500 $Y=3220200
X256 49 151 1014 1013 119 1015 538 335 1016 14 DFFSXL $T=1577400 3376800 0 0 $X=1573100 $Y=3372800
X257 113 79 1018 1017 119 1019 270 335 1020 14 DFFSXL $T=1663200 3074400 0 0 $X=1658900 $Y=3070400
X258 116 1 1022 1021 119 1023 414 335 1024 14 DFFSXL $T=1669800 3578400 0 0 $X=1665500 $Y=3574400
X259 116 54 1026 1025 119 1027 541 335 1028 14 DFFSXL $T=1702800 3376800 0 0 $X=1698500 $Y=3372800
X260 116 99 1030 1029 119 1031 544 335 1032 14 DFFSXL $T=1702800 3477600 1 0 $X=1698500 $Y=3421800
X261 116 45 1034 1033 119 1035 543 335 1036 14 DFFSXL $T=1722600 3276000 0 0 $X=1718300 $Y=3272000
X262 113 10 1038 1037 119 1039 366 335 1040 14 DFFSXL $T=1808400 3074400 0 0 $X=1804100 $Y=3070400
X263 113 45 1042 1041 119 1043 274 335 1044 14 DFFSXL $T=1808400 3276000 1 0 $X=1804100 $Y=3220200
X264 113 242 1046 1045 119 1047 417 335 1048 14 DFFSXL $T=1808400 3578400 0 0 $X=1804100 $Y=3574400
X265 116 242 1050 1049 119 1051 553 335 1052 14 DFFSXL $T=1815000 3175200 1 0 $X=1810700 $Y=3119400
X266 113 1 1054 1053 119 1055 824 335 1056 14 DFFSXL $T=1828200 3376800 0 0 $X=1823900 $Y=3372800
X267 113 23 1058 1057 119 1059 761 335 1060 14 DFFSXL $T=1834800 3376800 1 0 $X=1830500 $Y=3321000
X268 135 82 1062 1061 119 1063 559 335 1064 14 DFFSXL $T=1973400 3477600 1 0 $X=1969100 $Y=3421800
X269 135 23 23 1065 119 1066 558 335 1067 14 DFFSXL $T=1980000 3376800 1 0 $X=1975700 $Y=3321000
X270 135 99 99 1068 119 1069 825 335 1070 14 DFFSXL $T=1980000 3578400 1 0 $X=1975700 $Y=3522600
X271 135 133 133 1071 119 1072 370 335 1073 14 DFFSXL $T=1980000 3578400 0 0 $X=1975700 $Y=3574400
X272 135 54 54 1074 119 1075 420 335 1076 14 DFFSXL $T=1986600 3276000 0 0 $X=1982300 $Y=3272000
X273 135 1 1078 1077 277 1079 562 335 1080 14 DFFSXL $T=2046000 3276000 1 0 $X=2041700 $Y=3220200
X274 135 45 1082 1081 277 1083 563 335 1084 14 DFFSXL $T=2052600 3175200 1 0 $X=2048300 $Y=3119400
X275 135 242 1086 1085 277 1087 565 335 1088 14 DFFSXL $T=2059200 3074400 0 0 $X=2054900 $Y=3070400
X276 145 54 1090 1089 14 1091 545 335 1092 14 DFFSXL $T=2171400 3578400 0 0 $X=2167100 $Y=3574400
X277 145 133 1094 1093 14 1095 149 335 1096 14 DFFSXL $T=2178000 3578400 1 0 $X=2173700 $Y=3522600
X278 145 99 1098 1097 14 1099 766 335 1100 14 DFFSXL $T=2197800 3477600 0 0 $X=2193500 $Y=3473600
X279 145 80 80 1101 282 1102 137 335 1103 14 DFFSXL $T=2230800 3276000 0 0 $X=2226500 $Y=3272000
X280 145 45 1105 1104 282 1106 554 335 1107 14 DFFSXL $T=2263800 3175200 1 0 $X=2259500 $Y=3119400
X281 145 1 1109 1108 282 1110 564 335 1111 14 DFFSXL $T=2270400 3276000 1 0 $X=2266100 $Y=3220200
X282 283 54 1113 1112 282 1114 561 335 1115 14 DFFSXL $T=2296800 3578400 0 0 $X=2292500 $Y=3574400
X283 283 151 1117 1116 282 1118 372 335 1119 14 DFFSXL $T=2316600 3578400 1 0 $X=2312300 $Y=3522600
X284 283 133 1121 1120 282 1122 285 335 1123 14 DFFSXL $T=2336400 3477600 0 0 $X=2332100 $Y=3473600
X285 283 23 1125 1124 282 1126 566 335 1127 14 DFFSXL $T=2343000 3376800 1 0 $X=2338700 $Y=3321000
X286 283 10 1129 1128 282 1130 286 335 1131 14 DFFSXL $T=2395800 3175200 0 0 $X=2391500 $Y=3171200
X287 283 147 1133 1132 282 1134 550 335 1135 14 DFFSXL $T=2395800 3276000 1 0 $X=2391500 $Y=3220200
X288 150 82 1137 1136 282 1138 172 335 1139 14 DFFSXL $T=2442000 3477600 1 0 $X=2437700 $Y=3421800
X289 150 10 1141 1140 14 1142 148 335 1143 14 DFFSXL $T=2448600 3578400 0 0 $X=2444300 $Y=3574400
X290 283 79 1145 1144 282 1146 177 335 1147 14 DFFSXL $T=2468400 3276000 0 0 $X=2464100 $Y=3272000
X291 283 1 1149 1148 282 1150 429 335 1151 14 DFFSXL $T=2547600 3175200 0 0 $X=2543300 $Y=3171200
X292 283 7 1153 1152 282 1154 143 335 1155 14 DFFSXL $T=2547600 3276000 1 0 $X=2543300 $Y=3220200
X293 283 48 1157 1156 282 1158 568 335 1159 14 DFFSXL $T=2560800 3074400 0 0 $X=2556500 $Y=3070400
X294 283 99 1161 1160 282 1162 426 335 1163 14 DFFSXL $T=2620200 3276000 0 0 $X=2615900 $Y=3272000
X295 161 373 1165 1164 282 1166 594 335 1167 14 DFFSXL $T=2712600 3074400 0 0 $X=2708300 $Y=3070400
X296 170 773 1169 1168 282 1170 587 335 600 14 DFFSXL $T=2745600 3276000 0 0 $X=2741300 $Y=3272000
X297 170 772 1172 1171 282 1173 424 335 437 14 DFFSXL $T=2745600 3376800 0 0 $X=2741300 $Y=3372800
X298 170 774 1175 1174 282 1176 579 335 608 14 DFFSXL $T=2772000 3477600 0 0 $X=2767700 $Y=3473600
X299 170 378 1178 1177 282 1179 379 335 380 14 DFFSXL $T=2818200 3578400 1 0 $X=2813900 $Y=3522600
X300 170 169 1181 1180 282 1182 156 335 620 14 DFFSXL $T=2864400 3376800 1 0 $X=2860100 $Y=3321000
X301 170 780 1184 1183 282 1185 295 335 637 14 DFFSXL $T=2996400 3175200 1 0 $X=2992100 $Y=3119400
X302 170 182 1187 1186 196 1188 298 335 435 14 DFFSXL $T=3003000 3175200 0 0 $X=2998700 $Y=3171200
X303 205 447 1190 1189 196 1191 671 335 1192 14 DFFSXL $T=3379200 3276000 1 0 $X=3374900 $Y=3220200
X304 205 614 1194 1193 196 1195 673 335 1196 14 DFFSXL $T=3385800 3376800 0 0 $X=3381500 $Y=3372800
X305 205 211 1198 1197 196 1199 312 335 1200 14 DFFSXL $T=3392400 3175200 0 0 $X=3388100 $Y=3171200
X306 205 648 1202 1201 196 1203 316 335 1204 14 DFFSXL $T=3425400 3578400 1 0 $X=3421100 $Y=3522600
X307 313 448 1206 1205 14 1207 677 335 1208 14 DFFSXL $T=3517800 3074400 0 0 $X=3513500 $Y=3070400
X308 313 655 1210 1209 196 1211 223 335 1212 14 DFFSXL $T=3517800 3276000 1 0 $X=3513500 $Y=3220200
X309 205 448 1214 1213 196 1215 678 335 1216 14 DFFSXL $T=3524400 3175200 1 0 $X=3520100 $Y=3119400
X310 205 224 1218 1217 196 1219 683 335 1220 14 DFFSXL $T=3636600 3175200 0 0 $X=3632300 $Y=3171200
X311 313 306 1222 1221 196 1223 684 335 1224 14 DFFSXL $T=3636600 3276000 0 0 $X=3632300 $Y=3272000
X312 313 311 1226 1225 14 1227 390 335 1228 14 DFFSXL $T=3656400 3074400 0 0 $X=3652100 $Y=3070400
X313 313 665 1230 1229 196 1231 693 335 1232 14 DFFSXL $T=3669600 3477600 0 0 $X=3665300 $Y=3473600
X314 313 224 1234 1233 196 1235 687 335 1236 14 DFFSXL $T=3696000 3175200 1 0 $X=3691700 $Y=3119400
X315 227 682 1238 1237 196 1239 675 335 1240 14 DFFSXL $T=3709200 3578400 1 0 $X=3704900 $Y=3522600
X316 227 806 1242 1241 196 1243 695 335 1244 14 DFFSXL $T=3821400 3477600 0 0 $X=3817100 $Y=3473600
X317 227 805 1246 1245 196 1247 228 335 1248 14 DFFSXL $T=3828000 3376800 0 0 $X=3823700 $Y=3372800
X318 227 689 1250 1249 196 1251 395 335 1252 14 DFFSXL $T=3834600 3175200 1 0 $X=3830300 $Y=3119400
X319 227 686 1254 1253 196 1255 323 335 1256 14 DFFSXL $T=3841200 3578400 0 0 $X=3836900 $Y=3574400
X320 227 706 1258 1257 196 1259 330 335 1260 14 DFFSXL $T=3847800 3175200 0 0 $X=3843500 $Y=3171200
X321 227 690 1262 1261 196 1263 320 335 1264 14 DFFSXL $T=3874200 3276000 1 0 $X=3869900 $Y=3220200
X322 421 335 571 1265 14 767 NAND2BXL $T=2593800 3477600 1 180 $X=2563100 $Y=3473600
X323 574 335 577 1266 14 578 NAND2BXL $T=2600400 3477600 0 0 $X=2596100 $Y=3473600
X324 288 335 289 1267 14 586 NAND2BXL $T=2692800 3578400 0 0 $X=2688500 $Y=3574400
X325 770 335 582 1268 14 430 NAND2BXL $T=2706000 3578400 1 0 $X=2701700 $Y=3522600
X326 775 335 595 1269 14 598 NAND2BXL $T=2811600 3175200 1 0 $X=2807300 $Y=3119400
X327 593 335 589 1270 14 777 NAND2BXL $T=2877600 3376800 0 0 $X=2873300 $Y=3372800
X328 606 335 604 1271 14 779 NAND2BXL $T=2937000 3074400 0 0 $X=2932700 $Y=3070400
X329 433 335 635 1272 14 641 NAND2BXL $T=3148200 3376800 1 0 $X=3143900 $Y=3321000
X330 653 335 644 1273 14 439 NAND2BXL $T=3267000 3477600 0 0 $X=3262700 $Y=3473600
X331 656 335 658 1274 14 663 NAND2BXL $T=3286800 3175200 1 0 $X=3282500 $Y=3119400
X332 667 335 445 1275 14 661 NAND2BXL $T=3333000 3175200 1 180 $X=3302300 $Y=3171200
X333 660 335 661 1276 14 384 NAND2BXL $T=3326400 3074400 0 0 $X=3322100 $Y=3070400
X334 696 335 701 1277 14 807 NAND2BXL $T=4006200 3276000 0 0 $X=4001900 $Y=3272000
X335 715 335 717 717 14 707 NAND2BXL $T=4138200 3477600 0 180 $X=4107500 $Y=3421800
X336 713 335 705 1278 14 719 NAND2BXL $T=4171200 3276000 0 0 $X=4166900 $Y=3272000
X337 726 335 728 1279 14 813 NAND2BXL $T=4177800 3175200 1 0 $X=4173500 $Y=3119400
X338 333 335 401 1280 14 452 NAND2BXL $T=4263600 3074400 0 0 $X=4259300 $Y=3070400
X339 767 573 335 14 575 XOR2XL $T=2547600 3376800 0 0 $X=2543300 $Y=3372800
X340 597 598 335 14 432 XOR2XL $T=2844600 3175200 1 0 $X=2840300 $Y=3119400
X341 602 779 335 14 619 XOR2XL $T=2937000 3276000 1 0 $X=2932700 $Y=3220200
X342 630 641 335 14 828 XOR2XL $T=3220800 3376800 1 0 $X=3216500 $Y=3321000
X343 439 441 335 14 657 XOR2XL $T=3220800 3376800 0 0 $X=3216500 $Y=3372800
X344 719 450 335 14 703 XOR2XL $T=4171200 3276000 0 180 $X=4114100 $Y=3220200
X345 813 730 335 14 716 XOR2XL $T=4224000 3175200 1 180 $X=4166900 $Y=3171200
X346 685 671 1282 694 1281 1283 1284 699 335 14 698 CMPR32X1 $T=4098600 3376800 0 180 $X=3955700 $Y=3321000
X347 677 678 1286 329 1285 1287 1288 808 335 14 712 CMPR32X1 $T=3966600 3074400 0 0 $X=3962300 $Y=3070400
X348 200 619 335 789 14 648 OAI21X1 $T=3247200 3276000 0 180 $X=3209900 $Y=3220200
X349 200 666 335 650 14 203 OAI21X1 $T=3306600 3477600 0 0 $X=3302300 $Y=3473600
X350 200 657 335 647 14 306 OAI21X1 $T=3326400 3376800 1 0 $X=3322100 $Y=3321000
X351 387 798 14 669 208 335 AOI21X1 $T=3418800 3477600 1 180 $X=3388100 $Y=3473600
X352 377 166 335 14 184 XOR2X1 $T=2785200 3578400 0 0 $X=2780900 $Y=3574400
X353 777 601 335 14 611 XOR2X1 $T=2910600 3376800 0 0 $X=2906300 $Y=3372800
X354 795 667 335 14 797 XOR2X1 $T=3319800 3276000 0 0 $X=3315500 $Y=3272000
X355 663 796 335 14 799 XOR2X1 $T=3352800 3175200 1 0 $X=3348500 $Y=3119400
X356 210 388 335 14 800 XOR2X1 $T=3418800 3578400 0 0 $X=3414500 $Y=3574400
X357 600 192 14 785 335 193 610 AOI211XL $T=3154800 3175200 0 0 $X=3150500 $Y=3171200
X358 296 192 14 193 335 381 440 AOI211XL $T=3168000 3578400 0 0 $X=3163700 $Y=3574400
X359 437 192 14 786 335 193 789 AOI211XL $T=3174600 3276000 1 0 $X=3170300 $Y=3220200
X360 570 192 14 193 335 787 654 AOI211XL $T=3181200 3276000 0 0 $X=3176900 $Y=3272000
X361 608 192 14 193 335 640 646 AOI211XL $T=3181200 3376800 1 0 $X=3176900 $Y=3321000
X362 620 192 14 193 335 438 647 AOI211XL $T=3181200 3376800 0 0 $X=3176900 $Y=3372800
X363 436 192 14 193 335 643 650 AOI211XL $T=3181200 3477600 0 0 $X=3176900 $Y=3473600
X364 618 192 14 193 335 788 649 AOI211XL $T=3187800 3477600 1 0 $X=3183500 $Y=3421800
X365 637 192 14 193 335 791 651 AOI211XL $T=3194400 3175200 1 0 $X=3190100 $Y=3119400
X366 435 192 14 193 335 790 652 AOI211XL $T=3201000 3074400 0 0 $X=3196700 $Y=3070400
X367 633 300 335 14 792 XNOR2X1 $T=3141600 3074400 0 0 $X=3137300 $Y=3070400
X368 184 179 335 14 778 OR2XL $T=2930400 3477600 0 0 $X=2926100 $Y=3473600
X369 291 429 335 14 613 OR2XL $T=2937000 3578400 0 0 $X=2932700 $Y=3574400
X370 294 566 335 14 623 OR2XL $T=3009600 3477600 1 0 $X=3005300 $Y=3421800
X371 611 286 335 14 625 OR2XL $T=3029400 3276000 1 0 $X=3025100 $Y=3220200
X372 295 154 335 14 299 OR2XL $T=3042600 3074400 0 0 $X=3038300 $Y=3070400
X373 673 675 335 14 676 OR2XL $T=3583800 3578400 1 0 $X=3579500 $Y=3522600
X374 578 1289 576 335 14 583 XNOR2XL $T=2640000 3477600 0 0 $X=2635700 $Y=3473600
X375 586 1290 590 335 14 591 XNOR2XL $T=2785200 3578400 0 180 $X=2728100 $Y=3522600
X376 292 1291 293 335 14 605 XNOR2XL $T=2871000 3074400 0 0 $X=2866700 $Y=3070400
X377 783 1292 624 335 14 636 XNOR2XL $T=3062400 3578400 0 0 $X=3058100 $Y=3574400
X378 802 802 803 335 14 804 XNOR2XL $T=3636600 3578400 0 0 $X=3632300 $Y=3574400
X379 807 1293 709 335 14 702 XNOR2XL $T=4092000 3276000 0 180 $X=4034900 $Y=3220200
X380 811 1294 729 335 14 692 XNOR2XL $T=4217400 3578400 0 180 $X=4160300 $Y=3522600
X381 44 736 18 335 468 14 OAI2BB1XL $T=389400 3276000 0 0 $X=385100 $Y=3272000
X382 44 25 460 335 337 14 OAI2BB1XL $T=448800 3074400 0 0 $X=444500 $Y=3070400
X383 44 740 483 335 486 14 OAI2BB1XL $T=541200 3276000 1 0 $X=536900 $Y=3220200
X384 44 487 741 335 489 14 OAI2BB1XL $T=587400 3276000 1 0 $X=583100 $Y=3220200
X385 29 344 490 335 498 14 OAI2BB1XL $T=877800 3074400 1 180 $X=840500 $Y=3070400
X386 44 745 43 335 746 14 OAI2BB1XL $T=877800 3074400 0 0 $X=873500 $Y=3070400
X387 56 64 409 335 753 14 OAI2BB1XL $T=1168200 3477600 0 0 $X=1163900 $Y=3473600
X388 160 603 610 335 614 14 OAI2BB1XL $T=2943600 3175200 0 0 $X=2939300 $Y=3171200
X389 729 725 723 335 704 14 OAI2BB1XL $T=4184400 3477600 1 180 $X=4147100 $Y=3473600
X390 44 465 336 335 466 14 OAI2BB1X1 $T=382800 3276000 1 180 $X=345500 $Y=3272000
X391 335 14 241 242 1295 1296 14 733 1297 9 54 1298 14 735 1299 ICV_1 $T=39600 3376800 1 0 $X=35300 $Y=3321000
X392 335 14 241 133 1300 1301 14 455 1302 243 45 1303 14 458 1304 ICV_1 $T=52800 3175200 0 0 $X=48500 $Y=3171200
X393 335 14 241 45 1305 1306 11 734 1307 243 82 1308 11 459 1309 ICV_1 $T=66000 3074400 0 0 $X=61700 $Y=3070400
X394 335 14 9 151 1310 1311 14 736 1312 9 24 1313 14 740 1314 ICV_1 $T=283800 3276000 1 0 $X=279500 $Y=3220200
X395 335 14 12 151 1315 1316 14 737 1317 16 151 1318 14 474 1319 ICV_1 $T=310200 3578400 0 0 $X=305900 $Y=3574400
X396 335 14 9 45 1320 1321 14 404 1322 9 133 1323 14 487 1324 ICV_1 $T=541200 3175200 0 0 $X=536900 $Y=3171200
X397 335 14 36 54 1325 1326 14 743 1327 36 24 1328 14 496 1329 ICV_1 $T=686400 3578400 0 0 $X=682100 $Y=3574400
X398 335 14 16 32 1330 1331 14 491 1332 40 32 1333 14 508 1334 ICV_1 $T=693000 3276000 1 0 $X=688700 $Y=3220200
X399 335 14 40 38 1335 1336 14 503 1337 40 48 1338 14 407 1339 ICV_1 $T=825000 3376800 1 0 $X=820700 $Y=3321000
X400 335 14 40 80 1340 1341 14 514 1342 36 32 1343 14 519 1344 ICV_1 $T=957000 3276000 0 0 $X=952700 $Y=3272000
X401 335 14 50 80 1345 1346 14 260 1347 36 80 80 14 516 1348 ICV_1 $T=976800 3175200 1 0 $X=972500 $Y=3119400
X402 335 14 49 54 54 1349 14 406 1350 36 48 1351 14 520 1352 ICV_1 $T=983400 3074400 0 0 $X=979100 $Y=3070400
X403 335 14 49 10 1353 1354 14 412 1355 95 242 1356 14 757 1357 ICV_1 $T=1293600 3175200 1 0 $X=1289300 $Y=3119400
X404 335 14 49 82 1358 1359 14 354 1360 40 93 1361 14 526 1362 ICV_1 $T=1306800 3175200 0 0 $X=1302500 $Y=3171200
X405 335 14 95 54 1363 1364 119 758 1365 49 23 1366 119 537 1367 ICV_1 $T=1438800 3376800 1 0 $X=1434500 $Y=3321000
X406 335 14 49 242 1368 1369 14 413 1370 113 38 1371 119 120 1372 ICV_1 $T=1551000 3175200 1 0 $X=1546700 $Y=3119400
X407 335 14 116 82 1373 1374 119 540 1375 113 99 1376 119 546 1377 ICV_1 $T=1689600 3477600 0 0 $X=1685300 $Y=3473600
X408 335 14 145 151 1378 1379 282 281 1380 283 82 1381 282 176 1382 ICV_1 $T=2204400 3376800 0 0 $X=2200100 $Y=3372800
X409 335 14 145 371 1383 1384 277 555 1385 150 45 1386 282 567 1387 ICV_1 $T=2303400 3074400 0 0 $X=2299100 $Y=3070400
X410 335 14 205 655 1388 1389 196 307 1390 205 665 1391 196 674 1392 ICV_1 $T=3273600 3477600 1 0 $X=3269300 $Y=3421800
X411 335 14 205 670 1393 1394 196 672 1395 313 670 1396 196 680 1397 ICV_1 $T=3379200 3376800 1 0 $X=3374900 $Y=3321000
X412 335 14 313 305 1398 196 196 679 1399 313 447 1400 196 685 1401 ICV_1 $T=3524400 3376800 0 0 $X=3520100 $Y=3372800
X413 335 14 313 614 1402 1403 196 802 1404 313 648 1405 196 391 1406 ICV_1 $T=3537600 3477600 1 0 $X=3533300 $Y=3421800
X414 55 406 14 255 261 55 259 492 335 AOI222XL $T=1062600 3578400 1 180 $X=1005500 $Y=3574400
X415 51 502 14 524 55 261 749 822 335 AOI222XL $T=1029600 3477600 1 0 $X=1025300 $Y=3421800
X416 55 58 14 59 55 261 257 750 335 AOI222XL $T=1115400 3578400 0 180 $X=1058300 $Y=3522600
X417 55 61 14 751 51 55 60 752 335 AOI222XL $T=1155000 3477600 0 180 $X=1097900 $Y=3421800
X418 68 254 14 63 55 69 261 411 335 AOI222XL $T=1161600 3578400 1 0 $X=1157300 $Y=3522600
X419 96 523 14 66 55 55 70 409 335 AOI222XL $T=1214400 3578400 1 0 $X=1210100 $Y=3522600
X420 143 550 14 276 129 125 127 542 335 AOI222XL $T=1966800 3578400 0 180 $X=1909700 $Y=3522600
X421 142 141 14 154 143 131 271 764 335 AOI222XL $T=2138400 3477600 1 180 $X=2081300 $Y=3473600
X422 142 420 14 561 143 143 287 275 335 AOI222XL $T=2158200 3578400 1 180 $X=2101100 $Y=3574400
X423 142 559 14 143 172 143 176 418 335 AOI222XL $T=2145000 3477600 1 0 $X=2140700 $Y=3421800
X424 129 564 14 562 142 146 279 419 335 AOI222XL $T=2151600 3276000 0 0 $X=2147300 $Y=3272000
X425 142 563 14 567 143 143 280 765 335 AOI222XL $T=2191200 3074400 0 0 $X=2186900 $Y=3070400
X426 142 140 14 155 143 143 568 569 335 AOI222XL $T=2197800 3175200 0 0 $X=2193500 $Y=3171200
X427 142 565 14 158 143 143 179 552 335 AOI222XL $T=2211000 3175200 1 0 $X=2206700 $Y=3119400
X428 142 558 14 153 143 143 548 566 335 AOI222X1 $T=2151600 3376800 1 0 $X=2147300 $Y=3321000
X429 346 335 14 47 BUFXL $T=910800 3074400 0 0 $X=906500 $Y=3070400
X430 542 335 14 118 BUFXL $T=1834800 3578400 0 180 $X=1804100 $Y=3522600
X431 764 335 14 71 BUFXL $T=2092200 3376800 1 180 $X=2061500 $Y=3372800
X432 765 335 14 560 BUFXL $T=2204400 3175200 0 180 $X=2173700 $Y=3119400
X433 485 335 822 14 509 507 NAND3XL $T=1009800 3477600 0 180 $X=979100 $Y=3421800
X434 552 335 369 14 418 367 NAND3XL $T=1966800 3175200 0 180 $X=1936100 $Y=3119400
X435 334 14 13 244 733 456 335 AOI22XL $T=145200 3276000 1 0 $X=140900 $Y=3220200
X436 8 14 13 244 453 457 335 AOI22XL $T=184800 3276000 1 0 $X=180500 $Y=3220200
X437 734 14 244 13 458 462 335 AOI22XL $T=204600 3175200 1 0 $X=200300 $Y=3119400
X438 454 14 244 13 459 460 335 AOI22XL $T=257400 3175200 1 0 $X=253100 $Y=3119400
X439 737 14 42 29 474 738 335 AOI22XL $T=435600 3578400 1 0 $X=431300 $Y=3522600
X440 469 14 42 29 249 402 335 AOI22XL $T=468600 3578400 1 0 $X=464300 $Y=3522600
X441 470 14 29 42 471 481 335 AOI22XL $T=495000 3376800 0 0 $X=490700 $Y=3372800
X442 461 14 42 29 26 405 335 AOI22XL $T=514800 3477600 1 0 $X=510500 $Y=3421800
X443 463 14 42 29 28 476 335 AOI22XL $T=514800 3578400 1 0 $X=510500 $Y=3522600
X444 472 14 42 29 482 403 335 AOI22XL $T=528000 3477600 0 0 $X=523700 $Y=3473600
X445 455 14 244 13 247 741 335 AOI22XL $T=561000 3175200 1 0 $X=556700 $Y=3119400
X446 488 14 42 29 484 485 335 AOI22XL $T=594000 3477600 0 180 $X=556700 $Y=3421800
X447 339 14 13 244 340 483 335 AOI22XL $T=574200 3074400 0 0 $X=569900 $Y=3070400
X448 341 14 13 244 33 490 335 AOI22XL $T=620400 3074400 0 0 $X=616100 $Y=3070400
X449 480 14 42 29 491 252 335 AOI22XL $T=653400 3376800 1 0 $X=649100 $Y=3321000
X450 818 14 42 29 742 494 335 AOI22XL $T=712800 3276000 0 0 $X=708500 $Y=3272000
X451 743 14 68 51 495 819 335 AOI22XL $T=792000 3477600 1 180 $X=754700 $Y=3473600
X452 493 14 42 29 744 499 335 AOI22XL $T=798600 3276000 0 0 $X=794300 $Y=3272000
X453 496 14 68 51 497 820 335 AOI22XL $T=805200 3477600 0 0 $X=800900 $Y=3473600
X454 747 14 44 42 256 501 335 AOI22XL $T=943800 3175200 0 180 $X=906500 $Y=3119400
X455 748 14 68 51 503 821 335 AOI22XL $T=1029600 3477600 1 180 $X=992300 $Y=3473600
X456 516 14 68 51 514 510 335 AOI22XL $T=1128600 3276000 0 180 $X=1091300 $Y=3220200
X457 519 14 68 51 508 65 335 AOI22XL $T=1174800 3276000 0 180 $X=1137500 $Y=3220200
X458 520 14 68 51 407 518 335 AOI22XL $T=1201200 3175200 1 180 $X=1163900 $Y=3171200
X459 536 14 55 51 535 534 335 AOI22XL $T=1590600 3578400 0 180 $X=1553300 $Y=3522600
X460 545 14 129 131 541 365 335 AOI22XL $T=1874400 3578400 0 180 $X=1837100 $Y=3522600
X461 544 14 131 125 546 549 335 AOI22XL $T=1881000 3477600 1 0 $X=1876700 $Y=3421800
X462 132 14 129 131 128 416 335 AOI22XL $T=1966800 3175200 1 180 $X=1929500 $Y=3171200
X463 368 14 131 129 6 272 335 AOI22XL $T=1947000 3074400 0 0 $X=1942700 $Y=3070400
X464 138 14 129 131 553 763 335 AOI22XL $T=2032800 3074400 1 180 $X=1995500 $Y=3070400
X465 555 14 129 131 540 552 335 AOI22XL $T=2046000 3175200 0 180 $X=2008700 $Y=3119400
X466 825 14 142 143 278 557 335 AOI22XL $T=2125200 3578400 1 0 $X=2120900 $Y=3522600
X467 766 14 129 143 426 556 335 AOI22XL $T=2237400 3477600 0 180 $X=2200100 $Y=3421800
X468 19 335 456 403 739 473 14 NAND4XL $T=448800 3175200 0 0 $X=444500 $Y=3171200
X469 819 335 478 37 253 492 14 NAND4XL $T=752400 3477600 1 180 $X=715100 $Y=3473600
X470 752 335 408 67 754 250 14 NAND4XL $T=1161600 3376800 0 0 $X=1157300 $Y=3372800
X471 78 335 123 518 350 521 14 NAND4XL $T=1254000 3175200 1 180 $X=1216700 $Y=3171200
X472 479 335 533 357 572 534 14 NAND4XL $T=1445400 3578400 1 0 $X=1441100 $Y=3522600
X473 246 402 15 335 14 1407 479 AND3XL $T=448800 3376800 0 0 $X=444500 $Y=3372800
X474 476 467 457 335 14 1408 478 AND3XL $T=488400 3477600 0 0 $X=484100 $Y=3473600
X475 552 763 547 335 14 1409 473 AND3XL $T=2006400 3175200 0 180 $X=1969100 $Y=3119400
X476 548 760 416 124 335 14 AND3X4 $T=1900800 3276000 1 180 $X=1856900 $Y=3272000
X477 355 3 335 14 CLKBUFX3 $T=1419000 3578400 1 180 $X=1388300 $Y=3574400
X478 758 2 335 14 CLKBUFX3 $T=1518000 3477600 0 180 $X=1487300 $Y=3421800
X479 262 14 335 239 CLKBUFX2 $T=1095600 3175200 1 180 $X=1064900 $Y=3171200
X480 264 14 335 86 CLKBUFX2 $T=1372800 3578400 1 180 $X=1342100 $Y=3574400
X481 530 14 335 238 CLKBUFX2 $T=1405800 3376800 0 180 $X=1375100 $Y=3321000
X482 266 14 335 92 CLKBUFX2 $T=1471800 3074400 1 180 $X=1441100 $Y=3070400
X483 757 14 335 240 CLKBUFX2 $T=1485000 3276000 0 180 $X=1454300 $Y=3220200
X484 358 14 335 97 CLKBUFX2 $T=1531200 3074400 1 180 $X=1500500 $Y=3070400
X485 360 14 335 104 CLKBUFX2 $T=1564200 3074400 1 180 $X=1533500 $Y=3070400
X486 361 14 335 107 CLKBUFX2 $T=1610400 3074400 1 180 $X=1579700 $Y=3070400
X487 362 14 335 115 CLKBUFX2 $T=1729200 3276000 0 180 $X=1698500 $Y=3220200
X488 363 14 335 117 CLKBUFX2 $T=1742400 3175200 1 180 $X=1711700 $Y=3171200
X489 393 14 225 1410 335 227 AND2X2 $T=3814800 3074400 0 0 $X=3810500 $Y=3070400
X490 475 335 14 251 BUFX1 $T=574200 3578400 0 0 $X=569900 $Y=3574400
X491 569 335 14 521 BUFX1 $T=2184600 3175200 1 180 $X=2153900 $Y=3171200
X492 258 821 499 506 746 14 335 NAND4BXL $T=976800 3477600 1 180 $X=932900 $Y=3473600
X493 501 348 510 515 498 14 335 NAND4BXL $T=1042800 3175200 1 180 $X=998900 $Y=3171200
X494 462 560 343 415 335 14 512 AND4XL $T=660000 3074400 0 0 $X=655700 $Y=3070400
X495 74 411 411 755 335 14 528 AND4XL $T=1234200 3276000 1 0 $X=1229900 $Y=3220200
X496 136 549 556 557 335 14 533 AND4XL $T=2032800 3477600 0 0 $X=2028500 $Y=3473600
X497 414 131 14 134 429 551 335 AOI22X1 $T=1966800 3276000 1 0 $X=1962500 $Y=3220200
X498 554 129 14 131 543 415 335 AOI22X1 $T=2046000 3175200 1 180 $X=2008700 $Y=3171200
X499 371 82 335 14 CLKBUFX4 $T=2270400 3074400 0 0 $X=2266100 $Y=3070400
X500 319 684 320 321 14 335 681 ADDFHXL $T=3841200 3276000 0 180 $X=3691700 $Y=3220200
X501 672 680 233 691 14 335 708 ADDFHXL $T=3775200 3376800 1 0 $X=3770900 $Y=3321000
X502 315 679 695 700 14 335 697 ADDFHXL $T=4098600 3477600 1 180 $X=3949100 $Y=3473600
X503 674 693 328 809 14 335 326 ADDFHXL $T=3973200 3578400 1 0 $X=3968900 $Y=3522600
X504 683 687 330 710 14 335 810 ADDFHXL $T=3979800 3175200 0 0 $X=3975500 $Y=3171200
X505 170 596 1411 282 570 570 335 570 14 DFFSX1 $T=2996400 3276000 1 180 $X=2866700 $Y=3272000
X506 170 599 1412 282 1413 181 335 618 14 DFFSX1 $T=3108600 3376800 1 180 $X=2978900 $Y=3372800
X507 170 175 1414 282 1415 183 335 436 14 DFFSX1 $T=3115200 3376800 0 180 $X=2985500 $Y=3321000
X508 227 688 1416 196 1417 694 335 1418 14 DFFSX1 $T=3828000 3477600 1 0 $X=3823700 $Y=3421800
X509 114 335 119 14 CLKINVX8 $T=1683000 3276000 0 0 $X=1678700 $Y=3272000
X510 114 335 14 14 CLKINVX8 $T=1788600 3276000 0 180 $X=1744700 $Y=3220200
X511 114 335 277 14 CLKINVX8 $T=2112000 3175200 1 180 $X=2068100 $Y=3171200
X512 114 335 282 14 CLKINVX8 $T=2211000 3376800 1 0 $X=2206700 $Y=3321000
X513 309 335 196 14 CLKINVX8 $T=3445200 3175200 1 0 $X=3440900 $Y=3119400
X514 587 504 335 168 14 580 773 OAI211XL $T=2805000 3276000 0 180 $X=2761100 $Y=3220200
X515 612 622 335 616 14 781 195 OAI211XL $T=3009600 3477600 0 0 $X=3005300 $Y=3473600
X516 284 93 335 14 INVX4 $T=2151600 3376800 0 180 $X=2120900 $Y=3321000
X517 114 14 335 14 INVX4 $T=2151600 3376800 0 0 $X=2147300 $Y=3372800
X518 290 54 335 14 INVX4 $T=2719200 3175200 0 180 $X=2688500 $Y=3119400
X519 594 99 335 14 INVX4 $T=2758800 3175200 1 180 $X=2728100 $Y=3171200
X520 376 1 335 14 INVX4 $T=2765400 3175200 0 180 $X=2734700 $Y=3119400
X521 511 335 512 14 513 NAND2X1 $T=1042800 3276000 1 0 $X=1038500 $Y=3220200
X522 486 335 750 14 349 NAND2X1 $T=1075800 3578400 0 0 $X=1071500 $Y=3574400
X523 824 335 125 14 762 NAND2X1 $T=1980000 3376800 1 180 $X=1955900 $Y=3372800
X524 263 335 505 14 527 351 NAND3X1 $T=1273800 3578400 1 0 $X=1269500 $Y=3522600
X525 364 335 269 14 273 539 NAND3X1 $T=1795200 3578400 0 180 $X=1764500 $Y=3522600
X526 35 14 466 335 507 505 NOR3XL $T=943800 3477600 1 0 $X=939500 $Y=3421800
X527 91 14 94 335 506 356 NOR3XL $T=1425600 3578400 0 0 $X=1421300 $Y=3574400
X528 515 84 105 14 335 102 OR3X1 $T=1399200 3578400 1 0 $X=1394900 $Y=3522600
X529 347 335 14 504 INVX1 $T=937200 3074400 0 0 $X=932900 $Y=3070400
X530 528 335 14 265 INVX1 $T=1386000 3276000 0 0 $X=1381700 $Y=3272000
X531 55 412 14 335 522 AND2XL $T=1306800 3276000 1 180 $X=1276100 $Y=3272000
X532 477 522 753 1419 76 14 335 410 OR4X1 $T=1194600 3276000 1 0 $X=1190300 $Y=3220200
X533 738 14 4 468 22 475 335 NOR4BXL $T=442200 3477600 1 0 $X=437900 $Y=3421800
X534 820 14 500 345 486 486 335 NOR4BXL $T=844800 3477600 0 0 $X=840500 $Y=3473600
X535 481 14 489 342 335 NOR2BXL $T=600600 3376800 1 0 $X=596300 $Y=3321000
X536 248 335 405 338 14 477 NAND3BXL $T=488400 3175200 0 0 $X=484100 $Y=3171200
.ENDS
***************************************
.SUBCKT ADDFX1 B A CI 4 CO VSS VDD S
** N=15 EP=8 IP=0 FDC=30
M0 VSS B 11 VSS n18 L=1.8e-07 W=1.2e-06 $X=6200 $Y=6200 $D=6
M1 9 11 VSS VSS n18 L=1.8e-07 W=8.4e-07 $X=14250 $Y=9800 $D=6
M2 14 10 9 VSS n18 L=1.8e-07 W=6.4e-07 $X=21450 $Y=11800 $D=6
M3 10 9 14 VSS n18 L=1.8e-07 W=4.2e-07 $X=31300 $Y=14000 $D=6
M4 VSS A 10 VSS n18 L=1.8e-07 W=6e-07 $X=38550 $Y=12200 $D=6
M5 10 A VSS VSS n18 L=1.8e-07 W=6e-07 $X=44550 $Y=13600 $D=6
M6 4 11 10 VSS n18 L=1.8e-07 W=4.2e-07 $X=52500 $Y=13700 $D=6
M7 11 10 4 VSS n18 L=1.8e-07 W=6.4e-07 $X=60400 $Y=11500 $D=6
M8 13 4 11 VSS n18 L=1.8e-07 W=4.2e-07 $X=72850 $Y=15450 $D=6
M9 12 14 13 VSS n18 L=1.8e-07 W=4.2e-07 $X=80050 $Y=15450 $D=6
M10 VSS CI 12 VSS n18 L=1.8e-07 W=4.2e-07 $X=87650 $Y=10800 $D=6
M11 15 CI 14 VSS n18 L=1.8e-07 W=4.2e-07 $X=101150 $Y=13050 $D=6
M12 4 12 15 VSS n18 L=1.8e-07 W=4.2e-07 $X=108350 $Y=13050 $D=6
M13 VSS 13 CO VSS n18 L=1.8e-07 W=6e-07 $X=121100 $Y=12200 $D=6
M14 S 15 VSS VSS n18 L=1.8e-07 W=6e-07 $X=129500 $Y=12200 $D=6
M15 VDD B 11 VDD p18 L=1.82027e-07 W=1.79314e-06 $X=5400 $Y=33800 $D=10
M16 9 11 VDD VDD p18 L=1.8e-07 W=1.26e-06 $X=12250 $Y=27100 $D=10
M17 4 10 9 VDD p18 L=1.8e-07 W=9.6e-07 $X=20450 $Y=27200 $D=10
M18 10 9 4 VDD p18 L=1.8e-07 W=6.4e-07 $X=30900 $Y=28200 $D=10
M19 VDD A 10 VDD p18 L=1.8e-07 W=9e-07 $X=40550 $Y=29000 $D=10
M20 10 A VDD VDD p18 L=1.8e-07 W=9e-07 $X=47350 $Y=29000 $D=10
M21 14 11 10 VDD p18 L=1.8e-07 W=6.4e-07 $X=54550 $Y=29200 $D=10
M22 11 10 14 VDD p18 L=1.8e-07 W=9.6e-07 $X=61750 $Y=31000 $D=10
M23 13 14 11 VDD p18 L=1.8e-07 W=6.4e-07 $X=68950 $Y=32650 $D=10
M24 12 4 13 VDD p18 L=1.8e-07 W=6.4e-07 $X=76150 $Y=32650 $D=10
M25 VDD CI 12 VDD p18 L=1.8e-07 W=6.4e-07 $X=84750 $Y=33800 $D=10
M26 15 12 14 VDD p18 L=1.8e-07 W=6.4e-07 $X=98350 $Y=30800 $D=10
M27 4 CI 15 VDD p18 L=1.8e-07 W=6.4e-07 $X=105550 $Y=30800 $D=10
M28 VDD 13 CO VDD p18 L=1.8e-07 W=9e-07 $X=120950 $Y=27550 $D=10
M29 S 15 VDD VDD p18 L=1.8e-07 W=9e-07 $X=129500 $Y=27550 $D=10
.ENDS
***************************************
.SUBCKT AND2X4 A B VSS VDD Y
** N=7 EP=5 IP=0 FDC=8
M0 7 A 6 VSS n18 L=1.85215e-07 W=1.30713e-06 $X=4700 $Y=5750 $D=6
M1 VSS B 7 VSS n18 L=1.90638e-07 W=1.30299e-06 $X=10600 $Y=5750 $D=6
M2 Y 6 VSS VSS n18 L=1.85791e-07 W=1.17713e-06 $X=17800 $Y=12250 $D=6
M3 VSS 6 Y VSS n18 L=1.85791e-07 W=1.17713e-06 $X=24900 $Y=7050 $D=6
M4 6 A VDD VDD p18 L=1.8e-07 W=1.2e-06 $X=4600 $Y=27750 $D=10
M5 VDD B 6 VDD p18 L=1.8e-07 W=1.2e-06 $X=11800 $Y=27750 $D=10
M6 Y 6 VDD VDD p18 L=1.83772e-07 W=1.80713e-06 $X=17800 $Y=27250 $D=10
M7 VDD 6 Y VDD p18 L=1.83772e-07 W=1.80713e-06 $X=24900 $Y=35000 $D=10
.ENDS
***************************************
.SUBCKT CLKBUFX8 A VSS Y VDD
** N=5 EP=4 IP=0 FDC=10
M0 VSS A 5 VSS n18 L=1.8e-07 W=9.6e-07 $X=13400 $Y=5700 $D=6
M1 Y 5 VSS VSS n18 L=1.83022e-07 W=1.20314e-06 $X=19800 $Y=12200 $D=6
M2 VSS 5 Y VSS n18 L=1.83022e-07 W=1.20314e-06 $X=26200 $Y=5700 $D=6
M3 Y 5 VSS VSS n18 L=1.8e-07 W=4.8e-07 $X=33800 $Y=12600 $D=6
M4 5 A VDD VDD p18 L=1.83034e-07 W=1.19814e-06 $X=5400 $Y=27000 $D=10
M5 VDD A 5 VDD p18 L=1.83034e-07 W=1.19814e-06 $X=11800 $Y=32500 $D=10
M6 Y 5 VDD VDD p18 L=1.82016e-07 W=1.80314e-06 $X=19000 $Y=27000 $D=10
M7 VDD 5 Y VDD p18 L=1.82016e-07 W=1.80314e-06 $X=25400 $Y=34600 $D=10
M8 Y 5 VDD VDD p18 L=1.82016e-07 W=1.80314e-06 $X=31800 $Y=27000 $D=10
M9 VDD 5 Y VDD p18 L=1.82016e-07 W=1.80314e-06 $X=38200 $Y=34600 $D=10
.ENDS
***************************************
.SUBCKT BUFX8 A VDD VSS Y
** N=5 EP=4 IP=0 FDC=12
M0 5 A VSS VSS n18 L=1.8e-07 W=9.6e-07 $X=6200 $Y=5700 $D=6
M1 VSS A 5 VSS n18 L=1.8e-07 W=9.6e-07 $X=13400 $Y=5700 $D=6
M2 Y 5 VSS VSS n18 L=1.83022e-07 W=1.20314e-06 $X=19800 $Y=12200 $D=6
M3 VSS 5 Y VSS n18 L=1.83022e-07 W=1.20314e-06 $X=26200 $Y=5700 $D=6
M4 Y 5 VSS VSS n18 L=1.83022e-07 W=1.20314e-06 $X=32600 $Y=12200 $D=6
M5 VSS 5 Y VSS n18 L=1.83022e-07 W=1.20314e-06 $X=39000 $Y=5700 $D=6
M6 5 A VDD VDD p18 L=1.82563e-07 W=1.41814e-06 $X=6200 $Y=27000 $D=10
M7 VDD A 5 VDD p18 L=1.82563e-07 W=1.41814e-06 $X=12600 $Y=32500 $D=10
M8 Y 5 VDD VDD p18 L=1.82016e-07 W=1.80314e-06 $X=19000 $Y=27000 $D=10
M9 VDD 5 Y VDD p18 L=1.82016e-07 W=1.80314e-06 $X=25400 $Y=34600 $D=10
M10 Y 5 VDD VDD p18 L=1.82016e-07 W=1.80314e-06 $X=31800 $Y=27000 $D=10
M11 VDD 5 Y VDD p18 L=1.82016e-07 W=1.80314e-06 $X=38200 $Y=34600 $D=10
.ENDS
***************************************
.SUBCKT BUFX12 A Y VSS VDD
** N=5 EP=4 IP=0 FDC=18
M0 VSS A 5 VSS n18 L=1.8e-07 W=4.2e-07 $X=6200 $Y=13100 $D=6
M1 5 A VSS VSS n18 L=1.83022e-07 W=1.20314e-06 $X=12600 $Y=10700 $D=6
M2 VSS A 5 VSS n18 L=1.83022e-07 W=1.20314e-06 $X=19000 $Y=5700 $D=6
M3 Y 5 VSS VSS n18 L=1.83022e-07 W=1.20314e-06 $X=25400 $Y=12200 $D=6
M4 VSS 5 Y VSS n18 L=1.83022e-07 W=1.20314e-06 $X=31800 $Y=5700 $D=6
M5 Y 5 VSS VSS n18 L=1.83022e-07 W=1.20314e-06 $X=38200 $Y=12200 $D=6
M6 VSS 5 Y VSS n18 L=1.83022e-07 W=1.20314e-06 $X=44600 $Y=5700 $D=6
M7 Y 5 VSS VSS n18 L=1.83022e-07 W=1.20314e-06 $X=51000 $Y=12200 $D=6
M8 VSS 5 Y VSS n18 L=1.83022e-07 W=1.20314e-06 $X=57400 $Y=5700 $D=6
M9 VDD A 5 VDD p18 L=1.82563e-07 W=1.41814e-06 $X=5400 $Y=32500 $D=10
M10 5 A VDD VDD p18 L=1.82563e-07 W=1.41814e-06 $X=11800 $Y=27000 $D=10
M11 VDD A 5 VDD p18 L=1.82563e-07 W=1.41814e-06 $X=18200 $Y=32500 $D=10
M12 Y 5 VDD VDD p18 L=1.82016e-07 W=1.80314e-06 $X=24600 $Y=27000 $D=10
M13 VDD 5 Y VDD p18 L=1.82016e-07 W=1.80314e-06 $X=31000 $Y=34600 $D=10
M14 Y 5 VDD VDD p18 L=1.82016e-07 W=1.80314e-06 $X=37400 $Y=27000 $D=10
M15 VDD 5 Y VDD p18 L=1.82016e-07 W=1.80314e-06 $X=43800 $Y=34600 $D=10
M16 Y 5 VDD VDD p18 L=1.82016e-07 W=1.80314e-06 $X=51200 $Y=27000 $D=10
M17 VDD 5 Y VDD p18 L=1.82016e-07 W=1.80314e-06 $X=57600 $Y=34600 $D=10
.ENDS
***************************************
.SUBCKT BUFX16 A Y VSS VDD
** N=5 EP=4 IP=0 FDC=23
M0 VSS A 5 VSS n18 L=1.82889e-07 W=1.25814e-06 $X=5400 $Y=5700 $D=6
M1 5 A VSS VSS n18 L=1.82889e-07 W=1.25814e-06 $X=11800 $Y=12750 $D=6
M2 VSS A 5 VSS n18 L=1.82889e-07 W=1.25814e-06 $X=18200 $Y=5700 $D=6
M3 Y 5 VSS VSS n18 L=1.83009e-07 W=1.20814e-06 $X=25000 $Y=12250 $D=6
M4 VSS 5 Y VSS n18 L=1.83009e-07 W=1.20814e-06 $X=31400 $Y=5700 $D=6
M5 Y 5 VSS VSS n18 L=1.83009e-07 W=1.20814e-06 $X=37800 $Y=12250 $D=6
M6 VSS 5 Y VSS n18 L=1.83009e-07 W=1.20814e-06 $X=44200 $Y=5700 $D=6
M7 Y 5 VSS VSS n18 L=1.83009e-07 W=1.20814e-06 $X=50600 $Y=12250 $D=6
M8 VSS 5 Y VSS n18 L=1.83009e-07 W=1.20814e-06 $X=57000 $Y=5700 $D=6
M9 Y 5 VSS VSS n18 L=1.83009e-07 W=1.20814e-06 $X=64200 $Y=12250 $D=6
M10 VSS 5 Y VSS n18 L=1.83009e-07 W=1.20814e-06 $X=70600 $Y=5700 $D=6
M11 5 A VDD VDD p18 L=1.82563e-07 W=1.41814e-06 $X=5400 $Y=27000 $D=10
M12 VDD A 5 VDD p18 L=1.82563e-07 W=1.41814e-06 $X=11800 $Y=32500 $D=10
M13 5 A VDD VDD p18 L=1.82546e-07 W=1.42814e-06 $X=18200 $Y=27000 $D=10
M14 VDD A 5 VDD p18 L=1.82546e-07 W=1.42814e-06 $X=24600 $Y=32500 $D=10
M15 Y 5 VDD VDD p18 L=1.82016e-07 W=1.80314e-06 $X=31400 $Y=27000 $D=10
M16 VDD 5 Y VDD p18 L=1.82016e-07 W=1.80314e-06 $X=37800 $Y=34600 $D=10
M17 Y 5 VDD VDD p18 L=1.82016e-07 W=1.80314e-06 $X=44200 $Y=27000 $D=10
M18 VDD 5 Y VDD p18 L=1.82016e-07 W=1.80314e-06 $X=50600 $Y=34600 $D=10
M19 Y 5 VDD VDD p18 L=1.82016e-07 W=1.80314e-06 $X=57000 $Y=27000 $D=10
M20 VDD 5 Y VDD p18 L=1.82016e-07 W=1.80314e-06 $X=63800 $Y=34600 $D=10
M21 Y 5 VDD VDD p18 L=1.82016e-07 W=1.80314e-06 $X=71000 $Y=27000 $D=10
M22 VDD 5 Y VDD p18 L=1.82016e-07 W=1.80314e-06 $X=77400 $Y=34600 $D=10
.ENDS
***************************************
.SUBCKT AOI211X1 A1 VDD A0 C0 VSS B0 Y
** N=10 EP=7 IP=0 FDC=8
M0 9 A1 VSS VSS n18 L=1.8e-07 W=8e-07 $X=6200 $Y=6750 $D=6
M1 Y A0 9 VSS n18 L=1.8e-07 W=8e-07 $X=11800 $Y=6750 $D=6
M2 VSS C0 Y VSS n18 L=1.8e-07 W=6e-07 $X=19000 $Y=10550 $D=6
M3 Y B0 VSS VSS n18 L=1.8e-07 W=6e-07 $X=25000 $Y=10550 $D=6
M4 VDD A1 8 VDD p18 L=1.82563e-07 W=1.41814e-06 $X=5400 $Y=35100 $D=10
M5 8 A0 VDD VDD p18 L=1.82563e-07 W=1.41814e-06 $X=11800 $Y=27500 $D=10
M6 10 C0 8 VDD p18 L=1.8e-07 W=1.4e-06 $X=19000 $Y=27350 $D=10
M7 Y B0 10 VDD p18 L=1.8e-07 W=1.4e-06 $X=24600 $Y=27350 $D=10
.ENDS
***************************************
.SUBCKT INVX3 A VSS VDD Y
** N=4 EP=4 IP=0 FDC=4
M0 VSS A Y VSS n18 L=1.8e-07 W=1e-06 $X=6250 $Y=8200 $D=6
M1 Y A VSS VSS n18 L=1.8e-07 W=8e-07 $X=12250 $Y=10200 $D=6
M2 VDD A Y VDD p18 L=1.8e-07 W=1.4e-06 $X=6250 $Y=27200 $D=10
M3 Y A VDD VDD p18 L=1.8e-07 W=1.3e-06 $X=12250 $Y=27200 $D=10
.ENDS
***************************************
.SUBCKT ICV_4 4 5 6 8 9 12 13 14 15 16 17 18 19 20 21 22 23 24 25 26
+ 27 28 29 30 32 33 34 35 36 39 41 42 43 45 48 49 50 51 52 53
+ 54 55 58 59 60 61 62 63 65 66 67 68 69 70 71 72 73 74 75 76
+ 77 78 80 81 82 83 85 86 87 90 91 93 94 97 98 99 102 103 104 105
+ 106 107 108 109 110 111 112 113 114 115 116 119 120 121 122 123 124 125 126 127
+ 128 129 131 132 133 134 135 137 138 139 140 142 143 144 145 146 147 148 149 150
+ 151 152 155 156 157 158 159 160 161 162 163 164 165 166 167 168 169 170 171 172
+ 174 175 176 177 178 179 180 181 184 185 187 190 191 192 193 195 196 198 199 200
+ 204 207 208 210 211 212 213 214 215 216 219 220 221 222 223 224 225 228 229 230
+ 232 238 239 240 243 244 245 246 253 255 258 259 261 266 267 269 270 271 272 273
+ 274 275 276 277 278 279 280 281 282 283 284 285 286 287 288 289 290 291 292 293
+ 294 295 296 297 298 299 300 301 302 303 304 305 306 307 308 309 310 311 312 313
+ 314 315 316 317 318 319 320 321 322 323 324 325 326 327 328 329 330 331 332 333
+ 334 335 336 337 338 339 340 341 342 343 344 345 346 347 348 349 350 351 352 353
+ 354 355 356 357 358 359 360 361 362 363 364 365 366 367 368 369 370 371 372 373
+ 374 376 377 378 379 380 381 382 383 384 385 386 387 388 389 390 391 392 393 394
+ 395 396 397 398 399 400 401 402 403 404 405 406 407 408 409 410 411 412 413 414
+ 415 416 417 418 419 420 421 422 423 424 425 426 427 428 429 430 431 432 433 434
+ 435 436 437 438 439 440
*.CALIBRE ICV_CELL 2
** N=1512 EP=366 IP=3610 FDC=8500
M0 1496 60 354 354 n18 L=1.8e-07 W=5.6e-07 $X=989600 $Y=2979300 $D=6
M1 535 72 1496 354 n18 L=1.8e-07 W=5.6e-07 $X=995200 $Y=2979300 $D=6
M2 1497 72 535 354 n18 L=1.8e-07 W=5.6e-07 $X=1002400 $Y=2979300 $D=6
M3 354 72 1497 354 n18 L=1.8e-07 W=5.6e-07 $X=1008000 $Y=2979300 $D=6
M4 535 533 354 354 n18 L=1.8e-07 W=4.2e-07 $X=1016350 $Y=2982550 $D=6
M5 354 157 835 354 n18 L=1.8e-07 W=5.6e-07 $X=2185900 $Y=2855950 $D=6
M6 1498 590 354 354 n18 L=1.8e-07 W=3.6e-07 $X=2191900 $Y=2858600 $D=6
M7 833 835 1498 354 n18 L=1.8e-07 W=3.6e-07 $X=2197500 $Y=2858600 $D=6
M8 1499 836 833 354 n18 L=1.8e-07 W=3e-07 $X=2205500 $Y=2858600 $D=6
M9 354 834 1499 354 n18 L=1.8e-07 W=3e-07 $X=2211100 $Y=2858600 $D=6
M10 1500 307 354 354 n18 L=1.8e-07 W=5.4e-07 $X=2218700 $Y=2858500 $D=6
M11 834 833 1500 354 n18 L=1.8e-07 W=5.4e-07 $X=2224300 $Y=2858500 $D=6
M12 354 835 836 354 n18 L=1.8e-07 W=4e-07 $X=2240300 $Y=2857500 $D=6
M13 1501 834 354 354 n18 L=1.8e-07 W=6e-07 $X=2247900 $Y=2857400 $D=6
M14 837 836 1501 354 n18 L=1.8e-07 W=6e-07 $X=2253500 $Y=2857400 $D=6
M15 1502 836 837 354 n18 L=1.8e-07 W=6e-07 $X=2260700 $Y=2857400 $D=6
M16 354 834 1502 354 n18 L=1.8e-07 W=6e-07 $X=2266300 $Y=2857400 $D=6
M17 1503 835 837 354 n18 L=1.8e-07 W=3e-07 $X=2281000 $Y=2854700 $D=6
M18 354 838 1503 354 n18 L=1.8e-07 W=3e-07 $X=2287800 $Y=2854700 $D=6
M19 1504 307 354 354 n18 L=1.8e-07 W=9.4e-07 $X=2293800 $Y=2856400 $D=6
M20 838 837 1504 354 n18 L=1.8e-07 W=9.4e-07 $X=2299400 $Y=2856400 $D=6
M21 1505 837 838 354 n18 L=1.8e-07 W=9.4e-07 $X=2306600 $Y=2856400 $D=6
M22 354 307 1505 354 n18 L=1.8e-07 W=9.4e-07 $X=2312200 $Y=2856400 $D=6
M23 839 838 354 354 n18 L=1.8e-07 W=9.6e-07 $X=2319400 $Y=2856200 $D=6
M24 305 838 354 354 n18 L=1.8e-07 W=1.2e-06 $X=2332400 $Y=2855100 $D=6
M25 354 838 305 354 n18 L=1.8e-07 W=1.2e-06 $X=2339600 $Y=2855100 $D=6
M26 29 839 354 354 n18 L=1.8e-07 W=1.2e-06 $X=2346800 $Y=2855100 $D=6
M27 354 839 29 354 n18 L=1.8e-07 W=1.2e-06 $X=2354000 $Y=2855100 $D=6
M28 354 792 840 354 n18 L=1.8e-07 W=9.6e-07 $X=2857400 $Y=2677300 $D=6
M29 840 191 354 354 n18 L=1.8e-07 W=9.6e-07 $X=2865400 $Y=2677300 $D=6
M30 1506 614 840 354 n18 L=1.8e-07 W=9.6e-07 $X=2872600 $Y=2677300 $D=6
M31 192 614 1506 354 n18 L=1.8e-07 W=9.4e-07 $X=2878600 $Y=2680200 $D=6
M32 826 60 23 23 p18 L=1.8e-07 W=1e-06 $X=988000 $Y=3003800 $D=10
M33 23 72 826 23 p18 L=1.8e-07 W=1e-06 $X=995200 $Y=3003800 $D=10
M34 826 72 825 23 p18 L=1.8e-07 W=1e-06 $X=1006200 $Y=3000900 $D=10
M35 825 72 826 23 p18 L=1.8e-07 W=1e-06 $X=1013400 $Y=3000900 $D=10
M36 535 533 825 23 p18 L=1.8e-07 W=1e-06 $X=1019400 $Y=3000900 $D=10
M37 23 157 835 23 p18 L=1.8e-07 W=8.4e-07 $X=2185100 $Y=2836600 $D=10
M38 1507 590 23 23 p18 L=1.8e-07 W=5.4e-07 $X=2192000 $Y=2839600 $D=10
M39 833 836 1507 23 p18 L=1.8e-07 W=5.4e-07 $X=2197600 $Y=2839600 $D=10
M40 1508 835 833 23 p18 L=1.8e-07 W=4.2e-07 $X=2205600 $Y=2839400 $D=10
M41 23 834 1508 23 p18 L=1.8e-07 W=4.2e-07 $X=2211200 $Y=2839400 $D=10
M42 834 307 23 23 p18 L=1.8e-07 W=6.2e-07 $X=2219700 $Y=2837400 $D=10
M43 23 833 834 23 p18 L=1.8e-07 W=6.2e-07 $X=2226900 $Y=2837400 $D=10
M44 836 835 23 23 p18 L=1.8e-07 W=6e-07 $X=2232900 $Y=2837600 $D=10
M45 1509 834 23 23 p18 L=1.8e-07 W=9e-07 $X=2246300 $Y=2835600 $D=10
M46 837 835 1509 23 p18 L=1.8e-07 W=9e-07 $X=2251900 $Y=2835600 $D=10
M47 1510 835 837 23 p18 L=1.8e-07 W=9e-07 $X=2259100 $Y=2835600 $D=10
M48 23 834 1510 23 p18 L=1.8e-07 W=9e-07 $X=2264700 $Y=2835600 $D=10
M49 1511 836 837 23 p18 L=1.8e-07 W=3e-07 $X=2278200 $Y=2841200 $D=10
M50 23 838 1511 23 p18 L=1.8e-07 W=3e-07 $X=2283800 $Y=2841200 $D=10
M51 838 307 23 23 p18 L=1.8e-07 W=1.06e-06 $X=2289800 $Y=2833600 $D=10
M52 23 837 838 23 p18 L=1.8e-07 W=1.06e-06 $X=2297000 $Y=2833600 $D=10
M53 838 837 23 23 p18 L=1.8e-07 W=1.06e-06 $X=2304200 $Y=2833600 $D=10
M54 23 307 838 23 p18 L=1.8e-07 W=1.06e-06 $X=2311400 $Y=2833600 $D=10
M55 839 838 23 23 p18 L=1.8e-07 W=1.44e-06 $X=2318600 $Y=2829800 $D=10
M56 305 838 23 23 p18 L=1.8e-07 W=1.8e-06 $X=2331200 $Y=2828100 $D=10
M57 23 838 305 23 p18 L=1.8e-07 W=1.8e-06 $X=2338400 $Y=2828100 $D=10
M58 29 839 23 23 p18 L=1.8e-07 W=1.76e-06 $X=2345600 $Y=2828100 $D=10
M59 23 839 29 23 p18 L=1.8e-07 W=1.76e-06 $X=2352800 $Y=2828100 $D=10
M60 1512 792 23 23 p18 L=1.8e-07 W=1.2e-06 $X=2857400 $Y=2700400 $D=10
M61 192 191 1512 23 p18 L=1.8e-07 W=1.2e-06 $X=2863800 $Y=2700400 $D=10
M62 23 614 192 23 p18 L=1.8e-07 W=9e-07 $X=2871000 $Y=2703400 $D=10
M63 192 614 23 23 p18 L=1.8e-07 W=9e-07 $X=2879000 $Y=2703400 $D=10
X64 447 354 23 48 358 NAND2XL $T=396000 2973600 0 0 $X=391700 $Y=2969600
X65 499 354 23 66 510 NAND2XL $T=514800 2872800 1 0 $X=510500 $Y=2817000
X66 52 354 23 63 277 NAND2XL $T=613800 2772000 1 180 $X=589700 $Y=2768000
X67 281 354 23 280 450 NAND2XL $T=693000 2570400 1 180 $X=668900 $Y=2566400
X68 530 354 23 63 541 NAND2XL $T=910800 2772000 1 0 $X=906500 $Y=2716200
X69 779 354 23 66 543 NAND2XL $T=970200 2772000 0 0 $X=965900 $Y=2768000
X70 552 354 23 72 377 NAND2XL $T=1280400 2570400 1 0 $X=1276100 $Y=2514600
X71 828 354 23 72 454 NAND2XL $T=1313400 2973600 1 0 $X=1309100 $Y=2917800
X72 829 354 23 558 378 NAND2XL $T=1339800 2570400 0 180 $X=1315700 $Y=2514600
X73 388 354 23 301 551 NAND2XL $T=1854600 2973600 1 180 $X=1830500 $Y=2969600
X74 389 354 23 301 578 NAND2XL $T=1874400 2570400 1 0 $X=1870100 $Y=2514600
X75 576 354 23 301 306 NAND2XL $T=1874400 2973600 1 0 $X=1870100 $Y=2917800
X76 391 354 23 301 577 NAND2XL $T=1900800 2973600 1 180 $X=1876700 $Y=2969600
X77 603 354 23 179 592 NAND2XL $T=2626800 2671200 1 180 $X=2602700 $Y=2667200
X78 791 354 23 179 590 NAND2XL $T=2673000 2772000 1 180 $X=2648900 $Y=2768000
X79 608 354 23 404 609 NAND2XL $T=2765400 2570400 0 0 $X=2761100 $Y=2566400
X80 204 354 23 321 614 NAND2XL $T=2824800 2570400 1 180 $X=2800700 $Y=2566400
X81 617 354 23 179 613 NAND2XL $T=2851200 2872800 0 180 $X=2827100 $Y=2817000
X82 615 354 23 618 405 NAND2XL $T=2857800 3074400 0 180 $X=2833700 $Y=3018600
X83 614 354 23 457 620 NAND2XL $T=2844600 2671200 1 0 $X=2840300 $Y=2615400
X84 457 354 23 621 792 NAND2XL $T=2877600 2772000 0 180 $X=2853500 $Y=2716200
X85 676 354 23 179 607 NAND2XL $T=2877600 2973600 0 180 $X=2853500 $Y=2917800
X86 619 354 23 193 793 NAND2XL $T=2871000 2570400 1 0 $X=2866700 $Y=2514600
X87 623 354 23 179 610 NAND2XL $T=2871000 2772000 0 0 $X=2866700 $Y=2768000
X88 476 354 23 179 605 NAND2XL $T=2871000 2872800 1 0 $X=2866700 $Y=2817000
X89 625 354 23 179 185 NAND2XL $T=2897400 2872800 1 180 $X=2873300 $Y=2868800
X90 627 354 23 179 622 NAND2XL $T=2904000 2973600 0 180 $X=2879900 $Y=2917800
X91 323 354 23 456 615 NAND2XL $T=2904000 2973600 1 180 $X=2879900 $Y=2969600
X92 457 354 23 626 614 NAND2XL $T=2890800 2671200 1 0 $X=2886500 $Y=2615400
X93 628 354 23 179 599 NAND2XL $T=2910600 2772000 1 180 $X=2886500 $Y=2768000
X94 616 354 23 190 624 NAND2XL $T=2917200 2570400 0 180 $X=2893100 $Y=2514600
X95 464 354 23 461 459 NAND2XL $T=2917200 2872800 0 180 $X=2893100 $Y=2817000
X96 632 354 23 179 612 NAND2XL $T=2923800 2872800 1 180 $X=2899700 $Y=2868800
X97 619 354 23 324 460 NAND2XL $T=2943600 2570400 0 180 $X=2919500 $Y=2514600
X98 624 354 23 619 637 NAND2XL $T=2923800 2570400 0 0 $X=2919500 $Y=2566400
X99 634 354 23 629 641 NAND2XL $T=2923800 3074400 1 0 $X=2919500 $Y=3018600
X100 469 354 23 795 640 NAND2XL $T=2963400 2671200 1 180 $X=2939300 $Y=2667200
X101 640 354 23 466 796 NAND2XL $T=2950200 2772000 1 0 $X=2945900 $Y=2716200
X102 207 354 23 565 469 NAND2XL $T=2996400 2671200 0 180 $X=2972300 $Y=2615400
X103 473 354 23 647 636 NAND2XL $T=3003000 2872800 1 180 $X=2978900 $Y=2868800
X104 198 354 23 644 648 NAND2XL $T=2996400 2570400 1 0 $X=2992100 $Y=2514600
X105 198 354 23 470 407 NAND2XL $T=2996400 2671200 1 0 $X=2992100 $Y=2615400
X106 325 354 23 545 472 NAND2XL $T=2996400 3074400 1 0 $X=2992100 $Y=3018600
X107 198 354 23 645 797 NAND2XL $T=3003000 2872800 0 0 $X=2998700 $Y=2868800
X108 326 354 23 325 650 NAND2XL $T=3016200 3074400 1 0 $X=3011900 $Y=3018600
X109 198 354 23 798 799 NAND2XL $T=3029400 2671200 1 0 $X=3025100 $Y=2615400
X110 586 354 23 652 651 NAND2XL $T=3029400 2872800 1 0 $X=3025100 $Y=2817000
X111 652 354 23 474 473 NAND2XL $T=3062400 2872800 0 0 $X=3058100 $Y=2868800
X112 327 354 23 207 657 NAND2XL $T=3095400 2671200 1 0 $X=3091100 $Y=2615400
X113 653 354 23 328 800 NAND2XL $T=3115200 3074400 0 180 $X=3091100 $Y=3018600
X114 651 354 23 654 802 NAND2XL $T=3102000 2872800 0 0 $X=3097700 $Y=2868800
X115 653 354 23 658 656 NAND2XL $T=3148200 2973600 1 180 $X=3124100 $Y=2969600
X116 650 354 23 653 803 NAND2XL $T=3148200 2973600 0 0 $X=3143900 $Y=2969600
X117 588 354 23 616 668 NAND2XL $T=3168000 2570400 1 0 $X=3163700 $Y=2514600
X118 657 354 23 804 666 NAND2XL $T=3201000 2671200 0 180 $X=3176900 $Y=2615400
X119 668 354 23 669 672 NAND2XL $T=3207600 2570400 0 0 $X=3203300 $Y=2566400
X120 155 354 23 667 673 NAND2XL $T=3207600 2973600 0 0 $X=3203300 $Y=2969600
X121 166 354 23 671 678 NAND2XL $T=3260400 2872800 1 0 $X=3256100 $Y=2817000
X122 673 354 23 675 331 NAND2XL $T=3293400 3074400 1 0 $X=3289100 $Y=3018600
X123 678 354 23 682 688 NAND2XL $T=3300000 2973600 0 0 $X=3295700 $Y=2969600
X124 689 354 23 685 813 NAND2XL $T=3352800 2570400 0 0 $X=3348500 $Y=2566400
X125 813 354 23 221 693 NAND2XL $T=3379200 2570400 0 0 $X=3374900 $Y=2566400
X126 480 354 23 225 681 NAND2XL $T=3412200 2671200 1 180 $X=3388100 $Y=2667200
X127 418 354 23 221 692 NAND2XL $T=3418800 2570400 1 180 $X=3394700 $Y=2566400
X128 479 354 23 225 659 NAND2XL $T=3425400 2772000 0 180 $X=3401300 $Y=2716200
X129 728 354 23 225 649 NAND2XL $T=3425400 2772000 1 180 $X=3401300 $Y=2768000
X130 720 354 23 225 663 NAND2XL $T=3425400 2872800 0 180 $X=3401300 $Y=2817000
X131 336 354 23 225 684 NAND2XL $T=3438600 2872800 1 180 $X=3414500 $Y=2868800
X132 253 354 23 225 477 NAND2XL $T=3445200 2973600 0 180 $X=3421100 $Y=2917800
X133 337 354 23 225 686 NAND2XL $T=3471600 2872800 1 180 $X=3447500 $Y=2868800
X134 339 354 23 225 465 NAND2XL $T=3498000 2973600 0 180 $X=3473900 $Y=2917800
X135 699 354 23 225 662 NAND2XL $T=3504600 2671200 0 180 $X=3480500 $Y=2615400
X136 338 354 23 225 602 NAND2XL $T=3504600 2872800 1 180 $X=3480500 $Y=2868800
X137 698 354 23 225 601 NAND2XL $T=3498000 2570400 0 0 $X=3493700 $Y=2566400
X138 701 354 23 225 680 NAND2XL $T=3531000 2973600 0 180 $X=3506900 $Y=2917800
X139 259 354 23 723 709 NAND2XL $T=3973200 2772000 0 180 $X=3949100 $Y=2716200
X140 259 354 23 729 715 NAND2XL $T=3999600 2772000 0 180 $X=3975500 $Y=2716200
X141 433 354 23 481 482 NAND2XL $T=3999600 2772000 0 0 $X=3995300 $Y=2768000
X142 713 354 23 730 731 NAND2XL $T=4006200 2772000 1 0 $X=4001900 $Y=2716200
X143 727 354 23 702 737 NAND2XL $T=4059000 2570400 1 0 $X=4054700 $Y=2514600
X144 259 354 23 736 718 NAND2XL $T=4078800 2772000 0 180 $X=4054700 $Y=2716200
X145 484 354 23 719 739 NAND2XL $T=4085400 2772000 1 0 $X=4081100 $Y=2716200
X146 259 354 23 741 733 NAND2XL $T=4125000 2671200 1 180 $X=4100900 $Y=2667200
X147 259 354 23 740 721 NAND2XL $T=4125000 2772000 1 180 $X=4100900 $Y=2768000
X148 258 354 23 724 744 NAND2XL $T=4125000 2570400 1 0 $X=4120700 $Y=2514600
X149 726 354 23 725 748 NAND2XL $T=4125000 2973600 1 0 $X=4120700 $Y=2917800
X150 259 354 23 747 717 NAND2XL $T=4151400 2973600 1 180 $X=4127300 $Y=2969600
X151 483 354 23 742 751 NAND2XL $T=4144800 2772000 1 0 $X=4140500 $Y=2716200
X152 259 354 23 486 716 NAND2XL $T=4144800 2872800 1 0 $X=4140500 $Y=2817000
X153 737 354 23 345 437 NAND2XL $T=4158000 2570400 1 0 $X=4153700 $Y=2514600
X154 748 354 23 820 756 NAND2XL $T=4171200 2973600 0 0 $X=4166900 $Y=2969600
X155 750 354 23 738 759 NAND2XL $T=4191000 2671200 0 0 $X=4186700 $Y=2667200
X156 739 354 23 488 763 NAND2XL $T=4210800 2570400 0 0 $X=4206500 $Y=2566400
X157 489 354 23 755 765 NAND2XL $T=4250400 2872800 0 180 $X=4226300 $Y=2817000
X158 439 354 23 768 490 NAND2XL $T=4257000 3074400 1 0 $X=4252700 $Y=3018600
X159 759 354 23 759 764 NAND2XL $T=4276800 2671200 0 0 $X=4272500 $Y=2667200
X160 23 460 459 621 354 NOR2XL $T=2904000 2772000 0 180 $X=2879900 $Y=2716200
X161 23 323 456 458 354 NOR2XL $T=2923800 2973600 1 180 $X=2899700 $Y=2969600
X162 23 620 463 630 354 NOR2XL $T=2910600 2671200 1 0 $X=2906300 $Y=2615400
X163 23 633 458 461 354 NOR2XL $T=2930400 2973600 0 180 $X=2906300 $Y=2917800
X164 23 636 638 639 354 NOR2XL $T=2930400 2872800 0 0 $X=2926100 $Y=2868800
X165 23 637 467 642 354 NOR2XL $T=2943600 2570400 0 0 $X=2939300 $Y=2566400
X166 23 468 471 464 354 NOR2XL $T=3003000 2772000 1 180 $X=2978900 $Y=2768000
X167 23 325 545 633 354 NOR2XL $T=3003000 2973600 0 180 $X=2978900 $Y=2917800
X168 23 207 565 468 354 NOR2XL $T=2989800 2671200 0 0 $X=2985500 $Y=2667200
X169 23 652 474 471 354 NOR2XL $T=3055800 2872800 1 180 $X=3031700 $Y=2868800
X170 23 327 207 661 354 NOR2XL $T=3135000 2671200 1 0 $X=3130700 $Y=2615400
X171 23 666 665 806 354 NOR2XL $T=3174600 2671200 0 0 $X=3170300 $Y=2667200
X172 23 155 667 670 354 NOR2XL $T=3181200 2973600 0 0 $X=3176900 $Y=2969600
X173 23 211 667 808 354 NOR2XL $T=3227400 2973600 0 180 $X=3203300 $Y=2917800
X174 23 166 671 475 354 NOR2XL $T=3214200 2772000 0 0 $X=3209900 $Y=2768000
X175 23 670 475 415 354 NOR2XL $T=3234000 3074400 1 0 $X=3229700 $Y=3018600
X176 23 413 210 414 354 NOR2XL $T=3240600 2570400 1 0 $X=3236300 $Y=2514600
X177 23 211 671 809 354 NOR2XL $T=3313200 2671200 1 180 $X=3289100 $Y=2667200
X178 23 211 416 810 354 NOR2XL $T=3339600 2570400 0 180 $X=3315500 $Y=2514600
X179 23 688 690 691 354 NOR2XL $T=3326400 2973600 0 0 $X=3322100 $Y=2969600
X180 23 211 685 811 354 NOR2XL $T=3333000 2671200 1 0 $X=3328700 $Y=2615400
X181 23 433 481 743 354 NOR2XL $T=3979800 2872800 1 0 $X=3975500 $Y=2817000
X182 23 713 730 734 354 NOR2XL $T=4032600 2772000 1 0 $X=4028300 $Y=2716200
X183 23 258 724 758 354 NOR2XL $T=4111800 2570400 0 0 $X=4107500 $Y=2566400
X184 23 726 725 749 354 NOR2XL $T=4111800 2973600 0 0 $X=4107500 $Y=2969600
X185 23 483 742 745 354 NOR2XL $T=4118400 2772000 1 0 $X=4114100 $Y=2716200
X186 23 484 719 487 354 NOR2XL $T=4131600 2671200 0 0 $X=4127300 $Y=2667200
X187 23 750 738 761 354 NOR2XL $T=4158000 2671200 0 0 $X=4153700 $Y=2667200
X188 23 734 743 755 354 NOR2XL $T=4171200 2872800 1 0 $X=4166900 $Y=2817000
X189 23 745 761 489 354 NOR2XL $T=4210800 2772000 1 0 $X=4206500 $Y=2716200
X190 23 346 749 768 354 NOR2XL $T=4217400 3074400 1 0 $X=4213100 $Y=3018600
X191 23 758 487 438 354 NOR2XL $T=4224000 2570400 1 0 $X=4219700 $Y=2514600
X192 23 490 765 769 354 NOR2XL $T=4296600 2872800 1 180 $X=4272500 $Y=2868800
X193 534 23 354 544 INVXL $T=996600 2973600 1 0 $X=992300 $Y=2917800
X194 288 23 354 565 INVXL $T=1399200 2570400 0 0 $X=1394900 $Y=2566400
X195 458 23 354 618 INVXL $T=2871000 3074400 0 180 $X=2853500 $Y=3018600
X196 459 23 354 794 INVXL $T=2910600 2772000 0 0 $X=2906300 $Y=2768000
X197 468 23 354 795 INVXL $T=2976600 2671200 1 180 $X=2959100 $Y=2667200
X198 462 23 354 635 INVXL $T=2970000 2772000 0 0 $X=2965700 $Y=2768000
X199 471 23 354 647 INVXL $T=3029400 2872800 0 180 $X=3011900 $Y=2817000
X200 651 23 354 801 INVXL $T=3088800 2872800 1 0 $X=3084500 $Y=2817000
X201 410 23 354 658 INVXL $T=3121800 3074400 1 0 $X=3117500 $Y=3018600
X202 661 23 354 804 INVXL $T=3168000 2671200 1 0 $X=3163700 $Y=2615400
X203 668 23 354 807 INVXL $T=3227400 2570400 0 0 $X=3223100 $Y=2566400
X204 670 23 354 675 INVXL $T=3227400 2973600 0 0 $X=3223100 $Y=2969600
X205 475 23 354 682 INVXL $T=3280200 2973600 0 0 $X=3275900 $Y=2969600
X206 673 23 354 683 INVXL $T=3280200 3074400 1 0 $X=3275900 $Y=3018600
X207 737 23 354 435 INVXL $T=4144800 2570400 1 0 $X=4140500 $Y=2514600
X208 748 23 354 819 INVXL $T=4158000 2973600 1 0 $X=4153700 $Y=2917800
X209 749 23 354 820 INVXL $T=4158000 2973600 0 0 $X=4153700 $Y=2969600
X210 487 23 354 488 INVXL $T=4177800 2671200 0 0 $X=4173500 $Y=2667200
X211 261 23 354 754 INVXL $T=4177800 2872800 0 0 $X=4173500 $Y=2868800
X212 761 23 354 759 INVXL $T=4230600 2772000 1 0 $X=4226300 $Y=2716200
X213 759 23 354 823 INVXL $T=4243800 2772000 1 0 $X=4239500 $Y=2716200
X214 760 23 354 766 INVXL $T=4243800 2973600 1 0 $X=4239500 $Y=2917800
X215 615 354 633 472 23 631 OAI21XL $T=2937000 2973600 1 0 $X=2932700 $Y=2917800
X216 471 354 638 473 23 466 OAI21XL $T=2996400 2872800 0 180 $X=2965700 $Y=2817000
X217 640 354 466 796 23 470 OAI21XL $T=3003000 2772000 0 180 $X=2972300 $Y=2716200
X218 473 354 468 469 23 643 OAI21XL $T=3036000 2772000 1 180 $X=3005300 $Y=2768000
X219 661 354 665 657 23 214 OAI21XL $T=3214200 2671200 1 0 $X=3209900 $Y=2615400
X220 673 354 475 678 23 330 OAI21XL $T=3253800 2973600 0 0 $X=3249500 $Y=2969600
X221 223 354 812 679 23 219 OAI21XL $T=3372600 2671200 1 180 $X=3341900 $Y=2667200
X222 331 354 332 333 23 814 OAI21XL $T=3372600 3074400 1 0 $X=3368300 $Y=3018600
X223 223 354 694 687 23 334 OAI21XL $T=3412200 2671200 0 180 $X=3381500 $Y=2615400
X224 223 354 814 677 23 696 OAI21XL $T=3392400 2973600 0 0 $X=3388100 $Y=2969600
X225 743 354 754 482 23 735 OAI21XL $T=4125000 2872800 0 180 $X=4094300 $Y=2817000
X226 482 354 734 731 23 752 OAI21XL $T=4138200 2772000 0 0 $X=4133900 $Y=2768000
X227 739 354 758 744 23 348 OAI21XL $T=4210800 2570400 1 180 $X=4180100 $Y=2566400
X228 759 354 745 751 23 753 OAI21XL $T=4210800 2772000 0 180 $X=4180100 $Y=2716200
X229 748 354 346 347 23 436 OAI21XL $T=4184400 3074400 1 0 $X=4180100 $Y=3018600
X230 765 354 754 770 23 760 OAI21XL $T=4237200 2973600 0 180 $X=4206500 $Y=2917800
X231 490 354 770 267 23 822 OAI21XL $T=4290000 2973600 0 180 $X=4259300 $Y=2917800
X232 538 48 23 540 841 354 780 AOI21XL $T=950400 2973600 1 0 $X=946100 $Y=2917800
X233 621 195 23 626 842 354 463 AOI21XL $T=2910600 2671200 0 0 $X=2906300 $Y=2667200
X234 794 195 23 635 843 354 196 AOI21XL $T=2917200 2772000 1 0 $X=2912900 $Y=2716200
X235 620 463 23 630 844 354 798 AOI21XL $T=2937000 2671200 1 0 $X=2932700 $Y=2615400
X236 631 464 23 643 845 354 462 AOI21XL $T=2937000 2772000 0 0 $X=2932700 $Y=2768000
X237 461 195 23 631 846 354 638 AOI21XL $T=2937000 2872800 1 0 $X=2932700 $Y=2817000
X238 324 406 23 193 847 354 467 AOI21XL $T=2950200 2570400 1 0 $X=2945900 $Y=2514600
X239 636 638 23 639 848 354 645 AOI21XL $T=2956800 2872800 0 0 $X=2952500 $Y=2868800
X240 637 467 23 642 849 354 644 AOI21XL $T=3003000 2570400 1 180 $X=2972300 $Y=2566400
X241 654 655 23 801 850 354 665 AOI21XL $T=3088800 2772000 0 0 $X=3084500 $Y=2768000
X242 328 329 23 658 851 354 805 AOI21XL $T=3135000 3074400 1 0 $X=3130700 $Y=3018600
X243 669 212 23 807 852 354 210 AOI21XL $T=3194400 2570400 1 0 $X=3190100 $Y=2514600
X244 666 665 23 806 853 354 671 AOI21XL $T=3207600 2671200 0 0 $X=3203300 $Y=2667200
X245 675 332 23 683 854 354 690 AOI21XL $T=3326400 3074400 1 0 $X=3322100 $Y=3018600
X246 688 690 23 691 855 354 812 AOI21XL $T=3379200 2973600 1 180 $X=3348500 $Y=2969600
X247 259 722 23 255 856 354 815 AOI21XL $T=3927000 2872800 1 180 $X=3896300 $Y=2868800
X248 820 760 23 819 857 354 746 AOI21XL $T=4197600 2973600 0 180 $X=4166900 $Y=2917800
X249 752 489 23 753 858 354 770 AOI21XL $T=4230600 2772000 1 180 $X=4199900 $Y=2768000
X250 438 350 23 348 859 354 349 AOI21XL $T=4250400 2570400 1 0 $X=4246100 $Y=2514600
X251 261 769 23 822 860 354 266 AOI21XL $T=4250400 2872800 0 0 $X=4246100 $Y=2868800
X252 759 767 23 823 861 354 821 AOI21XL $T=4263600 2772000 1 0 $X=4259300 $Y=2716200
X253 270 14 863 862 19 864 492 354 865 23 DFFSXL $T=0 2772000 0 0 $X=-4300 $Y=2768000
X254 270 20 867 866 19 868 15 354 869 23 DFFSXL $T=6600 2671200 0 0 $X=2300 $Y=2667200
X255 270 76 871 870 19 872 493 354 873 23 DFFSXL $T=6600 2872800 1 0 $X=2300 $Y=2817000
X256 49 17 17 874 19 875 495 354 876 23 DFFSXL $T=112200 2973600 1 0 $X=107900 $Y=2917800
X257 270 16 878 877 19 879 355 354 880 23 DFFSXL $T=145200 2570400 0 0 $X=140900 $Y=2566400
X258 27 272 882 881 19 883 499 354 884 23 DFFSXL $T=145200 2772000 1 0 $X=140900 $Y=2716200
X259 6 12 886 885 352 887 447 354 888 23 DFFSXL $T=270600 2570400 1 0 $X=266300 $Y=2514600
X260 30 76 890 889 19 891 505 354 892 23 DFFSXL $T=323400 2973600 1 0 $X=319100 $Y=2917800
X261 27 16 894 893 19 895 773 354 896 23 DFFSXL $T=336600 2872800 0 0 $X=332300 $Y=2868800
X262 6 36 898 897 279 899 43 354 900 23 DFFSXL $T=402600 2570400 0 0 $X=398300 $Y=2566400
X263 270 42 902 901 19 903 363 354 904 23 DFFSXL $T=475200 2973600 1 0 $X=470900 $Y=2917800
X264 6 51 906 905 279 907 516 354 908 23 DFFSXL $T=488400 2570400 1 0 $X=484100 $Y=2514600
X265 6 102 910 909 279 911 514 354 912 23 DFFSXL $T=541200 2671200 1 0 $X=536900 $Y=2615400
X266 270 51 914 913 279 915 519 354 916 23 DFFSXL $T=541200 2772000 1 0 $X=536900 $Y=2716200
X267 6 127 918 917 279 919 524 354 920 23 DFFSXL $T=633600 2671200 0 0 $X=629300 $Y=2667200
X268 270 127 922 921 279 923 525 354 924 23 DFFSXL $T=666600 2671200 1 0 $X=662300 $Y=2615400
X269 49 127 926 925 279 927 775 354 928 23 DFFSXL $T=699600 2570400 1 0 $X=695300 $Y=2514600
X270 30 36 930 929 23 931 776 354 932 23 DFFSXL $T=719400 3074400 1 0 $X=715100 $Y=3018600
X271 30 59 934 933 279 935 530 354 936 23 DFFSXL $T=752400 2772000 0 0 $X=748100 $Y=2768000
X272 270 364 938 937 279 939 529 354 940 23 DFFSXL $T=759000 2671200 0 0 $X=754700 $Y=2667200
X273 6 59 942 941 279 943 778 354 944 23 DFFSXL $T=759000 2772000 1 0 $X=754700 $Y=2716200
X274 270 59 946 945 23 947 367 354 948 23 DFFSXL $T=838200 2570400 1 0 $X=833900 $Y=2514600
X275 6 17 950 949 279 951 448 354 952 23 DFFSXL $T=884400 2671200 0 0 $X=880100 $Y=2667200
X276 6 76 954 953 279 955 538 354 956 23 DFFSXL $T=891000 2671200 1 0 $X=886700 $Y=2615400
X277 27 542 958 957 279 959 960 354 441 23 DFFSXL $T=957000 2872800 1 0 $X=952700 $Y=2817000
X278 6 28 28 961 23 962 518 354 963 23 DFFSXL $T=983400 2570400 1 0 $X=979100 $Y=2514600
X279 70 76 76 964 23 965 72 354 966 23 DFFSXL $T=983400 3074400 1 0 $X=979100 $Y=3018600
X280 75 59 968 967 279 969 547 354 970 23 DFFSXL $T=1029600 2772000 1 0 $X=1025300 $Y=2716200
X281 75 105 972 971 23 973 552 354 974 23 DFFSXL $T=1042800 2671200 1 0 $X=1038500 $Y=2615400
X282 70 71 976 975 23 977 452 354 978 23 DFFSXL $T=1062600 2973600 0 0 $X=1058300 $Y=2969600
X283 78 76 980 979 279 981 537 354 982 23 DFFSXL $T=1082400 2772000 0 0 $X=1078100 $Y=2768000
X284 70 162 984 983 23 985 560 354 986 23 DFFSXL $T=1128600 2570400 1 0 $X=1124300 $Y=2514600
X285 70 105 988 987 23 989 93 354 990 23 DFFSXL $T=1148400 2671200 0 0 $X=1144100 $Y=2667200
X286 78 59 992 991 279 993 453 354 994 23 DFFSXL $T=1155000 2772000 1 0 $X=1150700 $Y=2716200
X287 70 127 996 995 23 997 828 354 998 23 DFFSXL $T=1174800 2973600 1 0 $X=1170500 $Y=2917800
X288 90 51 1000 999 23 1001 562 354 1002 23 DFFSXL $T=1260600 2671200 1 0 $X=1256300 $Y=2615400
X289 75 51 1004 1003 23 1005 559 354 1006 23 DFFSXL $T=1267200 2570400 0 0 $X=1262900 $Y=2566400
X290 90 162 1008 1007 23 1009 782 354 1010 23 DFFSXL $T=1280400 2772000 1 0 $X=1276100 $Y=2716200
X291 78 162 1012 1011 23 1013 783 354 1014 23 DFFSXL $T=1293600 2872800 1 0 $X=1289300 $Y=2817000
X292 78 292 1016 1015 23 1017 380 354 1018 23 DFFSXL $T=1412400 2772000 0 0 $X=1408100 $Y=2768000
X293 75 162 1020 1019 308 1021 561 354 1022 23 DFFSXL $T=1452000 2570400 1 0 $X=1447700 $Y=2514600
X294 106 272 1024 1023 23 1025 567 354 1026 23 DFFSXL $T=1465200 2973600 0 0 $X=1460900 $Y=2969600
X295 82 105 1028 1027 23 1029 382 354 1030 23 DFFSXL $T=1544400 2570400 0 0 $X=1540100 $Y=2566400
X296 113 121 1032 1031 23 1033 300 354 1034 23 DFFSXL $T=1650000 2772000 0 0 $X=1645700 $Y=2768000
X297 113 299 1036 1035 308 1037 784 354 1038 23 DFFSXL $T=1676400 2570400 1 0 $X=1672100 $Y=2514600
X298 113 122 1040 1039 23 1041 571 354 1042 23 DFFSXL $T=1683000 2772000 1 0 $X=1678700 $Y=2716200
X299 113 51 1044 1043 23 1045 387 354 1046 23 DFFSXL $T=1683000 2872800 0 0 $X=1678700 $Y=2868800
X300 128 302 1048 1047 308 1049 390 354 1050 23 DFFSXL $T=1808400 2570400 0 0 $X=1804100 $Y=2566400
X301 113 164 1052 1051 23 1053 574 354 1054 23 DFFSXL $T=1854600 2872800 0 0 $X=1850300 $Y=2868800
X302 131 127 1056 1055 307 1057 580 354 1058 23 DFFSXL $T=1854600 3074400 1 0 $X=1850300 $Y=3018600
X303 131 29 1060 1059 307 1061 575 354 1062 23 DFFSXL $T=1947000 2872800 1 0 $X=1942700 $Y=2817000
X304 148 51 1064 1063 23 1065 584 354 1066 23 DFFSXL $T=1953600 2772000 1 0 $X=1949300 $Y=2716200
X305 148 17 1068 1067 307 1069 587 354 1070 23 DFFSXL $T=2052600 3074400 1 0 $X=2048300 $Y=3018600
X306 148 290 1072 1071 307 1073 790 354 1074 23 DFFSXL $T=2072400 2772000 0 0 $X=2068100 $Y=2768000
X307 148 76 1076 1075 307 1077 589 354 1078 23 DFFSXL $T=2072400 2872800 0 0 $X=2068100 $Y=2868800
X308 170 290 1080 1079 307 1081 156 354 1082 23 DFFSXL $T=2085600 2671200 0 0 $X=2081300 $Y=2667200
X309 157 622 1084 1083 307 1085 596 354 1086 23 DFFSXL $T=2197800 2872800 0 0 $X=2193500 $Y=2868800
X310 170 51 1088 1087 307 1089 583 354 1090 23 DFFSXL $T=2211000 2772000 1 0 $X=2206700 $Y=2716200
X311 170 162 1092 1091 307 1093 165 354 1094 23 DFFSXL $T=2224200 2671200 0 0 $X=2219900 $Y=2667200
X312 170 76 1096 1095 307 1097 396 354 1098 23 DFFSXL $T=2296800 3074400 1 0 $X=2292500 $Y=3018600
X313 170 302 302 1099 307 1100 397 354 1101 23 DFFSXL $T=2356200 2772000 1 0 $X=2351900 $Y=2716200
X314 170 17 1103 1102 307 1104 593 354 1105 23 DFFSXL $T=2362800 2872800 0 0 $X=2358500 $Y=2868800
X315 170 16 1107 1106 307 1108 137 354 1109 23 DFFSXL $T=2369400 2973600 1 0 $X=2365100 $Y=2917800
X316 167 271 1111 1110 318 1112 399 354 1113 23 DFFSXL $T=2422200 3074400 1 0 $X=2417900 $Y=3018600
X317 174 105 1115 1114 23 1116 176 354 1117 23 DFFSXL $T=2475000 2570400 0 0 $X=2470700 $Y=2566400
X318 174 51 1119 1118 23 1120 155 354 1121 23 DFFSXL $T=2475000 2772000 0 0 $X=2470700 $Y=2768000
X319 170 271 1123 1122 307 1124 144 354 1125 23 DFFSXL $T=2488200 2872800 0 0 $X=2483900 $Y=2868800
X320 174 271 1127 1126 318 1128 400 354 1129 23 DFFSXL $T=2521200 2973600 0 0 $X=2516900 $Y=2969600
X321 174 272 1131 1130 318 1132 320 354 1133 23 DFFSXL $T=2574000 3074400 1 0 $X=2569700 $Y=3018600
X322 178 602 1135 1134 307 1136 791 354 1137 23 DFFSXL $T=2600400 2772000 1 0 $X=2596100 $Y=2716200
X323 178 477 1139 1138 319 1140 608 354 1141 23 DFFSXL $T=2620200 2570400 0 0 $X=2615900 $Y=2566400
X324 157 607 1143 1142 318 1144 402 354 1145 23 DFFSXL $T=2706000 2973600 0 0 $X=2701700 $Y=2969600
X325 157 609 1147 1146 23 1148 604 354 1149 23 DFFSXL $T=2725800 2772000 1 0 $X=2721500 $Y=2716200
X326 157 613 1151 1150 23 1152 322 354 1153 23 DFFSXL $T=2725800 2973600 1 0 $X=2721500 $Y=2917800
X327 157 610 1155 1154 23 1156 611 354 1157 23 DFFSXL $T=2739000 2772000 0 0 $X=2734700 $Y=2768000
X328 200 797 1159 1158 23 1160 652 354 674 23 DFFSXL $T=3016200 2973600 1 0 $X=3011900 $Y=2917800
X329 200 799 1162 1161 23 1163 204 354 664 23 DFFSXL $T=3029400 2671200 0 0 $X=3025100 $Y=2667200
X330 200 408 1165 1164 23 1166 411 354 412 23 DFFSXL $T=3036000 2570400 1 0 $X=3031700 $Y=2514600
X331 200 648 1168 1167 23 1169 616 354 660 23 DFFSXL $T=3036000 2570400 0 0 $X=3031700 $Y=2566400
X332 178 659 1171 1170 23 1172 623 354 1173 23 DFFSXL $T=3121800 2872800 1 0 $X=3117500 $Y=2817000
X333 178 663 1175 1174 23 1176 627 354 1177 23 DFFSXL $T=3148200 2872800 0 0 $X=3143900 $Y=2868800
X334 178 680 1179 1178 23 1180 476 354 1181 23 DFFSXL $T=3273600 2772000 1 0 $X=3269300 $Y=2716200
X335 178 681 1183 1182 23 1184 625 354 1185 23 DFFSXL $T=3273600 2772000 0 0 $X=3269300 $Y=2768000
X336 178 684 1187 1186 23 1188 676 354 1189 23 DFFSXL $T=3280200 2973600 1 0 $X=3275900 $Y=2917800
X337 178 686 1191 1190 23 1192 632 354 1193 23 DFFSXL $T=3293400 2872800 0 0 $X=3289100 $Y=2868800
X338 245 220 1195 1194 340 1196 478 354 1197 23 DFFSXL $T=3425400 2671200 0 0 $X=3421100 $Y=2667200
X339 245 228 1199 1198 23 1200 700 354 1201 23 DFFSXL $T=3432000 2772000 0 0 $X=3427700 $Y=2768000
X340 245 696 1203 1202 23 1204 695 354 1205 23 DFFSXL $T=3458400 2772000 1 0 $X=3454100 $Y=2716200
X341 245 232 1207 1206 23 1208 703 354 1209 23 DFFSXL $T=3524400 2872800 0 0 $X=3520100 $Y=2868800
X342 245 424 1211 1210 340 1212 704 354 1213 23 DFFSXL $T=3550800 2671200 1 0 $X=3546500 $Y=2615400
X343 335 240 1215 1214 23 1216 705 354 1217 23 DFFSXL $T=3550800 2671200 0 0 $X=3546500 $Y=2667200
X344 335 239 1219 1218 340 1220 707 354 1221 23 DFFSXL $T=3557400 2570400 0 0 $X=3553100 $Y=2566400
X345 335 424 1223 1222 23 1224 708 354 1225 23 DFFSXL $T=3557400 2772000 0 0 $X=3553100 $Y=2768000
X346 335 220 1227 1226 23 1228 710 354 1229 23 DFFSXL $T=3583800 2872800 1 0 $X=3579500 $Y=2817000
X347 335 232 1231 1230 23 1232 714 354 1233 23 DFFSXL $T=3682800 2872800 0 0 $X=3678500 $Y=2868800
X348 246 427 1235 1234 340 1236 229 354 1237 23 DFFSXL $T=3689400 2570400 1 0 $X=3685100 $Y=2514600
X349 246 733 1239 1238 23 1240 698 354 1241 23 DFFSXL $T=3696000 2671200 1 0 $X=3691700 $Y=2615400
X350 335 341 1243 1242 23 1244 712 354 1245 23 DFFSXL $T=3696000 2973600 1 0 $X=3691700 $Y=2917800
X351 246 428 1247 1246 23 1248 430 354 1249 23 DFFSXL $T=3821400 2671200 1 0 $X=3817100 $Y=2615400
X352 246 716 1251 1250 23 1252 720 354 1253 23 DFFSXL $T=3821400 2973600 1 0 $X=3817100 $Y=2917800
X353 246 429 1255 1254 23 1256 253 354 1257 23 DFFSXL $T=3821400 2973600 0 0 $X=3817100 $Y=2969600
X354 246 718 1259 1258 23 1260 699 354 1261 23 DFFSXL $T=3834600 2671200 0 0 $X=3830300 $Y=2667200
X355 246 721 721 1262 23 1263 728 354 1264 23 DFFSXL $T=3861000 2772000 0 0 $X=3856700 $Y=2768000
X356 743 354 482 1265 23 732 NAND2BXL $T=4006200 2872800 1 0 $X=4001900 $Y=2817000
X357 734 354 731 1266 23 816 NAND2BXL $T=4098600 2772000 1 180 $X=4067900 $Y=2768000
X358 346 354 347 1267 23 485 NAND2BXL $T=4171200 3074400 0 180 $X=4140500 $Y=3018600
X359 758 354 744 1268 23 817 NAND2BXL $T=4177800 2570400 1 180 $X=4147100 $Y=2566400
X360 745 354 751 1269 23 757 NAND2BXL $T=4171200 2772000 0 0 $X=4166900 $Y=2768000
X361 754 354 755 1270 23 762 NAND2BXL $T=4197600 2872800 0 0 $X=4193300 $Y=2868800
X362 752 354 762 1271 23 767 NAND2BXL $T=4263600 2872800 1 0 $X=4259300 $Y=2817000
X363 766 354 768 1272 23 440 NAND2BXL $T=4263600 2973600 0 0 $X=4259300 $Y=2969600
X364 693 420 354 23 694 XOR2XL $T=3425400 2570400 0 0 $X=3421100 $Y=2566400
X365 732 754 354 23 723 XOR2XL $T=4092000 2872800 0 180 $X=4034900 $Y=2817000
X366 485 746 354 23 722 XOR2XL $T=4158000 2872800 1 180 $X=4100900 $Y=2868800
X367 756 766 354 23 747 XOR2XL $T=4250400 2973600 1 180 $X=4193300 $Y=2969600
X368 757 821 354 23 740 XOR2XL $T=4290000 2772000 1 180 $X=4232900 $Y=2768000
X369 478 710 1274 479 1273 1275 1276 713 354 23 481 CMPR32X1 $T=3696000 2772000 1 0 $X=3691700 $Y=2716200
X370 711 712 728 728 728 1277 1278 726 354 23 742 CMPR32X1 $T=4092000 2872800 1 180 $X=3949100 $Y=2868800
X371 704 708 1280 699 1279 1281 1282 727 354 23 724 CMPR32X1 $T=4098600 2570400 1 180 $X=3955700 $Y=2566400
X372 703 714 1284 701 1283 1285 1286 432 354 23 725 CMPR32X1 $T=4098600 2973600 0 180 $X=3955700 $Y=2917800
X373 803 805 354 23 215 XOR2X1 $T=3174600 3074400 1 0 $X=3170300 $Y=3018600
X374 778 48 23 451 354 368 455 AOI211XL $T=937200 2772000 1 0 $X=932900 $Y=2716200
X375 674 208 23 9 354 808 677 AOI211XL $T=3240600 2973600 1 0 $X=3236300 $Y=2917800
X376 213 208 23 9 354 809 679 AOI211XL $T=3247200 2671200 0 0 $X=3242900 $Y=2667200
X377 664 208 23 9 354 810 216 AOI211XL $T=3273600 2570400 1 0 $X=3269300 $Y=2514600
X378 660 208 23 9 354 811 687 AOI211XL $T=3293400 2671200 1 0 $X=3289100 $Y=2615400
X379 802 655 354 23 667 XNOR2X1 $T=3148200 2973600 1 0 $X=3143900 $Y=2917800
X380 672 212 354 23 685 XNOR2X1 $T=3247200 2570400 0 0 $X=3242900 $Y=2566400
X381 817 818 354 23 736 XNOR2X1 $T=4171200 2671200 0 180 $X=4114100 $Y=2615400
X382 190 616 354 23 619 OR2XL $T=2838000 2570400 1 0 $X=2833700 $Y=2514600
X383 321 204 354 23 457 OR2XL $T=2838000 2570400 0 0 $X=2833700 $Y=2566400
X384 325 326 354 23 653 OR2XL $T=3042600 3074400 1 0 $X=3038300 $Y=3018600
X385 652 586 354 23 654 OR2XL $T=3055800 2772000 0 0 $X=3051500 $Y=2768000
X386 616 588 354 23 669 OR2XL $T=3168000 2570400 0 0 $X=3163700 $Y=2566400
X387 685 689 354 23 221 OR2XL $T=3313200 2570400 0 0 $X=3308900 $Y=2566400
X388 702 727 354 23 345 OR2XL $T=4092000 2570400 1 0 $X=4087700 $Y=2514600
X389 816 1287 735 354 23 729 XNOR2XL $T=4072200 2772000 1 180 $X=4015100 $Y=2768000
X390 764 1288 767 354 23 741 XNOR2XL $T=4217400 2671200 0 0 $X=4213100 $Y=2667200
X391 763 1289 350 354 23 486 XNOR2XL $T=4290000 2570400 1 180 $X=4232900 $Y=2566400
X392 24 496 357 354 772 23 OAI2BB1XL $T=382800 2671200 0 0 $X=378500 $Y=2667200
X393 48 448 497 354 360 23 OAI2BB1XL $T=442200 2973600 0 0 $X=437900 $Y=2969600
X394 21 502 513 354 449 23 OAI2BB1XL $T=580800 2570400 1 180 $X=543500 $Y=2566400
X395 21 519 517 354 521 23 OAI2BB1XL $T=679800 2772000 0 0 $X=675500 $Y=2768000
X396 63 528 526 354 536 23 OAI2BB1XL $T=884400 2772000 0 0 $X=880100 $Y=2768000
X397 291 537 532 354 533 23 OAI2BB1XL $T=937200 2973600 0 180 $X=899900 $Y=2917800
X398 301 385 386 354 540 23 OAI2BB1XL $T=1749000 2973600 0 0 $X=1744700 $Y=2969600
X399 195 618 615 354 629 23 OAI2BB1XL $T=2884200 3074400 1 0 $X=2879900 $Y=3018600
X400 350 488 739 354 818 23 OAI2BB1XL $T=4210800 2671200 0 180 $X=4173500 $Y=2615400
X401 354 23 351 102 1290 1291 352 22 1292 270 13 1293 352 446 1294 ICV_1 $T=0 2570400 1 0 $X=-4300 $Y=2514600
X402 354 23 270 271 1295 1296 19 353 1297 49 76 1298 19 771 1299 ICV_1 $T=0 2872800 0 0 $X=-4300 $Y=2868800
X403 354 23 270 102 1300 1301 19 491 1302 270 17 1303 19 445 1304 ICV_1 $T=6600 2671200 1 0 $X=2300 $Y=2615400
X404 354 23 49 12 1305 1306 19 494 1307 270 12 1308 19 498 1309 ICV_1 $T=85800 2973600 0 0 $X=81500 $Y=2969600
X405 354 23 49 16 1310 1311 19 496 1312 27 28 1313 19 503 1314 ICV_1 $T=125400 2772000 0 0 $X=121100 $Y=2768000
X406 354 23 49 28 1315 1316 19 501 1317 30 16 1318 19 509 1319 ICV_1 $T=250800 2872800 1 0 $X=246500 $Y=2817000
X407 354 23 270 28 1320 1321 19 502 1322 30 28 1323 352 511 1324 ICV_1 $T=270600 2671200 1 0 $X=266300 $Y=2615400
X408 354 23 270 29 1325 1326 19 359 1327 270 71 1328 19 276 1329 ICV_1 $T=323400 3074400 1 0 $X=319100 $Y=3018600
X409 354 23 27 127 1330 1331 19 515 1332 27 76 76 279 522 1333 ICV_1 $T=475200 2872800 0 0 $X=470900 $Y=2868800
X410 354 23 49 71 1334 1335 279 54 1336 30 71 1337 279 282 1338 ICV_1 $T=587400 2973600 0 0 $X=583100 $Y=2969600
X411 354 23 49 51 1339 1340 279 520 1341 30 127 1342 279 528 1343 ICV_1 $T=594000 2872800 1 0 $X=589700 $Y=2817000
X412 354 23 49 42 1344 1345 279 278 1346 30 443 443 279 1347 512 ICV_1 $T=600600 2973600 1 0 $X=596300 $Y=2917800
X413 354 23 27 59 1348 1349 279 779 1350 27 71 1351 279 373 1352 ICV_1 $T=844800 2872800 0 0 $X=840500 $Y=2868800
X414 354 23 27 105 1353 1354 279 374 1355 75 102 1356 23 85 1357 ICV_1 $T=1003200 2570400 0 0 $X=998900 $Y=2566400
X415 354 23 70 51 1358 1359 23 557 1360 106 28 1361 23 379 1362 ICV_1 $T=1201200 3074400 1 0 $X=1196900 $Y=3018600
X416 354 23 82 290 1363 1364 23 119 1365 113 127 1366 23 569 1367 ICV_1 $T=1333200 2973600 1 0 $X=1328900 $Y=2917800
X417 354 23 82 162 1368 1369 23 566 1370 113 175 1371 23 572 1372 ICV_1 $T=1419000 2671200 1 0 $X=1414700 $Y=2615400
X418 354 23 113 103 1373 1374 23 568 1375 113 105 1376 23 564 1377 ICV_1 $T=1419000 2671200 0 0 $X=1414700 $Y=2667200
X419 354 23 78 105 1378 1379 23 107 1380 113 162 1381 23 298 1382 ICV_1 $T=1419000 2872800 1 0 $X=1414700 $Y=2817000
X420 354 23 113 290 1383 1384 23 293 1385 131 76 1386 23 304 1387 ICV_1 $T=1597200 3074400 1 0 $X=1592900 $Y=3018600
X421 354 23 128 127 1388 1389 307 579 1390 131 302 1391 307 789 1392 ICV_1 $T=1815000 2671200 1 0 $X=1810700 $Y=2615400
X422 354 23 128 303 1393 1394 23 576 1395 131 51 1396 307 582 1397 ICV_1 $T=1821600 2671200 0 0 $X=1817300 $Y=2667200
X423 354 23 131 17 1398 1399 307 788 1400 148 59 1401 307 151 1402 ICV_1 $T=1920600 2973600 1 0 $X=1916300 $Y=2917800
X424 354 23 131 105 1403 1404 308 392 1405 167 290 1406 307 588 1407 ICV_1 $T=1927200 2570400 1 0 $X=1922900 $Y=2514600
X425 354 23 174 162 1408 1409 307 166 1410 170 105 105 307 594 1411 ICV_1 $T=2224200 2671200 1 0 $X=2219900 $Y=2615400
X426 354 23 174 290 1412 1413 307 689 1414 174 302 1415 23 398 1416 ICV_1 $T=2270400 2570400 1 0 $X=2266100 $Y=2514600
X427 354 23 178 601 1417 1418 319 401 1419 157 187 1420 23 600 1421 ICV_1 $T=2574000 2570400 1 0 $X=2569700 $Y=2514600
X428 354 23 178 465 1422 1423 307 603 1424 157 403 1425 23 598 1426 ICV_1 $T=2580600 2671200 1 0 $X=2576300 $Y=2615400
X429 354 23 157 605 1427 1428 23 597 1429 157 612 1430 23 606 1431 ICV_1 $T=2613600 2872800 0 0 $X=2609300 $Y=2868800
X430 354 23 178 649 1432 1433 23 617 1434 178 662 1435 23 628 1436 ICV_1 $T=3009600 2772000 1 0 $X=3005300 $Y=2716200
X431 354 23 335 419 1437 1438 23 422 1439 335 423 1440 23 706 1441 ICV_1 $T=3418800 3074400 1 0 $X=3414500 $Y=3018600
X432 354 23 335 696 1442 1443 23 697 1444 335 425 1445 23 426 1446 ICV_1 $T=3432000 2973600 0 0 $X=3427700 $Y=2969600
X433 354 23 246 709 1447 1448 340 479 1449 246 715 1450 340 480 1451 ICV_1 $T=3682800 2570400 0 0 $X=3678500 $Y=2566400
X434 354 23 245 341 1452 1453 23 711 1454 246 717 1455 23 701 1456 ICV_1 $T=3689400 3074400 1 0 $X=3685100 $Y=3018600
X435 72 452 23 72 372 112 371 370 354 AOI222XL $T=1082400 2973600 0 180 $X=1025300 $Y=2917800
X436 81 285 23 77 112 72 80 549 354 AOI222XL $T=1155000 2872800 1 180 $X=1097900 $Y=2868800
X437 72 557 23 559 112 72 562 555 354 AOI222XL $T=1320000 2772000 0 0 $X=1315700 $Y=2768000
X438 72 560 23 782 72 72 561 829 354 AOI222XL $T=1405800 2570400 0 180 $X=1348700 $Y=2514600
X439 547 112 23 289 72 72 132 563 354 AOI222XL $T=1537800 2772000 1 0 $X=1533500 $Y=2716200
X440 143 163 23 575 135 280 110 573 354 AOI222XL $T=1874400 2772000 1 180 $X=1817300 $Y=2768000
X441 145 584 23 586 155 155 155 581 354 AOI222XL $T=2158200 2772000 0 180 $X=2101100 $Y=2716200
X442 158 588 23 790 313 138 689 832 354 AOI222XL $T=2211000 2570400 1 180 $X=2153900 $Y=2566400
X443 143 593 23 587 145 158 160 577 354 AOI222XL $T=2237400 3074400 0 180 $X=2180300 $Y=3018600
X444 145 589 23 169 158 138 315 591 354 AOI222XL $T=2211000 2973600 0 0 $X=2206700 $Y=2969600
X445 573 354 23 384 BUFXL $T=1742400 2973600 0 180 $X=1711700 $Y=2917800
X446 832 354 23 73 BUFXL $T=2158200 2570400 1 180 $X=2127500 $Y=2566400
X447 591 354 23 539 BUFXL $T=2204400 2973600 1 180 $X=2173700 $Y=2969600
X448 551 354 510 23 41 362 NAND3XL $T=488400 2973600 0 0 $X=484100 $Y=2969600
X449 786 354 581 23 578 444 NAND3XL $T=1980000 2772000 1 180 $X=1949300 $Y=2768000
X450 445 23 21 24 495 497 354 AOI22XL $T=250800 3074400 0 180 $X=213500 $Y=3018600
X451 494 23 24 21 498 25 354 AOI22XL $T=250800 2973600 1 0 $X=246500 $Y=2917800
X452 493 23 21 24 771 532 354 AOI22XL $T=277200 2872800 0 0 $X=272900 $Y=2868800
X453 491 23 21 24 356 500 354 AOI22XL $T=323400 2570400 0 0 $X=319100 $Y=2566400
X454 446 23 21 24 50 35 354 AOI22XL $T=336600 2671200 0 0 $X=332300 $Y=2667200
X455 492 23 21 24 32 33 354 AOI22XL $T=336600 2772000 1 0 $X=332300 $Y=2716200
X456 501 23 24 66 503 508 354 AOI22XL $T=396000 2772000 1 0 $X=391700 $Y=2716200
X457 509 23 63 66 773 504 354 AOI22XL $T=468600 2772000 1 180 $X=431300 $Y=2768000
X458 361 23 66 63 512 506 354 AOI22XL $T=468600 2671200 0 0 $X=464300 $Y=2667200
X459 511 23 63 48 518 513 354 AOI22XL $T=594000 2570400 0 0 $X=589700 $Y=2566400
X460 520 23 24 48 516 517 354 AOI22XL $T=673200 2772000 1 180 $X=635900 $Y=2768000
X461 775 23 24 21 525 526 354 AOI22XL $T=798600 2671200 1 0 $X=794300 $Y=2615400
X462 529 23 21 24 62 67 354 AOI22XL $T=877800 2671200 0 180 $X=840500 $Y=2615400
X463 776 23 63 66 441 531 354 AOI22XL $T=844800 2973600 0 0 $X=840500 $Y=2969600
X464 522 23 66 63 505 777 354 AOI22XL $T=871200 2973600 1 0 $X=866900 $Y=2917800
X465 524 23 48 66 515 534 354 AOI22XL $T=877800 2872800 1 0 $X=873500 $Y=2817000
X466 99 23 287 291 453 781 354 AOI22XL $T=1405800 2973600 1 180 $X=1368500 $Y=2969600
X467 566 23 287 104 783 558 354 AOI22XL $T=1445400 2570400 0 180 $X=1408100 $Y=2514600
X468 580 23 135 301 579 554 354 AOI22XL $T=1940400 2772000 1 180 $X=1903100 $Y=2768000
X469 788 23 135 138 309 787 354 AOI22XL $T=2039400 2973600 1 180 $X=2002100 $Y=2969600
X470 583 23 143 135 582 786 354 AOI22XL $T=2052600 2772000 1 180 $X=2015300 $Y=2768000
X471 789 23 310 313 314 393 354 AOI22XL $T=2072400 2570400 0 0 $X=2068100 $Y=2566400
X472 176 23 138 159 161 394 354 AOI22XL $T=2217600 2570400 0 180 $X=2180300 $Y=2514600
X473 594 23 395 158 317 312 354 AOI22XL $T=2250600 2570400 0 180 $X=2213300 $Y=2514600
X474 500 354 273 506 507 39 23 NAND4XL $T=422400 2671200 0 0 $X=418100 $Y=2667200
X475 123 354 86 541 451 543 23 NAND4XL $T=1042800 2772000 1 180 $X=1005500 $Y=2768000
X476 554 354 549 450 546 454 23 NAND4XL $T=1247400 2772000 0 0 $X=1243100 $Y=2768000
X477 577 787 577 354 23 577 275 AND3XL $T=2019600 3074400 0 180 $X=1982300 $Y=3018600
X478 316 443 354 23 CLKBUFX3 $T=2376000 2973600 0 0 $X=2371700 $Y=2969600
X479 26 23 23 354 CLKINVX4 $T=283800 2671200 1 180 $X=253100 $Y=2667200
X480 26 279 23 354 CLKINVX4 $T=976800 2772000 1 0 $X=972500 $Y=2716200
X481 230 23 23 354 CLKINVX4 $T=3484800 2872800 0 180 $X=3454100 $Y=2817000
X482 774 23 354 5 CLKBUFX2 $T=468600 2772000 0 0 $X=464300 $Y=2768000
X483 564 23 354 98 CLKBUFX2 $T=1412400 2872800 1 180 $X=1381700 $Y=2868800
X484 567 23 354 269 CLKBUFX2 $T=1432200 2973600 1 180 $X=1401500 $Y=2969600
X485 568 23 354 108 CLKBUFX2 $T=1498200 2872800 1 180 $X=1467500 $Y=2868800
X486 569 23 354 109 CLKBUFX2 $T=1498200 3074400 0 180 $X=1467500 $Y=3018600
X487 570 23 354 97 CLKBUFX2 $T=1544400 3074400 0 180 $X=1513700 $Y=3018600
X488 381 23 354 111 CLKBUFX2 $T=1623600 2570400 0 180 $X=1592900 $Y=2514600
X489 571 23 354 114 CLKBUFX2 $T=1623600 2772000 0 180 $X=1592900 $Y=2716200
X490 572 23 354 296 CLKBUFX2 $T=1656600 2772000 0 180 $X=1625900 $Y=2716200
X491 383 23 354 116 CLKBUFX2 $T=1669800 2570400 0 180 $X=1639100 $Y=2514600
X492 784 23 354 120 CLKBUFX2 $T=1722600 2570400 1 180 $X=1691900 $Y=2566400
X493 444 23 354 442 CLKBUFX2 $T=1775400 2772000 0 0 $X=1771100 $Y=2768000
X494 574 23 354 126 CLKBUFX2 $T=1815000 2973600 0 180 $X=1784300 $Y=2917800
X495 785 23 354 133 CLKBUFX2 $T=1821600 2772000 1 0 $X=1817300 $Y=2716200
X496 58 23 61 1457 354 523 AND2X2 $T=712800 2570400 0 0 $X=708500 $Y=2566400
X497 65 23 61 1458 354 527 AND2X2 $T=831600 2570400 0 0 $X=827300 $Y=2566400
X498 124 23 8 1459 354 548 AND2X2 $T=1155000 2872800 0 0 $X=1150700 $Y=2868800
X499 376 23 8 1460 354 553 AND2X2 $T=1201200 2973600 0 0 $X=1196900 $Y=2969600
X500 91 23 8 1461 354 556 AND2X2 $T=1240800 2872800 0 0 $X=1236500 $Y=2868800
X501 94 23 8 1462 354 827 AND2X2 $T=1273800 2671200 0 0 $X=1269500 $Y=2667200
X502 140 23 8 1463 354 830 AND2X2 $T=1425600 2570400 0 0 $X=1421300 $Y=2566400
X503 125 23 8 1464 354 113 AND2X2 $T=1702800 2671200 0 0 $X=1698500 $Y=2667200
X504 139 23 8 1465 354 831 AND2X2 $T=1920600 2973600 0 0 $X=1916300 $Y=2969600
X505 152 23 8 1466 354 585 AND2X2 $T=2085600 2973600 0 0 $X=2081300 $Y=2969600
X506 168 23 8 1467 354 595 AND2X2 $T=2283600 2973600 0 0 $X=2279300 $Y=2969600
X507 171 23 8 1468 354 646 AND2X2 $T=2963400 2973600 0 0 $X=2959100 $Y=2969600
X508 150 354 23 147 BUFX1 $T=2112000 2872800 0 180 $X=2081300 $Y=2817000
X509 824 535 18 777 354 23 283 AND4XL $T=930600 2973600 1 180 $X=886700 $Y=2969600
X510 780 369 53 539 354 23 824 AND4XL $T=976800 2973600 1 180 $X=932900 $Y=2969600
X511 115 23 291 354 CLKINVX3 $T=1584000 3074400 0 180 $X=1559900 $Y=3018600
X512 149 23 155 354 CLKINVX3 $T=2125200 2671200 1 0 $X=2120900 $Y=2615400
X513 697 695 229 421 23 354 702 ADDFHXL $T=3405600 2570400 1 0 $X=3401300 $Y=2514600
X514 342 700 720 258 23 354 719 ADDFHXL $T=3715800 2772000 0 0 $X=3711500 $Y=2768000
X515 707 344 480 750 23 354 730 ADDFHXL $T=3900600 2570400 1 0 $X=3896300 $Y=2514600
X516 706 343 339 484 23 354 434 ADDFHXL $T=3960000 3074400 1 0 $X=3955700 $Y=3018600
X517 113 134 1469 23 1470 570 354 1471 23 DFFSX1 $T=1551000 2872800 0 0 $X=1546700 $Y=2868800
X518 113 297 1472 23 1473 294 354 1474 23 DFFSX1 $T=1597200 2973600 0 0 $X=1592900 $Y=2969600
X519 113 177 1475 23 1476 785 354 1477 23 DFFSX1 $T=1683000 2671200 1 0 $X=1678700 $Y=2615400
X520 113 292 1478 23 1479 295 354 1480 23 DFFSX1 $T=1683000 2872800 1 0 $X=1678700 $Y=2817000
X521 128 134 1481 23 1482 142 354 1483 23 DFFSX1 $T=1821600 2872800 1 0 $X=1817300 $Y=2817000
X522 157 592 1484 307 1485 542 354 303 23 DFFSX1 $T=2197800 2772000 0 0 $X=2193500 $Y=2768000
X523 157 599 1486 307 1487 316 354 1488 23 DFFSX1 $T=2349600 2772000 0 0 $X=2345300 $Y=2768000
X524 167 51 1489 23 1490 586 354 1491 23 DFFSX1 $T=2448600 2872800 1 0 $X=2444300 $Y=2817000
X525 246 815 1492 23 1493 336 354 1494 23 DFFSX1 $T=3834600 2872800 1 0 $X=3830300 $Y=2817000
X526 26 354 23 23 CLKINVX8 $T=957000 3074400 0 180 $X=913100 $Y=3018600
X527 460 462 354 624 23 793 626 OAI211XL $T=2917200 2570400 1 180 $X=2873300 $Y=2566400
X528 634 629 354 198 23 641 199 OAI211XL $T=2956800 3074400 1 0 $X=2952500 $Y=3018600
X529 800 409 354 650 23 656 655 OAI211XL $T=3075600 2973600 0 0 $X=3071300 $Y=2969600
X530 692 224 354 813 23 222 417 OAI211XL $T=3352800 2570400 1 0 $X=3348500 $Y=2514600
X531 311 59 354 23 INVX4 $T=2059200 2570400 1 180 $X=2028500 $Y=2566400
X532 146 155 354 23 INVX4 $T=2085600 2671200 1 0 $X=2081300 $Y=2615400
X533 596 13 354 23 INVX4 $T=2323200 2872800 0 0 $X=2318900 $Y=2868800
X534 597 271 354 23 INVX4 $T=2541000 2973600 0 180 $X=2510300 $Y=2917800
X535 598 14 354 23 INVX4 $T=2554200 2671200 1 180 $X=2523500 $Y=2667200
X536 600 127 354 23 INVX4 $T=2587200 2772000 0 180 $X=2556500 $Y=2716200
X537 604 76 354 23 INVX4 $T=2640000 2973600 0 180 $X=2609300 $Y=2917800
X538 180 71 354 23 INVX4 $T=2646600 2872800 0 180 $X=2615900 $Y=2817000
X539 606 272 354 23 INVX4 $T=2686200 2973600 0 180 $X=2655500 $Y=2917800
X540 184 51 354 23 INVX4 $T=2692800 2671200 1 180 $X=2662100 $Y=2667200
X541 611 17 354 23 INVX4 $T=2712600 2872800 0 180 $X=2681900 $Y=2817000
X542 555 354 83 23 550 474 NAND3X1 $T=1234200 2872800 1 180 $X=1203500 $Y=2868800
X543 563 354 781 23 455 456 NAND3X1 $T=1366200 2872800 1 180 $X=1335500 $Y=2868800
X544 544 546 536 536 286 23 354 545 OR4X1 $T=1141800 2973600 0 180 $X=1097900 $Y=2917800
X545 365 23 442 521 34 550 354 NOR4BXL $T=785400 2872800 0 0 $X=781100 $Y=2868800
X546 531 23 284 274 68 366 354 NOR4BXL $T=877800 3074400 1 0 $X=873500 $Y=3018600
X547 472 23 633 634 354 NOR2BXL $T=2956800 2973600 1 180 $X=2926100 $Y=2969600
X548 772 354 504 4 23 774 NAND3BXL $T=462000 2772000 1 0 $X=457700 $Y=2716200
X549 449 354 508 69 23 74 NAND3BXL $T=541200 2772000 0 0 $X=536900 $Y=2768000
X550 431 705 698 1495 483 354 23 738 ADDFX1 $T=3966600 2671200 0 0 $X=3962300 $Y=2667200
X551 55 61 354 23 49 AND2X4 $T=633600 2570400 0 0 $X=629300 $Y=2566400
X552 129 8 354 23 131 AND2X4 $T=1821600 2872800 0 0 $X=1817300 $Y=2868800
X553 172 8 354 23 170 AND2X4 $T=2316600 2973600 0 0 $X=2312300 $Y=2969600
X554 181 8 354 23 174 AND2X4 $T=2428800 2973600 0 0 $X=2424500 $Y=2969600
X555 244 238 354 23 245 AND2X4 $T=3676200 2671200 0 0 $X=3671900 $Y=2667200
X556 243 238 354 23 335 AND2X4 $T=3682800 2772000 0 0 $X=3678500 $Y=2768000
X557 585 354 148 23 CLKBUFX8 $T=2178000 2973600 1 180 $X=2127500 $Y=2969600
X558 646 354 200 23 CLKBUFX8 $T=3055800 2973600 1 180 $X=3005300 $Y=2969600
X559 523 23 354 27 BUFX8 $T=825000 2570400 1 180 $X=761300 $Y=2566400
X560 527 23 354 30 BUFX8 $T=943800 2570400 1 180 $X=880100 $Y=2566400
X561 827 23 354 78 BUFX8 $T=1300200 2671200 0 0 $X=1295900 $Y=2667200
X562 830 23 354 70 BUFX8 $T=1452000 2570400 0 0 $X=1447700 $Y=2566400
X563 831 23 354 128 BUFX8 $T=1947000 2973600 0 0 $X=1942700 $Y=2969600
X564 595 23 354 167 BUFX8 $T=2263800 2973600 1 0 $X=2259500 $Y=2917800
X565 548 82 354 23 BUFX12 $T=1135200 2872800 1 0 $X=1130900 $Y=2817000
X566 556 90 354 23 BUFX12 $T=1267200 2872800 0 0 $X=1262900 $Y=2868800
X567 553 75 354 23 BUFX16 $T=1227600 2973600 0 0 $X=1223300 $Y=2969600
X568 514 23 48 45 354 507 87 AOI211X1 $T=547800 2671200 1 180 $X=510500 $Y=2667200
X569 26 354 23 19 INVX3 $T=297000 2671200 0 0 $X=292700 $Y=2667200
.ENDS
***************************************
.SUBCKT NOR2BX1 AN VDD B Y VSS
** N=7 EP=5 IP=0 FDC=6
M0 VSS AN 6 VSS n18 L=1.8e-07 W=3e-07 $X=6600 $Y=13550 $D=6
M1 Y B VSS VSS n18 L=1.8e-07 W=6e-07 $X=12700 $Y=10550 $D=6
M2 VSS 6 Y VSS n18 L=1.8e-07 W=6e-07 $X=19900 $Y=10550 $D=6
M3 VDD AN 6 VDD p18 L=1.8e-07 W=4.2e-07 $X=6200 $Y=29650 $D=10
M4 7 B VDD VDD p18 L=1.8e-07 W=1.2e-06 $X=12800 $Y=29650 $D=10
M5 Y 6 7 VDD p18 L=1.8e-07 W=1.2e-06 $X=18400 $Y=29650 $D=10
.ENDS
***************************************
.SUBCKT NOR2X1 VDD B A Y VSS
** N=6 EP=5 IP=0 FDC=4
M0 Y B VSS VSS n18 L=1.8e-07 W=6e-07 $X=5400 $Y=10200 $D=6
M1 VSS A Y VSS n18 L=1.8e-07 W=6e-07 $X=12600 $Y=10200 $D=6
M2 6 B VDD VDD p18 L=1.8e-07 W=1.2e-06 $X=6200 $Y=28100 $D=10
M3 Y A 6 VDD p18 L=1.8e-07 W=1.2e-06 $X=11800 $Y=28100 $D=10
.ENDS
***************************************
.SUBCKT AOI22X2 B0 B1 VDD A0 A1 Y VSS
** N=12 EP=7 IP=0 FDC=16
M0 9 B1 VSS VSS n18 L=1.8e-07 W=8e-07 $X=6200 $Y=10200 $D=6
M1 Y B0 9 VSS n18 L=1.8e-07 W=8e-07 $X=11800 $Y=10200 $D=6
M2 10 B0 Y VSS n18 L=1.8e-07 W=8e-07 $X=19000 $Y=10200 $D=6
M3 VSS B1 10 VSS n18 L=1.8e-07 W=8e-07 $X=24600 $Y=10200 $D=6
M4 11 A1 VSS VSS n18 L=1.8e-07 W=8e-07 $X=30600 $Y=10200 $D=6
M5 Y A0 11 VSS n18 L=1.8e-07 W=8e-07 $X=36200 $Y=10200 $D=6
M6 12 A0 Y VSS n18 L=1.8e-07 W=8e-07 $X=43400 $Y=10200 $D=6
M7 VSS A1 12 VSS n18 L=1.8e-07 W=8e-07 $X=49000 $Y=10200 $D=6
M8 VDD B1 8 VDD p18 L=1.83034e-07 W=1.19814e-06 $X=5400 $Y=35200 $D=10
M9 8 B0 VDD VDD p18 L=1.83034e-07 W=1.19814e-06 $X=11800 $Y=29800 $D=10
M10 VDD B0 8 VDD p18 L=1.83034e-07 W=1.19814e-06 $X=18200 $Y=35200 $D=10
M11 8 B1 VDD VDD p18 L=1.83034e-07 W=1.19814e-06 $X=24600 $Y=29800 $D=10
M12 Y A1 8 VDD p18 L=1.83034e-07 W=1.19814e-06 $X=31000 $Y=35200 $D=10
M13 8 A0 Y VDD p18 L=1.83034e-07 W=1.19814e-06 $X=38200 $Y=35200 $D=10
M14 Y A0 8 VDD p18 L=1.83034e-07 W=1.19814e-06 $X=44600 $Y=29800 $D=10
M15 8 A1 Y VDD p18 L=1.83034e-07 W=1.19814e-06 $X=51000 $Y=35200 $D=10
.ENDS
***************************************
.SUBCKT ICV_5 2 4 5 6 9 10 11 12 13 14 15 16 18 20 21 22 23 24 25 26
+ 27 28 29 30 31 32 33 35 36 38 40 41 43 44 45 49 50 51 52 55
+ 56 57 60 61 62 63 64 65 66 67 69 70 71 72 73 74 76 77 78 79
+ 81 82 83 84 85 88 90 91 92 94 95 96 97 100 102 103 104 105 109 110
+ 111 112 116 118 121 124 125 126 132 134 135 137 138 139 142 144 146 147 148 151
+ 152 154 155 156 157 159 161 162 163 165 167 168 173 174 175 176 177 178 180 183
+ 184 185 187 188 189 190 192 193 195 198 201 203 204 205 206 209 210 211 212 213
+ 215 216 217 218 220 221 222 223 225 226 227 228 229 230 233 246 250 267 270 271
+ 272 273 274 275 276 277 278 279 280 281 282 283 284 285 286 287 288 289 290 291
+ 292 293 294 295 296 297 298 299 300 301 302 303 304 306 307 308 309 310 311 312
+ 313 314 315 316 317 318 319 320 321 322 323 324 325 326 327 328 329 330 331 332
+ 333 334 335 336 337 338 339 340 341 342 343 344 345 346 347 348 349 350 351 352
+ 353 354 355 356 357 358 359 360 361 362 363 365 366 367 368 369 370 371 372 373
+ 374 375 376 377 378 379 380 381 382 384 385 386 387 388 389 390 391 392 393 395
+ 396 397 398 399 400 401 402 403 404 405 406 407 408 409 410 412 413 414 415 416
+ 417
*.CALIBRE ICV_CELL 2
** N=1321 EP=301 IP=3109 FDC=7261
M0 372 703 361 361 n18 L=1.8e-07 W=6e-07 $X=1161600 $Y=2352350 $D=6
M1 361 486 372 361 n18 L=1.8e-07 W=6e-07 $X=1168850 $Y=2352350 $D=6
M2 372 297 361 361 n18 L=1.8e-07 W=6e-07 $X=1179000 $Y=2352350 $D=6
M3 361 490 372 361 n18 L=1.8e-07 W=6e-07 $X=1186200 $Y=2352350 $D=6
M4 361 493 709 361 n18 L=1.8e-07 W=6e-07 $X=1365800 $Y=2453050 $D=6
M5 709 96 361 361 n18 L=1.8e-07 W=6e-07 $X=1372400 $Y=2453050 $D=6
M6 361 498 709 361 n18 L=1.8e-07 W=6e-07 $X=1379600 $Y=2453050 $D=6
M7 1317 703 174 174 p18 L=1.8e-07 W=1.64e-06 $X=1162450 $Y=2324750 $D=10
M8 1318 486 1317 174 p18 L=1.8e-07 W=1.64e-06 $X=1168600 $Y=2324750 $D=10
M9 1319 297 1318 174 p18 L=1.8e-07 W=1.64e-06 $X=1174450 $Y=2324750 $D=10
M10 372 490 1319 174 p18 L=1.8e-07 W=1.64e-06 $X=1180450 $Y=2327350 $D=10
M11 1320 493 709 174 p18 L=1.8e-07 W=1.4e-06 $X=1366000 $Y=2428150 $D=10
M12 1321 96 1320 174 p18 L=1.8e-07 W=1.4e-06 $X=1371850 $Y=2428150 $D=10
M13 174 498 1321 174 p18 L=1.8e-07 W=1.4e-06 $X=1378000 $Y=2428150 $D=10
X14 449 361 174 463 23 NAND2XL $T=336600 2469600 0 0 $X=332300 $Y=2465600
X15 457 361 174 695 29 NAND2XL $T=376200 2368800 0 0 $X=371900 $Y=2364800
X16 483 361 174 70 425 NAND2XL $T=1102200 2066400 0 0 $X=1097900 $Y=2062400
X17 704 361 174 83 705 NAND2XL $T=1181400 2368800 0 0 $X=1177100 $Y=2364800
X18 513 361 174 110 510 NAND2XL $T=1656600 2066400 0 180 $X=1632500 $Y=2010600
X19 157 361 174 313 424 NAND2XL $T=2191200 2368800 0 180 $X=2167100 $Y=2313000
X20 156 361 174 314 489 NAND2XL $T=2237400 2368800 0 180 $X=2213300 $Y=2313000
X21 320 361 174 167 719 NAND2XL $T=2626800 2368800 1 180 $X=2602700 $Y=2364800
X22 551 361 174 180 546 NAND2XL $T=2692800 2167200 1 180 $X=2668700 $Y=2163200
X23 554 361 174 180 544 NAND2XL $T=2712600 2368800 0 180 $X=2688500 $Y=2313000
X24 433 361 174 167 397 NAND2XL $T=2732400 2469600 0 180 $X=2708300 $Y=2413800
X25 555 361 174 180 548 NAND2XL $T=2752200 2368800 0 180 $X=2728100 $Y=2313000
X26 398 361 174 180 545 NAND2XL $T=2778600 2066400 1 180 $X=2754500 $Y=2062400
X27 564 361 174 180 553 NAND2XL $T=2778600 2368800 1 180 $X=2754500 $Y=2364800
X28 556 361 174 180 178 NAND2XL $T=2785200 2368800 0 180 $X=2761100 $Y=2313000
X29 557 361 174 180 539 NAND2XL $T=2805000 2368800 1 180 $X=2780900 $Y=2364800
X30 330 361 174 426 563 NAND2XL $T=2818200 2469600 1 0 $X=2813900 $Y=2413800
X31 562 361 174 323 565 NAND2XL $T=2838000 2368800 0 0 $X=2833700 $Y=2364800
X32 720 361 174 180 547 NAND2XL $T=2864400 2066400 1 180 $X=2840300 $Y=2062400
X33 569 361 174 567 762 NAND2XL $T=2904000 2469600 1 0 $X=2899700 $Y=2413800
X34 437 361 174 322 570 NAND2XL $T=2930400 2066400 0 180 $X=2906300 $Y=2010600
X35 574 361 174 721 575 NAND2XL $T=2956800 2167200 1 180 $X=2932700 $Y=2163200
X36 436 361 174 722 577 NAND2XL $T=2956800 2368800 0 0 $X=2952500 $Y=2364800
X37 571 361 174 324 724 NAND2XL $T=2970000 2066400 0 0 $X=2965700 $Y=2062400
X38 579 361 174 502 436 NAND2XL $T=2989800 2368800 0 180 $X=2965700 $Y=2313000
X39 577 361 174 183 723 NAND2XL $T=2970000 2469600 1 0 $X=2965700 $Y=2413800
X40 534 361 174 437 725 NAND2XL $T=3003000 2066400 0 180 $X=2978900 $Y=2010600
X41 193 361 174 578 727 NAND2XL $T=2996400 2368800 1 0 $X=2992100 $Y=2313000
X42 193 361 174 576 726 NAND2XL $T=2996400 2469600 1 0 $X=2992100 $Y=2413800
X43 725 361 174 581 400 NAND2XL $T=3003000 2066400 1 0 $X=2998700 $Y=2010600
X44 193 361 174 729 401 NAND2XL $T=3042600 2469600 0 0 $X=3038300 $Y=2465600
X45 536 361 174 579 586 NAND2XL $T=3102000 2268000 0 0 $X=3097700 $Y=2264000
X46 318 361 174 328 587 NAND2XL $T=3128400 2469600 0 0 $X=3124100 $Y=2465600
X47 439 361 174 330 595 NAND2XL $T=3161400 2469600 1 0 $X=3157100 $Y=2413800
X48 586 361 174 593 599 NAND2XL $T=3187800 2268000 0 0 $X=3183500 $Y=2264000
X49 327 361 174 562 597 NAND2XL $T=3187800 2368800 1 0 $X=3183500 $Y=2313000
X50 519 361 174 329 601 NAND2XL $T=3194400 2066400 0 0 $X=3190100 $Y=2062400
X51 595 361 174 733 598 NAND2XL $T=3201000 2469600 1 0 $X=3196700 $Y=2413800
X52 587 361 174 600 332 NAND2XL $T=3207600 2469600 0 0 $X=3203300 $Y=2465600
X53 601 361 174 592 604 NAND2XL $T=3253800 2066400 0 180 $X=3229700 $Y=2010600
X54 604 361 174 215 763 NAND2XL $T=3273600 2066400 1 0 $X=3269300 $Y=2010600
X55 315 361 174 611 616 NAND2XL $T=3306600 2268000 0 0 $X=3302300 $Y=2264000
X56 168 361 174 221 443 NAND2XL $T=3306600 2368800 1 0 $X=3302300 $Y=2313000
X57 333 361 174 225 438 NAND2XL $T=3333000 2066400 1 180 $X=3308900 $Y=2062400
X58 227 361 174 225 572 NAND2XL $T=3366000 2066400 1 180 $X=3341900 $Y=2062400
X59 624 361 174 228 229 NAND2XL $T=3366000 2469600 1 180 $X=3341900 $Y=2465600
X60 335 361 174 225 559 NAND2XL $T=3372600 2167200 1 180 $X=3348500 $Y=2163200
X61 616 361 174 739 620 NAND2XL $T=3352800 2268000 1 0 $X=3348500 $Y=2212200
X62 201 361 174 614 623 NAND2XL $T=3379200 2469600 0 180 $X=3355100 $Y=2413800
X63 620 361 174 626 764 NAND2XL $T=3372600 2268000 1 0 $X=3368300 $Y=2212200
X64 319 361 174 612 740 NAND2XL $T=3372600 2368800 0 0 $X=3368300 $Y=2364800
X65 337 361 174 225 561 NAND2XL $T=3412200 2167200 1 180 $X=3388100 $Y=2163200
X66 630 361 174 225 558 NAND2XL $T=3438600 2167200 0 180 $X=3414500 $Y=2111400
X67 623 361 174 445 635 NAND2XL $T=3432000 2469600 0 0 $X=3427700 $Y=2465600
X68 643 361 174 225 550 NAND2XL $T=3484800 2268000 0 180 $X=3460700 $Y=2212200
X69 352 361 174 225 560 NAND2XL $T=3498000 2368800 1 0 $X=3493700 $Y=2313000
X70 634 361 174 225 189 NAND2XL $T=3498000 2368800 0 0 $X=3493700 $Y=2364800
X71 342 361 174 639 637 NAND2XL $T=3636600 2066400 1 0 $X=3632300 $Y=2010600
X72 354 361 174 654 638 NAND2XL $T=3999600 2066400 1 180 $X=3975500 $Y=2062400
X73 354 361 174 655 628 NAND2XL $T=4026000 2066400 1 180 $X=4001900 $Y=2062400
X74 354 361 174 658 648 NAND2XL $T=4045800 2469600 0 180 $X=4021700 $Y=2413800
X75 354 361 174 659 412 NAND2XL $T=4052400 2066400 1 180 $X=4028300 $Y=2062400
X76 354 361 174 661 348 NAND2XL $T=4065600 2469600 1 180 $X=4041500 $Y=2465600
X77 341 361 174 666 667 NAND2XL $T=4065600 2469600 1 0 $X=4061300 $Y=2413800
X78 354 361 174 664 355 NAND2XL $T=4085400 2469600 1 180 $X=4061300 $Y=2465600
X79 662 361 174 747 768 NAND2XL $T=4072200 2167200 1 0 $X=4067900 $Y=2111400
X80 768 361 174 671 748 NAND2XL $T=4125000 2167200 0 180 $X=4100900 $Y=2111400
X81 657 361 174 660 677 NAND2XL $T=4125000 2268000 1 180 $X=4100900 $Y=2264000
X82 674 361 174 669 767 NAND2XL $T=4151400 2469600 1 180 $X=4127300 $Y=2465600
X83 668 361 174 663 684 NAND2XL $T=4138200 2368800 1 0 $X=4133900 $Y=2313000
X84 679 361 174 670 683 NAND2XL $T=4144800 2066400 0 0 $X=4140500 $Y=2062400
X85 677 361 174 665 687 NAND2XL $T=4151400 2268000 0 0 $X=4147100 $Y=2264000
X86 672 361 174 656 681 NAND2XL $T=4164600 2268000 1 0 $X=4160300 $Y=2212200
X87 684 361 174 689 749 NAND2XL $T=4164600 2368800 1 0 $X=4160300 $Y=2313000
X88 689 361 174 754 751 NAND2XL $T=4184400 2368800 1 0 $X=4180100 $Y=2313000
X89 359 361 174 360 690 NAND2XL $T=4250400 2469600 0 0 $X=4246100 $Y=2465600
X90 689 361 174 692 769 NAND2XL $T=4276800 2368800 1 0 $X=4272500 $Y=2313000
X91 174 562 323 435 361 NOR2XL $T=2831400 2368800 1 180 $X=2807300 $Y=2364800
X92 174 330 426 434 361 NOR2XL $T=2844600 2469600 1 0 $X=2840300 $Y=2413800
X93 174 435 434 399 361 NOR2XL $T=2930400 2469600 0 0 $X=2926100 $Y=2465600
X94 174 318 328 585 361 NOR2XL $T=3088800 2469600 0 0 $X=3084500 $Y=2465600
X95 174 327 562 594 361 NOR2XL $T=3168000 2368800 1 0 $X=3163700 $Y=2313000
X96 174 209 734 606 361 NOR2XL $T=3234000 2167200 1 0 $X=3229700 $Y=2111400
X97 174 209 329 607 361 NOR2XL $T=3240600 2066400 0 0 $X=3236300 $Y=2062400
X98 174 209 611 735 361 NOR2XL $T=3240600 2268000 1 0 $X=3236300 $Y=2212200
X99 174 315 611 617 361 NOR2XL $T=3280200 2268000 0 0 $X=3275900 $Y=2264000
X100 174 209 612 736 361 NOR2XL $T=3326400 2368800 1 180 $X=3302300 $Y=2364800
X101 174 209 614 737 361 NOR2XL $T=3333000 2469600 0 180 $X=3308900 $Y=2413800
X102 174 168 221 625 361 NOR2XL $T=3326400 2368800 1 0 $X=3322100 $Y=2313000
X103 174 625 617 441 361 NOR2XL $T=3352800 2268000 1 180 $X=3328700 $Y=2264000
X104 174 201 614 444 361 NOR2XL $T=3333000 2469600 1 0 $X=3328700 $Y=2413800
X105 174 319 612 622 361 NOR2XL $T=3346200 2368800 0 0 $X=3341900 $Y=2364800
X106 174 444 622 336 361 NOR2XL $T=3372600 2469600 0 0 $X=3368300 $Y=2465600
X107 174 341 666 673 361 NOR2XL $T=4105200 2469600 1 0 $X=4100900 $Y=2413800
X108 174 672 656 676 361 NOR2XL $T=4111800 2167200 0 0 $X=4107500 $Y=2163200
X109 174 679 670 750 361 NOR2XL $T=4177800 2066400 0 0 $X=4173500 $Y=2062400
X110 174 673 690 692 361 NOR2XL $T=4250400 2469600 1 0 $X=4246100 $Y=2413800
X111 420 174 361 35 INVXL $T=257400 2167200 0 0 $X=253100 $Y=2163200
X112 18 174 361 28 INVXL $T=349800 2167200 1 0 $X=345500 $Y=2111400
X113 436 174 361 568 INVXL $T=2917200 2368800 1 180 $X=2899700 $Y=2364800
X114 190 174 361 325 INVXL $T=2950200 2469600 0 0 $X=2945900 $Y=2465600
X115 725 174 361 730 INVXL $T=3042600 2066400 1 0 $X=3038300 $Y=2010600
X116 583 174 361 574 INVXL $T=3095400 2167200 1 180 $X=3077900 $Y=2163200
X117 586 174 361 732 INVXL $T=3161400 2268000 1 0 $X=3157100 $Y=2212200
X118 595 174 361 596 INVXL $T=3187800 2469600 1 0 $X=3183500 $Y=2413800
X119 601 174 361 605 INVXL $T=3227400 2066400 0 0 $X=3223100 $Y=2062400
X120 585 174 361 600 INVXL $T=3227400 2469600 0 0 $X=3223100 $Y=2465600
X121 223 174 361 621 INVXL $T=3352800 2368800 1 0 $X=3348500 $Y=2313000
X122 617 174 361 739 INVXL $T=3359400 2268000 0 0 $X=3355100 $Y=2264000
X123 444 174 361 445 INVXL $T=3379200 2469600 1 0 $X=3374900 $Y=2413800
X124 407 174 361 627 INVXL $T=3451800 2469600 0 0 $X=3447500 $Y=2465600
X125 637 174 361 408 INVXL $T=3616800 2066400 0 180 $X=3599300 $Y=2010600
X126 768 174 361 675 INVXL $T=4125000 2167200 1 0 $X=4120700 $Y=2111400
X127 677 174 361 678 INVXL $T=4131600 2268000 0 0 $X=4127300 $Y=2264000
X128 267 174 361 417 INVXL $T=4283400 2368800 1 180 $X=4265900 $Y=2364800
X129 417 174 361 691 INVXL $T=4283400 2469600 0 180 $X=4265900 $Y=2413800
X130 563 361 435 565 174 184 OAI21XL $T=2871000 2469600 1 0 $X=2866700 $Y=2413800
X131 434 361 190 563 174 567 OAI21XL $T=2923800 2469600 1 180 $X=2893100 $Y=2465600
X132 569 361 567 762 174 576 OAI21XL $T=2937000 2469600 1 0 $X=2932700 $Y=2413800
X133 577 361 183 723 174 578 OAI21XL $T=3003000 2368800 1 180 $X=2972300 $Y=2364800
X134 585 361 210 587 174 440 OAI21XL $T=3168000 2469600 0 0 $X=3163700 $Y=2465600
X135 594 361 603 597 174 211 OAI21XL $T=3214200 2368800 0 0 $X=3209900 $Y=2364800
X136 215 361 604 763 174 619 OAI21XL $T=3313200 2066400 1 0 $X=3308900 $Y=2010600
X137 443 361 617 616 174 738 OAI21XL $T=3346200 2268000 0 180 $X=3315500 $Y=2212200
X138 230 361 619 442 174 334 OAI21XL $T=3339600 2066400 1 0 $X=3335300 $Y=2010600
X139 230 361 765 615 174 405 OAI21XL $T=3379200 2167200 1 0 $X=3374900 $Y=2111400
X140 625 361 621 443 174 626 OAI21XL $T=3379200 2268000 0 0 $X=3374900 $Y=2264000
X141 620 361 626 764 174 742 OAI21XL $T=3399000 2268000 1 0 $X=3394700 $Y=2212200
X142 623 361 622 740 174 624 OAI21XL $T=3425400 2469600 0 180 $X=3394700 $Y=2413800
X143 230 361 742 613 174 631 OAI21XL $T=3432000 2167200 0 0 $X=3427700 $Y=2163200
X144 230 361 743 218 174 629 OAI21XL $T=3458400 2268000 1 180 $X=3427700 $Y=2264000
X145 230 361 746 610 174 633 OAI21XL $T=3465000 2368800 1 0 $X=3460700 $Y=2313000
X146 230 361 766 618 174 636 OAI21XL $T=3544200 2469600 1 0 $X=3539900 $Y=2413800
X147 674 361 669 767 174 658 OAI21XL $T=4118400 2469600 1 180 $X=4087700 $Y=2465600
X148 676 361 680 681 174 446 OAI21XL $T=4171200 2167200 1 180 $X=4140500 $Y=2163200
X149 750 361 682 683 174 414 OAI21XL $T=4191000 2066400 1 0 $X=4186700 $Y=2010600
X150 673 361 752 667 174 754 OAI21XL $T=4230600 2368800 1 180 $X=4199900 $Y=2364800
X151 690 361 691 752 174 669 OAI21XL $T=4237200 2469600 0 180 $X=4206500 $Y=2413800
X152 581 402 174 730 770 361 584 AOI21XL $T=3069000 2066400 0 0 $X=3064700 $Y=2062400
X153 593 440 174 732 771 361 206 AOI21XL $T=3214200 2268000 0 180 $X=3183500 $Y=2212200
X154 733 213 174 596 772 361 603 AOI21XL $T=3220800 2469600 1 0 $X=3216500 $Y=2413800
X155 332 210 174 404 773 361 221 AOI21XL $T=3253800 2469600 0 0 $X=3249500 $Y=2465600
X156 592 215 174 605 774 361 609 AOI21XL $T=3267000 2066400 0 0 $X=3262700 $Y=2062400
X157 223 441 174 738 775 361 217 AOI21XL $T=3346200 2167200 1 180 $X=3315500 $Y=2163200
X158 336 627 174 624 776 361 406 AOI21XL $T=3399000 2469600 0 0 $X=3394700 $Y=2465600
X159 671 446 174 675 777 361 682 AOI21XL $T=4144800 2167200 1 0 $X=4140500 $Y=2111400
X160 665 688 174 678 778 361 680 AOI21XL $T=4177800 2268000 0 0 $X=4173500 $Y=2264000
X161 359 413 174 358 779 361 752 AOI21XL $T=4177800 2469600 1 0 $X=4173500 $Y=2413800
X162 692 417 174 754 780 361 686 AOI21XL $T=4257000 2368800 1 180 $X=4226300 $Y=2364800
X163 43 271 782 781 273 783 450 361 784 174 DFFSXL $T=0 2167200 1 0 $X=-4300 $Y=2111400
X164 43 4 786 785 273 787 447 361 788 174 DFFSXL $T=0 2368800 1 0 $X=-4300 $Y=2313000
X165 43 26 790 789 273 791 448 361 792 174 DFFSXL $T=6600 2066400 0 0 $X=2300 $Y=2062400
X166 274 270 794 793 273 795 693 361 796 174 DFFSXL $T=6600 2469600 1 0 $X=2300 $Y=2413800
X167 274 61 798 797 273 799 694 361 800 174 DFFSXL $T=6600 2469600 0 0 $X=2300 $Y=2465600
X168 274 4 802 801 273 803 755 361 804 174 DFFSXL $T=99000 2268000 0 0 $X=94700 $Y=2264000
X169 274 272 272 805 273 806 451 361 807 174 DFFSXL $T=105600 2066400 1 0 $X=101300 $Y=2010600
X170 274 26 809 808 273 810 454 361 811 174 DFFSXL $T=132000 2066400 0 0 $X=127700 $Y=2062400
X171 276 271 813 812 273 814 461 361 815 174 DFFSXL $T=224400 2368800 0 0 $X=220100 $Y=2364800
X172 276 270 270 816 273 817 462 361 818 174 DFFSXL $T=231000 2368800 1 0 $X=226700 $Y=2313000
X173 25 4 820 819 273 821 421 361 822 174 DFFSXL $T=369600 2268000 1 0 $X=365300 $Y=2212200
X174 276 33 824 823 273 825 465 361 826 174 DFFSXL $T=389400 2469600 1 0 $X=385100 $Y=2413800
X175 44 4 828 827 273 829 38 361 830 174 DFFSXL $T=514800 2268000 0 0 $X=510500 $Y=2264000
X176 25 270 832 831 174 833 422 361 834 174 DFFSXL $T=574200 2167200 0 0 $X=569900 $Y=2163200
X177 43 31 836 835 174 837 284 361 838 174 DFFSXL $T=580800 2066400 1 0 $X=576500 $Y=2010600
X178 43 64 840 839 174 841 698 361 842 174 DFFSXL $T=666600 2167200 1 0 $X=662300 $Y=2111400
X179 44 64 844 843 174 845 474 361 846 174 DFFSXL $T=739200 2469600 0 0 $X=734900 $Y=2465600
X180 285 102 848 847 174 849 478 361 850 174 DFFSXL $T=871200 2469600 1 0 $X=866900 $Y=2413800
X181 285 288 852 851 174 853 477 361 854 174 DFFSXL $T=884400 2368800 0 0 $X=880100 $Y=2364800
X182 285 290 856 855 174 857 480 361 858 174 DFFSXL $T=924000 2167200 1 0 $X=919700 $Y=2111400
X183 285 152 860 859 174 861 699 361 862 174 DFFSXL $T=943800 2268000 1 0 $X=939500 $Y=2212200
X184 2 152 864 863 291 865 483 361 866 174 DFFSXL $T=963600 2066400 1 0 $X=959300 $Y=2010600
X185 52 152 152 867 174 868 700 361 869 174 DFFSXL $T=983400 2368800 1 0 $X=979100 $Y=2313000
X186 52 288 288 870 174 871 484 361 872 174 DFFSXL $T=983400 2469600 0 0 $X=979100 $Y=2465600
X187 50 152 874 873 174 875 704 361 876 174 DFFSXL $T=1075800 2469600 1 0 $X=1071500 $Y=2413800
X188 95 64 878 877 174 879 373 361 880 174 DFFSXL $T=1122000 2469600 0 0 $X=1117700 $Y=2465600
X189 95 33 882 881 174 883 71 361 884 174 DFFSXL $T=1207800 2368800 0 0 $X=1203500 $Y=2364800
X190 84 65 65 885 174 886 296 361 887 174 DFFSXL $T=1234200 2268000 0 0 $X=1229900 $Y=2264000
X191 84 288 889 888 174 890 496 361 891 174 DFFSXL $T=1247400 2469600 0 0 $X=1243100 $Y=2465600
X192 95 90 90 892 142 893 500 361 894 174 DFFSXL $T=1359600 2368800 1 0 $X=1355300 $Y=2313000
X193 94 288 896 895 142 897 427 361 898 174 DFFSXL $T=1478400 2469600 0 0 $X=1474100 $Y=2465600
X194 94 90 900 899 142 901 428 361 902 174 DFFSXL $T=1544400 2268000 0 0 $X=1540100 $Y=2264000
X195 105 290 290 903 142 904 508 361 905 174 DFFSXL $T=1610400 2469600 1 0 $X=1606100 $Y=2413800
X196 105 90 907 906 142 908 514 361 909 174 DFFSXL $T=1676400 2268000 1 0 $X=1672100 $Y=2212200
X197 116 118 911 910 142 912 302 361 913 174 DFFSXL $T=1676400 2368800 1 0 $X=1672100 $Y=2313000
X198 105 288 915 914 142 916 512 361 917 174 DFFSXL $T=1683000 2167200 1 0 $X=1678700 $Y=2111400
X199 116 288 919 918 142 920 304 361 921 174 DFFSXL $T=1689600 2469600 0 0 $X=1685300 $Y=2465600
X200 105 100 923 922 142 924 513 361 925 174 DFFSXL $T=1716000 2066400 0 0 $X=1711700 $Y=2062400
X201 94 381 927 926 142 928 382 361 929 174 DFFSXL $T=1729200 2066400 1 0 $X=1724900 $Y=2010600
X202 121 270 931 930 142 932 385 361 933 174 DFFSXL $T=1788600 2469600 1 0 $X=1784300 $Y=2413800
X203 121 100 935 934 142 936 517 361 937 174 DFFSXL $T=1801800 2268000 1 0 $X=1797500 $Y=2212200
X204 121 152 939 938 142 940 430 361 941 174 DFFSXL $T=1801800 2368800 1 0 $X=1797500 $Y=2313000
X205 124 152 943 942 142 944 518 361 945 174 DFFSXL $T=1887600 2268000 0 0 $X=1883300 $Y=2264000
X206 124 100 947 946 142 948 137 361 949 174 DFFSXL $T=1900800 2167200 0 0 $X=1896500 $Y=2163200
X207 134 100 951 950 142 952 389 361 953 174 DFFSXL $T=2006400 2066400 1 0 $X=2002100 $Y=2010600
X208 139 126 955 954 155 956 144 361 957 174 DFFSXL $T=2032800 2368800 1 0 $X=2028500 $Y=2313000
X209 139 290 959 958 155 960 532 361 533 174 DFFSXL $T=2052600 2368800 0 0 $X=2048300 $Y=2364800
X210 134 102 962 961 155 963 524 361 964 174 DFFSXL $T=2105400 2469600 0 0 $X=2101100 $Y=2465600
X211 139 152 966 965 155 967 310 361 968 174 DFFSXL $T=2178000 2268000 1 0 $X=2173700 $Y=2212200
X212 134 152 970 969 155 971 527 361 972 174 DFFSXL $T=2184600 2167200 0 0 $X=2180300 $Y=2163200
X213 134 288 974 973 155 975 392 361 976 174 DFFSXL $T=2211000 2469600 1 0 $X=2206700 $Y=2413800
X214 159 100 978 977 174 979 538 361 980 174 DFFSXL $T=2250600 2066400 1 0 $X=2246300 $Y=2010600
X215 139 5 982 981 155 983 162 361 984 174 DFFSXL $T=2310000 2167200 0 0 $X=2305700 $Y=2163200
X216 165 539 986 985 155 987 542 361 988 174 DFFSXL $T=2343000 2469600 0 0 $X=2338700 $Y=2465600
X217 165 544 990 989 155 991 395 361 992 174 DFFSXL $T=2415600 2368800 1 0 $X=2411300 $Y=2313000
X218 165 546 994 993 155 995 540 361 996 174 DFFSXL $T=2541000 2268000 1 0 $X=2536700 $Y=2212200
X219 165 321 998 997 174 999 543 361 1000 174 DFFSXL $T=2600400 2066400 1 0 $X=2596100 $Y=2010600
X220 165 548 1002 1001 174 1003 552 361 1004 174 DFFSXL $T=2633400 2368800 0 0 $X=2629100 $Y=2364800
X221 173 438 1006 1005 155 1007 551 361 1008 174 DFFSXL $T=2686200 2268000 1 0 $X=2681900 $Y=2212200
X222 165 553 1010 1009 174 1011 175 361 1012 174 DFFSXL $T=2699400 2469600 0 0 $X=2695100 $Y=2465600
X223 173 220 1014 1013 174 1015 720 361 1016 174 DFFSXL $T=2745600 2066400 1 0 $X=2741300 $Y=2010600
X224 173 558 1018 1017 174 1019 556 361 1020 174 DFFSXL $T=2798400 2167200 1 0 $X=2794100 $Y=2111400
X225 173 560 1022 1021 155 1023 433 361 1024 174 DFFSXL $T=2805000 2368800 1 0 $X=2800700 $Y=2313000
X226 173 561 1026 1025 174 1027 564 361 1028 174 DFFSXL $T=2811600 2167200 0 0 $X=2807300 $Y=2163200
X227 195 726 1030 1029 174 1031 562 361 591 174 DFFSXL $T=3029400 2469600 1 0 $X=3025100 $Y=2413800
X228 195 580 1033 1032 174 1034 437 361 588 174 DFFSXL $T=3036000 2167200 1 0 $X=3031700 $Y=2111400
X229 195 728 1036 1035 174 1037 582 361 589 174 DFFSXL $T=3036000 2268000 1 0 $X=3031700 $Y=2212200
X230 195 727 1039 1038 174 1040 579 361 590 174 DFFSXL $T=3036000 2368800 1 0 $X=3031700 $Y=2313000
X231 195 326 1042 1041 174 1043 203 361 212 174 DFFSXL $T=3042600 2368800 0 0 $X=3038300 $Y=2364800
X232 195 198 1045 1044 338 1046 204 361 403 174 DFFSXL $T=3095400 2066400 1 0 $X=3091100 $Y=2010600
X233 233 632 1048 1047 338 1049 639 361 1050 174 DFFSXL $T=3451800 2167200 1 0 $X=3447500 $Y=2111400
X234 340 636 1052 1051 339 1053 640 361 1054 174 DFFSXL $T=3491400 2268000 0 0 $X=3487100 $Y=2264000
X235 340 633 1056 1055 339 1057 641 361 1058 174 DFFSXL $T=3511200 2268000 1 0 $X=3506900 $Y=2212200
X236 340 226 1060 1059 339 1061 642 361 1062 174 DFFSXL $T=3517800 2368800 0 0 $X=3513500 $Y=2364800
X237 340 344 1064 1063 339 1065 650 361 1066 174 DFFSXL $T=3570600 2368800 1 0 $X=3566300 $Y=2313000
X238 246 636 1068 1067 339 1069 644 361 1070 174 DFFSXL $T=3570600 2469600 0 0 $X=3566300 $Y=2465600
X239 246 633 1072 1071 339 1073 646 361 1074 174 DFFSXL $T=3636600 2268000 0 0 $X=3632300 $Y=2264000
X240 246 344 1076 1075 339 1077 647 361 1078 174 DFFSXL $T=3649800 2469600 1 0 $X=3645500 $Y=2413800
X241 340 409 1080 1079 338 1081 410 361 1082 174 DFFSXL $T=3702600 2066400 1 0 $X=3698300 $Y=2010600
X242 250 648 1084 1083 339 1085 634 361 1086 174 DFFSXL $T=3755400 2469600 0 0 $X=3751100 $Y=2465600
X243 246 346 1088 1087 339 1089 349 361 1090 174 DFFSXL $T=3768600 2167200 0 0 $X=3764300 $Y=2163200
X244 340 631 1092 1091 338 1093 653 361 1094 174 DFFSXL $T=3854400 2066400 0 0 $X=3850100 $Y=2062400
X245 246 345 1096 1095 339 1097 353 361 1098 174 DFFSXL $T=3887400 2469600 1 0 $X=3883100 $Y=2413800
X246 434 361 563 1099 174 566 NAND2BXL $T=2857800 2469600 0 0 $X=2853500 $Y=2465600
X247 435 361 565 565 174 569 NAND2BXL $T=2864400 2368800 0 0 $X=2860100 $Y=2364800
X248 594 361 597 1100 174 602 NAND2BXL $T=3214200 2368800 1 0 $X=3209900 $Y=2313000
X249 625 361 443 1101 174 741 NAND2BXL $T=3372600 2368800 1 0 $X=3368300 $Y=2313000
X250 673 361 667 1102 174 674 NAND2BXL $T=4164600 2469600 0 180 $X=4133900 $Y=2413800
X251 676 361 681 1103 174 753 NAND2BXL $T=4191000 2167200 0 0 $X=4186700 $Y=2163200
X252 750 361 683 1104 174 685 NAND2BXL $T=4204200 2066400 0 0 $X=4199900 $Y=2062400
X253 741 621 361 174 743 XOR2XL $T=3405600 2368800 1 0 $X=3401300 $Y=2313000
X254 685 682 361 174 356 XOR2XL $T=4184400 2066400 0 180 $X=4127300 $Y=2010600
X255 749 686 361 174 661 XOR2XL $T=4191000 2368800 1 180 $X=4133900 $Y=2364800
X256 753 680 361 174 654 XOR2XL $T=4230600 2167200 0 180 $X=4173500 $Y=2111400
X257 416 415 361 174 664 XOR2XL $T=4237200 2469600 1 180 $X=4180100 $Y=2465600
X258 651 653 1106 337 1105 1107 1108 357 361 174 670 CMPR32X1 $T=3979800 2066400 1 0 $X=3975500 $Y=2010600
X259 646 641 1110 350 1109 1111 1112 672 361 174 660 CMPR32X1 $T=4012800 2268000 1 0 $X=4008500 $Y=2212200
X260 722 183 174 568 187 361 AOI21X1 $T=2943600 2368800 1 180 $X=2912900 $Y=2364800
X261 582 506 361 174 583 XOR2X1 $T=3003000 2167200 0 0 $X=2998700 $Y=2163200
X262 731 584 361 174 734 XOR2X1 $T=3174600 2167200 1 0 $X=3170300 $Y=2111400
X263 602 603 361 174 612 XOR2X1 $T=3247200 2368800 1 0 $X=3242900 $Y=2313000
X264 608 609 361 174 765 XOR2X1 $T=3306600 2167200 1 0 $X=3302300 $Y=2111400
X265 744 745 361 174 746 XOR2X1 $T=3438600 2368800 0 0 $X=3434300 $Y=2364800
X266 591 205 174 216 361 736 610 AOI211XL $T=3260400 2368800 0 0 $X=3256100 $Y=2364800
X267 588 205 174 216 361 607 442 AOI211XL $T=3267000 2167200 1 0 $X=3262700 $Y=2111400
X268 589 205 174 216 361 606 615 AOI211XL $T=3273600 2167200 0 0 $X=3269300 $Y=2163200
X269 590 205 174 216 361 735 613 AOI211XL $T=3273600 2268000 1 0 $X=3269300 $Y=2212200
X270 331 205 174 216 361 737 618 AOI211XL $T=3300000 2469600 0 0 $X=3295700 $Y=2465600
X271 599 440 361 174 611 XNOR2X1 $T=3220800 2268000 0 0 $X=3216500 $Y=2264000
X272 598 213 361 174 614 XNOR2X1 $T=3253800 2469600 1 0 $X=3249500 $Y=2413800
X273 502 579 361 174 722 OR2XL $T=2963400 2368800 0 180 $X=2932700 $Y=2313000
X274 322 437 361 174 573 OR2XL $T=2943600 2066400 1 0 $X=2939300 $Y=2010600
X275 437 534 361 174 581 OR2XL $T=3022800 2066400 0 0 $X=3018500 $Y=2062400
X276 329 519 361 174 592 OR2XL $T=3141600 2066400 0 0 $X=3137300 $Y=2062400
X277 579 536 361 174 593 OR2XL $T=3148200 2268000 0 0 $X=3143900 $Y=2264000
X278 330 439 361 174 733 OR2XL $T=3181200 2368800 0 0 $X=3176900 $Y=2364800
X279 660 657 361 174 665 OR2XL $T=4052400 2268000 0 0 $X=4048100 $Y=2264000
X280 747 662 361 174 671 OR2XL $T=4072200 2167200 0 0 $X=4067900 $Y=2163200
X281 663 668 361 174 689 OR2XL $T=4078800 2368800 1 0 $X=4074500 $Y=2313000
X282 566 1113 325 361 174 729 XNOR2XL $T=2970000 2469600 0 0 $X=2965700 $Y=2465600
X283 533 1114 589 361 174 731 XNOR2XL $T=3154800 2167200 0 0 $X=3150500 $Y=2163200
X284 531 1115 734 361 174 608 XNOR2XL $T=3214200 2167200 0 0 $X=3209900 $Y=2163200
X285 635 1116 627 361 174 766 XNOR2XL $T=3478200 2469600 1 0 $X=3473900 $Y=2413800
X286 748 1117 446 361 174 655 XNOR2XL $T=4118400 2066400 1 180 $X=4061300 $Y=2062400
X287 687 1118 688 361 174 659 XNOR2XL $T=4204200 2268000 1 0 $X=4199900 $Y=2212200
X288 9 448 452 361 62 174 OAI2BB1XL $T=250800 2167200 0 180 $X=213500 $Y=2111400
X289 66 477 701 361 293 174 OAI2BB1XL $T=1128600 2368800 1 180 $X=1091300 $Y=2364800
X290 66 479 488 361 371 174 OAI2BB1XL $T=1174800 2167200 1 0 $X=1170500 $Y=2111400
X291 324 573 570 361 721 174 OAI2BB1XL $T=2970000 2167200 0 180 $X=2932700 $Y=2111400
X292 627 445 623 361 745 174 OAI2BB1XL $T=3438600 2469600 1 0 $X=3434300 $Y=2413800
X293 361 174 43 61 1119 1120 273 419 1121 274 271 1122 273 453 1123 ICV_1 $T=0 2167200 0 0 $X=-4300 $Y=2163200
X294 361 174 43 270 1124 1125 273 418 1126 276 4 1127 273 455 1128 ICV_1 $T=0 2268000 1 0 $X=-4300 $Y=2212200
X295 361 174 276 61 1129 1130 273 456 1131 276 30 1132 273 281 1133 ICV_1 $T=132000 2469600 1 0 $X=127700 $Y=2413800
X296 361 174 25 16 1134 1135 273 363 1136 25 26 1137 174 459 1138 ICV_1 $T=310200 2167200 0 0 $X=305900 $Y=2163200
X297 361 174 25 272 1139 1140 174 458 1141 25 30 1142 174 466 1143 ICV_1 $T=323400 2066400 0 0 $X=319100 $Y=2062400
X298 361 174 276 64 1144 1145 273 464 1146 44 283 1147 273 21 1148 ICV_1 $T=369600 2368800 1 0 $X=365300 $Y=2313000
X299 361 174 25 283 1149 1150 174 460 1151 44 31 1152 174 22 1153 ICV_1 $T=409200 2167200 1 0 $X=404900 $Y=2111400
X300 361 174 43 33 1154 1155 273 696 1156 43 30 30 367 368 1157 ICV_1 $T=475200 2469600 0 0 $X=470900 $Y=2465600
X301 361 174 43 102 1158 1159 367 470 1160 44 126 1161 174 57 1162 ICV_1 $T=613800 2469600 1 0 $X=609500 $Y=2413800
X302 361 174 44 102 1163 1164 174 286 1165 44 152 1166 174 481 1167 ICV_1 $T=666600 2066400 0 0 $X=662300 $Y=2062400
X303 361 174 43 288 1168 1169 174 471 1170 2 102 1171 174 476 1172 ICV_1 $T=673200 2268000 0 0 $X=668900 $Y=2264000
X304 361 174 25 64 1173 1174 174 468 1175 25 61 1176 174 467 1177 ICV_1 $T=679800 2268000 1 0 $X=675500 $Y=2212200
X305 361 174 285 91 1178 1179 174 479 1180 25 100 1181 174 72 1182 ICV_1 $T=917400 2167200 0 0 $X=913100 $Y=2163200
X306 361 174 84 90 1183 1184 291 710 1185 92 90 1186 142 499 1187 ICV_1 $T=1313400 2268000 1 0 $X=1309100 $Y=2212200
X307 361 174 95 288 1188 1189 142 507 1190 92 288 1191 142 511 1192 ICV_1 $T=1452000 2066400 0 0 $X=1447700 $Y=2062400
X308 361 174 159 290 1193 1194 174 537 1195 163 290 290 174 531 1196 ICV_1 $T=2349600 2469600 1 0 $X=2345300 $Y=2413800
X309 361 174 163 100 1197 1198 155 519 1199 165 547 1200 174 549 1201 ICV_1 $T=2488200 2066400 0 0 $X=2483900 $Y=2062400
X310 361 174 165 719 1202 1203 155 541 1204 173 550 1205 155 554 1206 ICV_1 $T=2541000 2268000 0 0 $X=2536700 $Y=2264000
X311 361 174 173 559 1207 1208 174 557 1209 173 572 1210 174 555 1211 ICV_1 $T=2805000 2268000 0 0 $X=2800700 $Y=2264000
X312 361 174 233 628 1212 1213 338 630 1214 233 638 1215 338 643 1216 ICV_1 $T=3412200 2066400 0 0 $X=3407900 $Y=2062400
X313 361 174 340 346 1217 1218 339 347 1219 246 631 1220 339 651 1221 ICV_1 $T=3643200 2167200 1 0 $X=3638900 $Y=2111400
X314 361 174 246 226 1222 1223 339 649 1224 246 343 1225 339 351 1226 ICV_1 $T=3709200 2368800 0 0 $X=3704900 $Y=2364800
X315 12 13 174 454 24 15 459 452 361 AOI222XL $T=264000 2167200 1 0 $X=259700 $Y=2111400
X316 66 480 174 706 70 83 707 494 361 AOI222XL $T=1221000 2167200 1 0 $X=1216700 $Y=2111400
X317 110 300 174 295 83 111 104 492 361 AOI222XL $T=1392600 2469600 1 0 $X=1388300 $Y=2413800
X318 97 710 174 499 111 97 500 501 361 AOI222XL $T=1419000 2268000 0 0 $X=1414700 $Y=2264000
X319 111 376 174 497 97 97 713 714 361 AOI222XL $T=1537800 2368800 1 180 $X=1480700 $Y=2364800
X320 97 377 174 715 97 97 711 375 361 AOI222XL $T=1570800 2066400 0 180 $X=1513700 $Y=2010600
X321 111 511 174 496 97 97 507 503 361 AOI222XL $T=1623600 2167200 1 180 $X=1566500 $Y=2163200
X322 148 310 174 527 138 74 491 481 361 AOI222X1 $T=2092200 2167200 1 180 $X=2035100 $Y=2163200
X323 473 361 469 174 472 287 NAND3XL $T=858000 2368800 1 180 $X=827300 $Y=2364800
X324 702 361 485 174 294 486 NAND3XL $T=1122000 2268000 1 0 $X=1117700 $Y=2212200
X325 425 361 491 174 705 490 NAND3XL $T=1188000 2167200 0 0 $X=1183700 $Y=2163200
X326 298 361 482 174 492 493 NAND3XL $T=1221000 2469600 1 0 $X=1216700 $Y=2413800
X327 708 361 85 174 709 299 NAND3XL $T=1313400 2469600 1 0 $X=1309100 $Y=2413800
X328 503 361 504 174 423 502 NAND3XL $T=1511400 2268000 1 180 $X=1480700 $Y=2264000
X329 714 361 757 174 103 712 NAND3XL $T=1511400 2368800 0 180 $X=1480700 $Y=2313000
X330 501 361 505 174 81 426 NAND3XL $T=1518000 2268000 0 0 $X=1513700 $Y=2264000
X331 387 361 718 174 311 498 NAND3XL $T=2079000 2469600 0 180 $X=2048300 $Y=2413800
X332 530 361 388 174 758 516 NAND3XL $T=2118600 2469600 0 180 $X=2087900 $Y=2413800
X333 760 361 526 174 528 312 NAND3XL $T=2118600 2167200 1 0 $X=2114300 $Y=2111400
X334 418 174 9 24 693 449 361 AOI22XL $T=92400 2368800 0 0 $X=88100 $Y=2364800
X335 275 174 9 12 11 420 361 AOI22XL $T=250800 2066400 1 0 $X=246500 $Y=2010600
X336 755 174 24 9 447 457 361 AOI22XL $T=250800 2268000 0 0 $X=246500 $Y=2264000
X337 10 174 24 15 460 280 361 AOI22XL $T=290400 2268000 0 0 $X=286100 $Y=2264000
X338 277 174 24 15 279 362 361 AOI22XL $T=297000 2066400 1 0 $X=292700 $Y=2010600
X339 455 174 12 15 421 695 361 AOI22XL $T=343200 2268000 0 0 $X=338900 $Y=2264000
X340 365 174 15 12 461 32 361 AOI22XL $T=422400 2268000 1 180 $X=385100 $Y=2264000
X341 278 174 69 63 56 282 361 AOI22XL $T=415800 2469600 0 0 $X=411500 $Y=2465600
X342 462 174 12 15 422 463 361 AOI22XL $T=435600 2368800 0 0 $X=431300 $Y=2364800
X343 465 174 12 9 696 697 361 AOI22XL $T=508200 2368800 0 0 $X=503900 $Y=2364800
X344 456 174 12 15 467 41 361 AOI22XL $T=554400 2368800 0 0 $X=550100 $Y=2364800
X345 464 174 12 15 468 469 361 AOI22XL $T=640200 2368800 1 0 $X=635900 $Y=2313000
X346 60 174 24 9 698 472 361 AOI22XL $T=752400 2066400 1 0 $X=748100 $Y=2010600
X347 370 174 69 289 474 473 361 AOI22XL $T=930600 2469600 1 180 $X=893300 $Y=2465600
X348 470 174 77 66 478 482 361 AOI22XL $T=1009800 2469600 1 0 $X=1005500 $Y=2413800
X349 471 174 77 63 484 701 361 AOI22XL $T=1049400 2368800 0 0 $X=1045100 $Y=2364800
X350 699 174 66 63 700 702 361 AOI22XL $T=1082400 2268000 0 0 $X=1078100 $Y=2264000
X351 475 174 74 70 487 488 361 AOI22XL $T=1128600 2167200 1 0 $X=1124300 $Y=2111400
X352 509 174 97 301 508 757 361 AOI22XL $T=1597200 2368800 0 180 $X=1559900 $Y=2313000
X353 427 174 97 301 512 504 361 AOI22XL $T=1623600 2268000 1 0 $X=1619300 $Y=2212200
X354 428 174 97 301 514 505 361 AOI22XL $T=1650000 2167200 0 0 $X=1645700 $Y=2163200
X355 307 174 309 132 716 384 361 AOI22XL $T=1927200 2066400 0 180 $X=1889900 $Y=2010600
X356 519 174 313 132 517 717 361 AOI22XL $T=1986600 2167200 0 180 $X=1949300 $Y=2111400
X357 521 174 309 138 525 522 361 AOI22XL $T=1999800 2469600 1 0 $X=1995500 $Y=2413800
X358 431 174 309 138 523 526 361 AOI22XL $T=2039400 2167200 1 0 $X=2035100 $Y=2111400
X359 386 174 309 138 524 718 361 AOI22XL $T=2039400 2469600 0 0 $X=2035100 $Y=2465600
X360 201 174 313 132 135 528 361 AOI22XL $T=2112000 2167200 0 180 $X=2074700 $Y=2111400
X361 531 174 313 132 432 759 361 AOI22XL $T=2164800 2268000 0 180 $X=2127500 $Y=2212200
X362 315 174 313 132 306 758 361 AOI22XL $T=2171400 2469600 0 180 $X=2134100 $Y=2413800
X363 538 174 314 148 534 520 361 AOI22XL $T=2178000 2066400 0 180 $X=2140700 $Y=2010600
X364 390 174 314 148 439 760 361 AOI22XL $T=2197800 2167200 0 180 $X=2160500 $Y=2111400
X365 537 174 314 148 532 529 361 AOI22XL $T=2296800 2368800 0 180 $X=2259500 $Y=2313000
X366 317 174 314 148 536 530 361 AOI22XL $T=2296800 2469600 1 180 $X=2259500 $Y=2465600
X367 489 361 76 424 703 40 174 NAND4XL $T=1168200 2268000 1 180 $X=1130900 $Y=2264000
X368 51 361 429 494 495 374 174 NAND4XL $T=1287000 2066400 1 0 $X=1282700 $Y=2010600
X369 379 361 378 510 380 67 174 NAND4XL $T=1590600 2066400 1 0 $X=1586300 $Y=2010600
X370 520 717 308 361 174 1227 82 AND3XL $T=1986600 2066400 0 180 $X=1949300 $Y=2010600
X371 759 522 529 361 174 1228 429 AND3XL $T=2125200 2268000 0 180 $X=2087900 $Y=2212200
X372 14 273 174 361 CLKINVX4 $T=363000 2268000 0 180 $X=332300 $Y=2212200
X373 14 20 174 361 CLKINVX4 $T=349800 2066400 1 0 $X=345500 $Y=2010600
X374 14 174 174 361 CLKINVX4 $T=976800 2268000 1 180 $X=946100 $Y=2264000
X375 222 155 174 361 CLKINVX4 $T=2739000 2167200 0 180 $X=2708300 $Y=2111400
X376 222 338 174 361 CLKINVX4 $T=3379200 2066400 0 0 $X=3374900 $Y=2062400
X377 222 339 174 361 CLKINVX4 $T=3478200 2167200 0 0 $X=3473900 $Y=2163200
X378 515 174 361 112 CLKBUFX2 $T=1656600 2469600 1 180 $X=1625900 $Y=2465600
X379 535 174 361 147 CLKBUFX2 $T=2217600 2268000 1 180 $X=2186900 $Y=2264000
X380 177 174 361 176 CLKBUFX2 $T=2778600 2167200 1 180 $X=2747900 $Y=2163200
X381 49 174 55 1229 361 756 AND2X2 $T=739200 2368800 0 0 $X=734900 $Y=2364800
X382 161 174 154 1230 361 761 AND2X2 $T=2481600 2368800 0 0 $X=2477300 $Y=2364800
X383 697 361 174 36 BUFX1 $T=541200 2469600 1 0 $X=536900 $Y=2413800
X384 396 361 174 319 BUFX1 $T=2560800 2066400 0 180 $X=2530100 $Y=2010600
X385 419 9 174 24 694 6 361 AOI22X1 $T=138600 2368800 1 0 $X=134300 $Y=2313000
X386 451 24 174 15 458 27 361 AOI22X1 $T=264000 2066400 0 0 $X=259700 $Y=2062400
X387 476 70 174 97 88 708 361 AOI22X1 $T=1267200 2469600 1 0 $X=1262900 $Y=2413800
X388 518 309 174 132 430 485 361 AOI22X1 $T=1966800 2268000 1 0 $X=1962500 $Y=2212200
X389 650 647 643 662 174 361 656 ADDFHXL $T=3854400 2268000 1 0 $X=3850100 $Y=2212200
X390 640 644 352 657 174 361 663 ADDFHXL $T=3900600 2368800 1 0 $X=3896300 $Y=2313000
X391 645 652 630 679 174 361 747 ADDFHXL $T=3913800 2167200 0 0 $X=3909500 $Y=2163200
X392 642 649 634 668 174 361 666 ADDFHXL $T=3979800 2368800 0 0 $X=3975500 $Y=2364800
X393 44 91 1231 174 1232 475 361 1233 174 DFFSX1 $T=785400 2167200 0 0 $X=781100 $Y=2163200
X394 2 90 1234 174 1235 369 361 1236 174 DFFSX1 $T=825000 2066400 1 0 $X=820700 $Y=2010600
X395 2 290 1237 291 1238 706 361 1239 174 DFFSX1 $T=1102200 2066400 1 0 $X=1097900 $Y=2010600
X396 2 91 1240 291 1241 487 361 1242 174 DFFSX1 $T=1141800 2066400 0 0 $X=1137500 $Y=2062400
X397 50 290 1243 174 1244 707 361 1245 174 DFFSX1 $T=1181400 2268000 1 0 $X=1177100 $Y=2212200
X398 84 33 1246 174 1247 73 361 1248 174 DFFSX1 $T=1227600 2368800 1 0 $X=1223300 $Y=2313000
X399 84 290 1249 291 1250 497 361 1251 174 DFFSX1 $T=1280400 2167200 1 0 $X=1276100 $Y=2111400
X400 84 91 1252 291 1253 711 361 1254 174 DFFSX1 $T=1320000 2066400 0 0 $X=1315700 $Y=2062400
X401 95 290 1255 142 1256 713 361 1257 174 DFFSX1 $T=1353000 2368800 0 0 $X=1348700 $Y=2364800
X402 95 91 1258 291 1259 715 361 1260 174 DFFSX1 $T=1412400 2167200 1 0 $X=1408100 $Y=2111400
X403 94 290 1261 142 1262 509 361 1263 174 DFFSX1 $T=1544400 2368800 0 0 $X=1540100 $Y=2364800
X404 92 91 1264 291 1265 303 361 1266 174 DFFSX1 $T=1551000 2167200 1 0 $X=1546700 $Y=2111400
X405 116 109 1267 142 1268 515 361 1269 174 DFFSX1 $T=1669800 2368800 0 0 $X=1665500 $Y=2364800
X406 84 64 1270 142 1271 125 361 1272 174 DFFSX1 $T=1762200 2167200 0 0 $X=1757900 $Y=2163200
X407 121 91 1273 142 1274 716 361 1275 174 DFFSX1 $T=1815000 2167200 1 0 $X=1810700 $Y=2111400
X408 124 90 1276 142 1277 431 361 1278 174 DFFSX1 $T=1894200 2469600 0 0 $X=1889900 $Y=2465600
X409 124 290 1279 142 1280 521 361 1281 174 DFFSX1 $T=1914000 2368800 0 0 $X=1909700 $Y=2364800
X410 121 290 1282 155 1283 432 361 1284 174 DFFSX1 $T=1940400 2066400 0 0 $X=1936100 $Y=2062400
X411 139 90 1285 155 1286 439 361 1287 174 DFFSX1 $T=2046000 2268000 0 0 $X=2041700 $Y=2264000
X412 134 90 1288 155 1289 523 361 1290 174 DFFSX1 $T=2072400 2066400 0 0 $X=2068100 $Y=2062400
X413 134 290 1291 155 1292 525 361 1293 174 DFFSX1 $T=2184600 2368800 0 0 $X=2180300 $Y=2364800
X414 151 316 1294 155 1295 535 361 1296 174 DFFSX1 $T=2204400 2066400 0 0 $X=2200100 $Y=2062400
X415 139 109 1297 155 1298 393 361 1299 174 DFFSX1 $T=2303400 2167200 1 0 $X=2299100 $Y=2111400
X416 139 100 1300 174 1301 534 361 1302 174 DFFSX1 $T=2488200 2066400 1 180 $X=2358500 $Y=2062400
X417 139 288 1303 155 1304 536 361 1305 174 DFFSX1 $T=2415600 2268000 0 0 $X=2411300 $Y=2264000
X418 139 102 1306 174 1307 318 361 1308 174 DFFSX1 $T=2475000 2469600 0 0 $X=2470700 $Y=2465600
X419 165 545 545 155 1310 1309 361 118 174 DFFSX1 $T=2481600 2167200 1 0 $X=2477300 $Y=2111400
X420 340 629 1311 339 1312 645 361 1313 174 DFFSX1 $T=3643200 2167200 0 0 $X=3638900 $Y=2163200
X421 246 629 1314 339 1315 652 361 1316 174 DFFSX1 $T=3768600 2268000 0 0 $X=3764300 $Y=2264000
X422 14 361 174 174 CLKINVX8 $T=1049400 2066400 0 0 $X=1045100 $Y=2062400
X423 222 361 174 174 CLKINVX8 $T=2785200 2167200 0 180 $X=2741300 $Y=2111400
X424 222 361 174 174 CLKINVX8 $T=2917200 2066400 1 180 $X=2873300 $Y=2062400
X425 574 721 361 193 174 575 728 OAI211XL $T=2976600 2268000 1 0 $X=2972300 $Y=2212200
X426 571 324 361 193 174 724 580 OAI211XL $T=3022800 2167200 0 180 $X=2978900 $Y=2111400
X427 639 342 361 637 174 354 632 OAI211XL $T=3577200 2066400 0 180 $X=3533300 $Y=2010600
X428 769 267 361 684 174 751 688 OAI211XL $T=4243800 2368800 0 180 $X=4199900 $Y=2313000
X429 146 142 361 174 INVX4 $T=2158200 2167200 1 180 $X=2127500 $Y=2163200
X430 540 391 361 174 INVX4 $T=2382600 2268000 0 180 $X=2351900 $Y=2212200
X431 541 5 361 174 INVX4 $T=2395800 2368800 0 180 $X=2365100 $Y=2313000
X432 543 152 361 174 INVX4 $T=2448600 2066400 0 180 $X=2417900 $Y=2010600
X433 174 146 361 174 INVX4 $T=2514600 2167200 1 180 $X=2483900 $Y=2163200
X434 549 288 361 174 INVX4 $T=2659800 2167200 1 180 $X=2629100 $Y=2163200
X435 552 102 361 174 INVX4 $T=2692800 2469600 0 180 $X=2662100 $Y=2413800
X436 573 570 174 361 571 AND2XL $T=2956800 2066400 1 180 $X=2926100 $Y=2062400
X437 292 174 516 293 293 423 361 NOR4BXL $T=1155000 2368800 0 180 $X=1111100 $Y=2313000
X438 45 55 361 174 285 AND2X4 $T=666600 2368800 0 0 $X=662300 $Y=2364800
X439 185 188 361 174 192 AND2X4 $T=2963400 2167200 0 0 $X=2959100 $Y=2163200
X440 756 361 52 174 CLKBUFX8 $T=765600 2368800 0 0 $X=761300 $Y=2364800
X441 761 361 165 174 CLKBUFX8 $T=2508000 2368800 0 0 $X=2503700 $Y=2364800
X442 542 361 174 290 INVX3 $T=2343000 2368800 1 180 $X=2312300 $Y=2364800
X443 740 174 622 744 361 NOR2BX1 $T=3399000 2368800 0 0 $X=3394700 $Y=2364800
X444 174 712 495 506 361 NOR2X1 $T=1478400 2167200 0 0 $X=1474100 $Y=2163200
X445 9 450 174 24 453 78 361 AOI22X2 $T=257400 2268000 1 0 $X=253100 $Y=2212200
X446 24 366 174 15 466 79 361 AOI22X2 $T=567600 2066400 0 180 $X=503900 $Y=2010600
.ENDS
***************************************
.SUBCKT BUFX2 A VDD VSS Y
** N=5 EP=4 IP=0 FDC=4
M0 VSS A 5 VSS n18 L=1.8e-07 W=4.8e-07 $X=7200 $Y=10550 $D=6
M1 Y 5 VSS VSS n18 L=1.8e-07 W=1.2e-06 $X=13600 $Y=5700 $D=6
M2 VDD A 5 VDD p18 L=1.8e-07 W=7.2e-07 $X=7200 $Y=27200 $D=10
M3 Y 5 VDD VDD p18 L=1.8e-07 W=1.76e-06 $X=13200 $Y=27100 $D=10
.ENDS
***************************************
.SUBCKT TLATNXL GN 2 D 4 Q VSS VDD
** N=14 EP=7 IP=0 FDC=18
M0 2 GN VSS VSS n18 L=1.8e-07 W=3e-07 $X=4600 $Y=14100 $D=6
M1 VSS 2 4 VSS n18 L=1.8e-07 W=3e-07 $X=13600 $Y=8300 $D=6
M2 11 D VSS VSS n18 L=1.8e-07 W=5.6e-07 $X=21600 $Y=5700 $D=6
M3 8 2 11 VSS n18 L=1.8e-07 W=5.6e-07 $X=27200 $Y=5700 $D=6
M4 12 4 8 VSS n18 L=1.8e-07 W=3e-07 $X=34800 $Y=8300 $D=6
M5 VSS 9 12 VSS n18 L=1.8e-07 W=3e-07 $X=40400 $Y=8300 $D=6
M6 Q 8 VSS VSS n18 L=1.8e-07 W=4.2e-07 $X=48400 $Y=5900 $D=6
M7 9 8 VSS VSS n18 L=1.8e-07 W=3e-07 $X=48400 $Y=13600 $D=6
M8 QN 9 VSS VSS n18 L=1.8e-07 W=4.2e-07 $X=63600 $Y=11200 $D=6
M9 2 GN VDD VDD p18 L=1.8e-07 W=4.2e-07 $X=4600 $Y=27000 $D=10
M10 VDD 2 4 VDD p18 L=1.8e-07 W=4.2e-07 $X=13600 $Y=34200 $D=10
M11 13 D VDD VDD p18 L=1.8e-07 W=8.4e-07 $X=21950 $Y=30000 $D=10
M12 8 4 13 VDD p18 L=1.8e-07 W=8.4e-07 $X=27550 $Y=30000 $D=10
M13 14 2 8 VDD p18 L=1.8e-07 W=4.2e-07 $X=35150 $Y=30000 $D=10
M14 VDD 9 14 VDD p18 L=1.8e-07 W=4.2e-07 $X=40750 $Y=30000 $D=10
M15 9 8 VDD VDD p18 L=1.8e-07 W=4.2e-07 $X=50000 $Y=28100 $D=10
M16 Q 8 VDD VDD p18 L=1.8e-07 W=6.4e-07 $X=50000 $Y=36750 $D=10
M17 QN 9 VDD VDD p18 L=1.8e-07 W=6.4e-07 $X=64600 $Y=30100 $D=10
.ENDS
***************************************
.SUBCKT DFFSX2 CK D 3 4 SN QN VDD VSS Q
** N=24 EP=9 IP=0 FDC=34
M0 VSS CK 4 VSS n18 L=1.8e-07 W=4.2e-07 $X=6250 $Y=11500 $D=6
M1 15 D VSS VSS n18 L=1.8e-07 W=3e-07 $X=16050 $Y=8400 $D=6
M2 3 4 15 VSS n18 L=1.8e-07 W=3e-07 $X=21650 $Y=8400 $D=6
M3 16 11 3 VSS n18 L=1.8e-07 W=3e-07 $X=28400 $Y=15200 $D=6
M4 VSS 10 16 VSS n18 L=1.8e-07 W=3e-07 $X=34000 $Y=15200 $D=6
M5 17 SN VSS VSS n18 L=1.8e-07 W=3.6e-07 $X=40000 $Y=14600 $D=6
M6 10 3 17 VSS n18 L=1.8e-07 W=3.6e-07 $X=45600 $Y=14600 $D=6
M7 VSS 4 11 VSS n18 L=1.8e-07 W=3e-07 $X=53600 $Y=7500 $D=6
M8 18 10 VSS VSS n18 L=1.8e-07 W=6.8e-07 $X=62500 $Y=9050 $D=6
M9 12 11 18 VSS n18 L=1.8e-07 W=6.8e-07 $X=68100 $Y=9050 $D=6
M10 19 4 12 VSS n18 L=1.8e-07 W=3e-07 $X=74100 $Y=7150 $D=6
M11 VSS 13 19 VSS n18 L=1.8e-07 W=3e-07 $X=79700 $Y=7150 $D=6
M12 20 SN VSS VSS n18 L=1.8e-07 W=1e-06 $X=87300 $Y=7150 $D=6
M13 13 12 20 VSS n18 L=1.8e-07 W=1e-06 $X=92900 $Y=7150 $D=6
M14 14 13 VSS VSS n18 L=1.8e-07 W=4.8e-07 $X=105500 $Y=12450 $D=6
M15 VSS 13 QN VSS n18 L=1.8e-07 W=1.2e-06 $X=118100 $Y=5900 $D=6
M16 Q 14 VSS VSS n18 L=1.8e-07 W=1.2e-06 $X=126100 $Y=5900 $D=6
M17 VDD CK 4 VDD p18 L=1.8e-07 W=6.4e-07 $X=6500 $Y=33000 $D=10
M18 21 D VDD VDD p18 L=1.8e-07 W=4.2e-07 $X=13600 $Y=28450 $D=10
M19 3 11 21 VDD p18 L=1.8e-07 W=4.2e-07 $X=19200 $Y=28450 $D=10
M20 22 4 3 VDD p18 L=1.8e-07 W=4.2e-07 $X=26800 $Y=31500 $D=10
M21 VDD 10 22 VDD p18 L=1.8e-07 W=4.2e-07 $X=32400 $Y=31500 $D=10
M22 10 SN VDD VDD p18 L=1.8e-07 W=4e-07 $X=38400 $Y=31100 $D=10
M23 VDD 3 10 VDD p18 L=1.8e-07 W=4e-07 $X=46400 $Y=31100 $D=10
M24 11 4 VDD VDD p18 L=1.8e-07 W=4.4e-07 $X=52400 $Y=27600 $D=10
M25 23 10 VDD VDD p18 L=1.8e-07 W=1.02e-06 $X=65000 $Y=34500 $D=10
M26 12 4 23 VDD p18 L=1.8e-07 W=1.02e-06 $X=70600 $Y=34500 $D=10
M27 24 11 12 VDD p18 L=1.8e-07 W=3e-07 $X=78200 $Y=34500 $D=10
M28 VDD 13 24 VDD p18 L=1.8e-07 W=3e-07 $X=83800 $Y=34500 $D=10
M29 13 SN VDD VDD p18 L=1.8e-07 W=1.14e-06 $X=89800 $Y=26900 $D=10
M30 VDD 12 13 VDD p18 L=1.8e-07 W=1.14e-06 $X=97000 $Y=26900 $D=10
M31 14 13 VDD VDD p18 L=1.8e-07 W=7.2e-07 $X=104200 $Y=31100 $D=10
M32 VDD 13 QN VDD p18 L=1.8e-07 W=1.8e-06 $X=116800 $Y=26700 $D=10
M33 Q 14 VDD VDD p18 L=1.8e-07 W=1.8e-06 $X=124000 $Y=26700 $D=10
.ENDS
***************************************
.SUBCKT OAI221XL B1 B0 VSS A0 VDD A1 C0 Y
** N=12 EP=8 IP=0 FDC=10
M0 9 B1 VSS VSS n18 L=1.8e-07 W=6.6e-07 $X=4600 $Y=10200 $D=6
M1 VSS B0 9 VSS n18 L=1.8e-07 W=6.6e-07 $X=11800 $Y=10200 $D=6
M2 9 A0 10 VSS n18 L=1.8e-07 W=6.6e-07 $X=22850 $Y=13750 $D=6
M3 10 A1 9 VSS n18 L=1.8e-07 W=6.6e-07 $X=30050 $Y=13750 $D=6
M4 Y C0 10 VSS n18 L=1.8e-07 W=6.6e-07 $X=36100 $Y=8050 $D=6
M5 11 B1 VDD VDD p18 L=1.8e-07 W=8.4e-07 $X=4600 $Y=31800 $D=10
M6 Y B0 11 VDD p18 L=1.8e-07 W=8.4e-07 $X=10200 $Y=31800 $D=10
M7 12 A0 Y VDD p18 L=1.8e-07 W=8.4e-07 $X=17400 $Y=31800 $D=10
M8 VDD A1 12 VDD p18 L=1.8e-07 W=8.4e-07 $X=23000 $Y=31800 $D=10
M9 Y C0 VDD VDD p18 L=1.8e-07 W=6.4e-07 $X=29000 $Y=33850 $D=10
.ENDS
***************************************
.SUBCKT NOR3X2 A VSS B C Y VDD
** N=10 EP=6 IP=0 FDC=9
M0 Y C VSS VSS n18 L=1.8e-07 W=1.2e-06 $X=6200 $Y=5700 $D=6
M1 VSS B Y VSS n18 L=1.8e-07 W=1.2e-06 $X=13400 $Y=5700 $D=6
M2 Y A VSS VSS n18 L=1.8e-07 W=1.2e-06 $X=20600 $Y=5700 $D=6
M3 7 C VDD VDD p18 L=1.8e-07 W=1.4e-06 $X=6200 $Y=30700 $D=10
M4 8 B 7 VDD p18 L=1.8e-07 W=1.4e-06 $X=12350 $Y=30700 $D=10
M5 Y A 8 VDD p18 L=1.8e-07 W=1.4e-06 $X=18200 $Y=30700 $D=10
M6 9 A Y VDD p18 L=1.8e-07 W=1.4e-06 $X=25400 $Y=27450 $D=10
M7 10 B 9 VDD p18 L=1.8e-07 W=1.4e-06 $X=31000 $Y=27450 $D=10
M8 VDD C 10 VDD p18 L=1.8e-07 W=1.4e-06 $X=36600 $Y=27450 $D=10
.ENDS
***************************************
.SUBCKT CLKBUFXL A VSS VDD Y
** N=5 EP=4 IP=0 FDC=4
M0 VSS A 5 VSS n18 L=1.8e-07 W=3e-07 $X=6600 $Y=11900 $D=6
M1 Y 5 VSS VSS n18 L=1.8e-07 W=3e-07 $X=12600 $Y=11900 $D=6
M2 VDD A 5 VDD p18 L=1.8e-07 W=3e-07 $X=6600 $Y=27800 $D=10
M3 Y 5 VDD VDD p18 L=1.8e-07 W=1e-06 $X=12600 $Y=27200 $D=10
.ENDS
***************************************
.SUBCKT INVX2 A VSS Y VDD
** N=4 EP=4 IP=0 FDC=3
M0 Y A VSS VSS n18 L=1.8e-07 W=1.2e-06 $X=11000 $Y=5750 $D=6
M1 Y A VDD VDD p18 L=1.8e-07 W=9e-07 $X=4600 $Y=27300 $D=10
M2 VDD A Y VDD p18 L=1.8e-07 W=9e-07 $X=11800 $Y=27300 $D=10
.ENDS
***************************************
.SUBCKT NAND2X2 A B Y VSS VDD
** N=7 EP=5 IP=0 FDC=8
M0 6 B VSS VSS n18 L=1.8e-07 W=7.5e-07 $X=6600 $Y=8950 $D=6
M1 Y A 6 VSS n18 L=1.8e-07 W=7.5e-07 $X=12200 $Y=8950 $D=6
M2 7 A Y VSS n18 L=1.8e-07 W=8.5e-07 $X=19400 $Y=8950 $D=6
M3 VSS B 7 VSS n18 L=1.8e-07 W=8.5e-07 $X=25000 $Y=8950 $D=6
M4 Y B VDD VDD p18 L=1.8e-07 W=9.2e-07 $X=6400 $Y=28600 $D=10
M5 VDD A Y VDD p18 L=1.8e-07 W=9.2e-07 $X=13600 $Y=28600 $D=10
M6 Y A VDD VDD p18 L=1.83388e-07 W=9.38995e-07 $X=19200 $Y=28600 $D=10
M7 VDD B Y VDD p18 L=1.83388e-07 W=9.38995e-07 $X=25700 $Y=33300 $D=10
.ENDS
***************************************
.SUBCKT ICV_6 3 5 8 9 10 11 12 14 15 16 17 18 19 20 22 23 24 25 26 27
+ 28 29 30 31 32 33 34 35 36 37 38 40 42 43 44 45 46 47 50 51
+ 52 53 54 55 62 63 64 65 66 67 68 70 71 72 73 74 75 77 78 80
+ 81 82 83 84 87 88 89 90 92 94 96 97 98 99 100 101 102 103 104 106
+ 108 109 110 112 114 115 116 117 118 120 123 125 126 127 130 131 132 134 136 137
+ 138 139 141 143 145 146 147 148 149 150 151 152 153 154 155 157 159 160 161 162
+ 164 165 166 167 168 169 170 172 173 175 176 177 179 180 181 182 183 184 185 187
+ 188 190 194 195 197 198 199 200 201 202 203 206 207 208 209 210 212 213 214 216
+ 219 225 233 234 235 237 238 241 243 249 251 253 254 255 256 257 258 259 260 261
+ 262 263 264 265 266 267 268 269 270 271 272 273 274 275 276 277 278 279 280 281
+ 282 283 284 285 286 287 288 289 290 291 292 293 294 295 296 297 298 299 300 301
+ 302 303 304 305 306 307 308 309 310 311 312 313 314 315 316 317 318 319 320 321
+ 322 323 324 325 326 327 328 329 332 333 334 335 336 337 338 339 340 341 342 343
+ 344 345 346 347 348 349 350 351 352 353 354 355 356 357 358 359 360 361 362 363
+ 364 365 366 367 368 369 370 371 372 373 374 375 376 377 378 379 380 381 382 383
+ 384 385 386 387 388 389 390 391 392 393 394 395 396 397 398 399 400 401
*.CALIBRE ICV_CELL 2
** N=1422 EP=318 IP=3433 FDC=8153
M0 292 405 775 292 n18 L=1.8e-07 W=3.6e-07 $X=1201200 $Y=1951450 $D=6
M1 351 278 292 292 n18 L=1.8e-07 W=6e-07 $X=1207200 $Y=1949050 $D=6
M2 292 488 351 292 n18 L=1.8e-07 W=6e-07 $X=1214400 $Y=1949400 $D=6
M3 351 72 292 292 n18 L=1.8e-07 W=6e-07 $X=1220400 $Y=1949400 $D=6
M4 292 775 351 292 n18 L=1.8e-07 W=6e-07 $X=1227600 $Y=1949400 $D=6
M5 292 714 776 292 n18 L=1.8e-07 W=3e-07 $X=1522200 $Y=1954900 $D=6
M6 292 279 776 292 n18 L=1.8e-07 W=3e-07 $X=1529400 $Y=1947400 $D=6
M7 776 509 292 292 n18 L=1.8e-07 W=3e-07 $X=1535400 $Y=1951200 $D=6
M8 292 506 776 292 n18 L=1.8e-07 W=3e-07 $X=1543400 $Y=1951200 $D=6
M9 512 776 292 292 n18 L=1.8e-07 W=4.2e-07 $X=1549400 $Y=1951200 $D=6
M10 310 646 292 292 n18 L=1.8e-07 W=1.2e-06 $X=3438200 $Y=1669600 $D=6
M11 292 783 310 292 n18 L=1.8e-07 W=1.2e-06 $X=3445400 $Y=1669600 $D=6
M12 783 650 292 292 n18 L=1.8e-07 W=5.8e-07 $X=3463600 $Y=1674000 $D=6
M13 17 405 775 17 p18 L=1.8e-07 W=5.4e-07 $X=1200800 $Y=1930900 $D=10
M14 1415 278 17 17 p18 L=1.8e-07 W=1.54e-06 $X=1207800 $Y=1920900 $D=10
M15 1416 488 1415 17 p18 L=1.8e-07 W=1.54e-06 $X=1213400 $Y=1920900 $D=10
M16 1417 72 1416 17 p18 L=1.8e-07 W=1.54e-06 $X=1219200 $Y=1920900 $D=10
M17 351 775 1417 17 p18 L=1.8e-07 W=1.54e-06 $X=1224800 $Y=1920900 $D=10
M18 1418 714 776 17 p18 L=1.8e-07 W=7.6e-07 $X=1524800 $Y=1925550 $D=10
M19 1419 279 1418 17 p18 L=1.8e-07 W=7.6e-07 $X=1530400 $Y=1925550 $D=10
M20 1420 509 1419 17 p18 L=1.8e-07 W=7.6e-07 $X=1536000 $Y=1925550 $D=10
M21 17 506 1420 17 p18 L=1.8e-07 W=7.6e-07 $X=1541600 $Y=1925550 $D=10
M22 512 776 17 17 p18 L=1.8e-07 W=6.4e-07 $X=1547600 $Y=1926750 $D=10
M23 1421 646 17 17 p18 L=1.8e-07 W=1.2e-06 $X=3438400 $Y=1691200 $D=10
M24 310 783 1421 17 p18 L=1.8e-07 W=1.2e-06 $X=3444000 $Y=1691200 $D=10
M25 1422 783 310 17 p18 L=1.8e-07 W=1.2e-06 $X=3451200 $Y=1691200 $D=10
M26 17 646 1422 17 p18 L=1.8e-07 W=1.2e-06 $X=3456800 $Y=1691200 $D=10
M27 783 650 17 17 p18 L=1.8e-07 W=8.8e-07 $X=3463600 $Y=1691200 $D=10
X28 773 292 17 270 37 NAND2XL $T=627000 1663200 0 180 $X=602900 $Y=1607400
X29 459 292 17 707 40 NAND2XL $T=679800 1965600 0 0 $X=675500 $Y=1961600
X30 461 292 17 264 77 NAND2XL $T=686400 1764000 1 0 $X=682100 $Y=1708200
X31 708 292 17 42 43 NAND2XL $T=745800 1562400 0 0 $X=741500 $Y=1558400
X32 275 292 17 709 480 NAND2XL $T=976800 1562400 1 180 $X=952700 $Y=1558400
X33 281 292 17 99 506 NAND2XL $T=1504800 1965600 0 180 $X=1480700 $Y=1909800
X34 500 292 17 357 714 NAND2XL $T=1498200 1965600 0 0 $X=1493900 $Y=1961600
X35 505 292 17 101 359 NAND2XL $T=1570800 1965600 0 0 $X=1566500 $Y=1961600
X36 520 292 17 101 408 NAND2XL $T=1623600 1965600 0 0 $X=1619300 $Y=1961600
X37 360 292 17 109 718 NAND2XL $T=1656600 1562400 1 0 $X=1652300 $Y=1506600
X38 722 292 17 101 717 NAND2XL $T=1676400 1864800 0 180 $X=1652300 $Y=1809000
X39 285 292 17 101 719 NAND2XL $T=1716000 1864800 0 180 $X=1691900 $Y=1809000
X40 558 292 17 166 552 NAND2XL $T=2494800 1663200 1 0 $X=2490500 $Y=1607400
X41 294 292 17 149 375 NAND2XL $T=2527800 1461600 1 180 $X=2503700 $Y=1457600
X42 560 292 17 166 548 NAND2XL $T=2541000 1562400 1 180 $X=2516900 $Y=1558400
X43 561 292 17 180 546 NAND2XL $T=2547600 1663200 0 180 $X=2523500 $Y=1607400
X44 565 292 17 166 556 NAND2XL $T=2600400 1663200 1 180 $X=2576300 $Y=1659200
X45 566 292 17 180 563 NAND2XL $T=2646600 1663200 1 180 $X=2622500 $Y=1659200
X46 571 292 17 180 732 NAND2XL $T=2699400 1764000 1 180 $X=2675300 $Y=1760000
X47 570 292 17 180 381 NAND2XL $T=2725800 1965600 1 180 $X=2701700 $Y=1961600
X48 576 292 17 180 564 NAND2XL $T=2732400 1864800 0 180 $X=2708300 $Y=1809000
X49 574 292 17 180 569 NAND2XL $T=2778600 1965600 0 180 $X=2754500 $Y=1909800
X50 580 292 17 512 582 NAND2XL $T=2884200 1864800 0 0 $X=2879900 $Y=1860800
X51 734 292 17 586 779 NAND2XL $T=2930400 1864800 1 180 $X=2906300 $Y=1860800
X52 427 292 17 187 585 NAND2XL $T=2943600 1764000 0 180 $X=2919500 $Y=1708200
X53 585 292 17 420 734 NAND2XL $T=2943600 1864800 1 0 $X=2939300 $Y=1809000
X54 582 292 17 583 421 NAND2XL $T=2956800 1965600 1 0 $X=2952500 $Y=1909800
X55 202 292 17 510 587 NAND2XL $T=2983200 1764000 0 180 $X=2959100 $Y=1708200
X56 549 292 17 427 422 NAND2XL $T=2996400 1663200 0 0 $X=2992100 $Y=1659200
X57 155 292 17 588 594 NAND2XL $T=3003000 1864800 0 0 $X=2998700 $Y=1860800
X58 587 292 17 590 737 NAND2XL $T=3016200 1764000 0 0 $X=3011900 $Y=1760000
X59 422 292 17 595 593 NAND2XL $T=3022800 1663200 1 0 $X=3018500 $Y=1607400
X60 155 292 17 739 195 NAND2XL $T=3029400 1864800 0 0 $X=3025100 $Y=1860800
X61 596 292 17 184 584 NAND2XL $T=3055800 1562400 1 180 $X=3031700 $Y=1558400
X62 159 292 17 202 597 NAND2XL $T=3036000 1764000 1 0 $X=3031700 $Y=1708200
X63 607 292 17 184 568 NAND2XL $T=3062400 1663200 0 180 $X=3038300 $Y=1607400
X64 155 292 17 740 745 NAND2XL $T=3042600 1965600 1 0 $X=3038300 $Y=1909800
X65 551 292 17 580 602 NAND2XL $T=3082200 1864800 0 0 $X=3077900 $Y=1860800
X66 615 292 17 184 579 NAND2XL $T=3154800 1663200 1 180 $X=3130700 $Y=1659200
X67 545 292 17 605 610 NAND2XL $T=3161400 1663200 1 0 $X=3157100 $Y=1607400
X68 431 292 17 184 573 NAND2XL $T=3194400 1764000 0 180 $X=3170300 $Y=1708200
X69 610 292 17 423 429 NAND2XL $T=3187800 1663200 1 0 $X=3183500 $Y=1607400
X70 547 292 17 748 619 NAND2XL $T=3187800 1764000 0 0 $X=3183500 $Y=1760000
X71 750 292 17 428 426 NAND2XL $T=3227400 1663200 0 180 $X=3203300 $Y=1607400
X72 219 292 17 184 572 NAND2XL $T=3227400 1663200 1 180 $X=3203300 $Y=1659200
X73 619 292 17 613 622 NAND2XL $T=3214200 1764000 0 0 $X=3209900 $Y=1760000
X74 430 292 17 429 625 NAND2XL $T=3227400 1663200 0 0 $X=3223100 $Y=1659200
X75 553 292 17 627 626 NAND2XL $T=3227400 1864800 0 0 $X=3223100 $Y=1860800
X76 431 292 17 624 750 NAND2XL $T=3253800 1663200 0 180 $X=3229700 $Y=1607400
X77 607 292 17 629 617 NAND2XL $T=3273600 1562400 1 180 $X=3249500 $Y=1558400
X78 626 292 17 634 751 NAND2XL $T=3273600 1864800 0 0 $X=3269300 $Y=1860800
X79 210 292 17 754 755 NAND2XL $T=3293400 1562400 0 0 $X=3289100 $Y=1558400
X80 210 292 17 433 635 NAND2XL $T=3313200 1663200 0 180 $X=3289100 $Y=1607400
X81 639 292 17 184 567 NAND2XL $T=3319800 1764000 1 180 $X=3295700 $Y=1760000
X82 307 292 17 184 578 NAND2XL $T=3339600 1864800 1 180 $X=3315500 $Y=1860800
X83 641 292 17 184 577 NAND2XL $T=3346200 1864800 0 180 $X=3322100 $Y=1809000
X84 210 292 17 757 642 NAND2XL $T=3352800 1663200 0 0 $X=3348500 $Y=1659200
X85 640 292 17 184 213 NAND2XL $T=3372600 1864800 0 180 $X=3348500 $Y=1809000
X86 643 292 17 184 592 NAND2XL $T=3372600 1965600 0 0 $X=3368300 $Y=1961600
X87 596 292 17 645 636 NAND2XL $T=3418800 1764000 1 180 $X=3394700 $Y=1760000
X88 210 292 17 644 756 NAND2XL $T=3418800 1864800 1 180 $X=3394700 $Y=1860800
X89 210 292 17 391 647 NAND2XL $T=3498000 1562400 0 0 $X=3493700 $Y=1558400
X90 762 292 17 653 654 NAND2XL $T=3517800 1864800 0 0 $X=3513500 $Y=1860800
X91 640 292 17 657 659 NAND2XL $T=3603600 1562400 1 180 $X=3579500 $Y=1558400
X92 658 292 17 314 646 NAND2XL $T=3630000 1864800 0 180 $X=3605900 $Y=1809000
X93 659 292 17 660 315 NAND2XL $T=3623400 1461600 0 0 $X=3619100 $Y=1457600
X94 210 292 17 669 661 NAND2XL $T=3795000 1562400 0 180 $X=3770900 $Y=1506600
X95 210 292 17 670 662 NAND2XL $T=3795000 1663200 0 180 $X=3770900 $Y=1607400
X96 666 292 17 674 764 NAND2XL $T=3887400 1562400 0 0 $X=3883100 $Y=1558400
X97 678 292 17 671 685 NAND2XL $T=3999600 1663200 0 0 $X=3995300 $Y=1659200
X98 210 292 17 684 665 NAND2XL $T=4039200 1663200 1 180 $X=4015100 $Y=1659200
X99 210 292 17 686 649 NAND2XL $T=4045800 1764000 0 180 $X=4021700 $Y=1708200
X100 615 292 17 766 697 NAND2XL $T=4039200 1764000 0 0 $X=4034900 $Y=1760000
X101 210 292 17 689 664 NAND2XL $T=4065600 1965600 1 180 $X=4041500 $Y=1961600
X102 685 292 17 438 690 NAND2XL $T=4052400 1663200 0 0 $X=4048100 $Y=1659200
X103 687 292 17 675 691 NAND2XL $T=4052400 1764000 1 0 $X=4048100 $Y=1708200
X104 210 292 17 692 651 NAND2XL $T=4065600 1864800 1 0 $X=4061300 $Y=1809000
X105 210 292 17 399 663 NAND2XL $T=4072200 1965600 0 0 $X=4067900 $Y=1961600
X106 769 292 17 688 695 NAND2XL $T=4105200 1864800 1 180 $X=4081100 $Y=1860800
X107 697 292 17 694 699 NAND2XL $T=4125000 1864800 0 180 $X=4100900 $Y=1809000
X108 401 292 17 771 442 NAND2XL $T=4177800 1965600 1 0 $X=4173500 $Y=1909800
X109 442 292 17 441 702 NAND2XL $T=4237200 1965600 1 180 $X=4213100 $Y=1961600
X110 17 580 512 581 292 NOR2XL $T=2857800 1965600 0 180 $X=2833700 $Y=1909800
X111 17 421 299 736 292 NOR2XL $T=2976600 1864800 0 0 $X=2972300 $Y=1860800
X112 17 202 510 735 292 NOR2XL $T=3016200 1764000 0 180 $X=2992100 $Y=1708200
X113 17 737 591 738 292 NOR2XL $T=3016200 1864800 0 180 $X=2992100 $Y=1809000
X114 17 159 202 598 292 NOR2XL $T=3042600 1764000 0 0 $X=3038300 $Y=1760000
X115 17 551 580 600 292 NOR2XL $T=3055800 1864800 0 0 $X=3051500 $Y=1860800
X116 17 197 605 606 292 NOR2XL $T=3108600 1663200 0 0 $X=3104300 $Y=1659200
X117 17 547 748 609 292 NOR2XL $T=3141600 1764000 0 0 $X=3137300 $Y=1760000
X118 17 197 748 614 292 NOR2XL $T=3161400 1864800 1 0 $X=3157100 $Y=1809000
X119 17 197 627 618 292 NOR2XL $T=3194400 1864800 0 0 $X=3190100 $Y=1860800
X120 17 607 629 616 292 NOR2XL $T=3240600 1562400 0 180 $X=3216500 $Y=1506600
X121 17 622 425 628 292 NOR2XL $T=3240600 1764000 0 0 $X=3236300 $Y=1760000
X122 17 553 627 630 292 NOR2XL $T=3247200 1864800 0 0 $X=3242900 $Y=1860800
X123 17 751 209 753 292 NOR2XL $T=3286800 1965600 0 0 $X=3282500 $Y=1961600
X124 17 758 434 759 292 NOR2XL $T=3399000 1764000 1 180 $X=3374900 $Y=1760000
X125 17 596 645 638 292 NOR2XL $T=3412200 1663200 1 180 $X=3388100 $Y=1659200
X126 17 179 310 648 292 NOR2XL $T=3451800 1562400 0 0 $X=3447500 $Y=1558400
X127 17 666 674 765 292 NOR2XL $T=3913800 1562400 0 0 $X=3909500 $Y=1558400
X128 17 687 675 768 292 NOR2XL $T=4078800 1764000 1 0 $X=4074500 $Y=1708200
X129 17 769 688 700 292 NOR2XL $T=4111800 1864800 0 0 $X=4107500 $Y=1860800
X130 581 17 292 583 INVXL $T=2877600 1965600 1 0 $X=2873300 $Y=1909800
X131 585 17 292 419 INVXL $T=2943600 1764000 0 0 $X=2939300 $Y=1760000
X132 161 17 292 780 INVXL $T=2963400 1562400 1 0 $X=2959100 $Y=1506600
X133 735 17 292 590 INVXL $T=2996400 1764000 0 0 $X=2992100 $Y=1760000
X134 599 17 292 741 INVXL $T=3055800 1562400 0 0 $X=3051500 $Y=1558400
X135 422 17 292 743 INVXL $T=3055800 1663200 0 0 $X=3051500 $Y=1659200
X136 292 17 292 604 INVXL $T=3115200 1461600 0 0 $X=3110900 $Y=1457600
X137 610 17 292 608 INVXL $T=3168000 1663200 1 180 $X=3150500 $Y=1659200
X138 609 17 292 613 INVXL $T=3168000 1764000 0 0 $X=3163700 $Y=1760000
X139 750 17 292 623 INVXL $T=3240600 1562400 0 0 $X=3236300 $Y=1558400
X140 630 17 292 634 INVXL $T=3306600 1864800 0 0 $X=3302300 $Y=1860800
X141 646 17 292 652 INVXL $T=3484800 1764000 0 0 $X=3480500 $Y=1760000
X142 659 17 292 655 INVXL $T=3557400 1461600 1 180 $X=3539900 $Y=1457600
X143 654 17 292 392 INVXL $T=3544200 1965600 0 0 $X=3539900 $Y=1961600
X144 685 17 292 767 INVXL $T=4032600 1663200 1 0 $X=4028300 $Y=1607400
X145 697 17 292 696 INVXL $T=4085400 1764000 0 0 $X=4081100 $Y=1760000
X146 326 17 292 400 INVXL $T=4111800 1461600 1 180 $X=4094300 $Y=1457600
X147 325 17 292 680 INVXL $T=4151400 1562400 0 180 $X=4133900 $Y=1506600
X148 328 17 292 683 INVXL $T=4184400 1663200 0 180 $X=4166900 $Y=1607400
X149 329 17 292 668 INVXL $T=4237200 1663200 0 180 $X=4219700 $Y=1607400
X150 442 17 292 703 INVXL $T=4237200 1965600 1 0 $X=4232900 $Y=1909800
X151 581 292 299 582 17 586 OAI21XL $T=2917200 1965600 1 0 $X=2912900 $Y=1909800
X152 734 292 586 779 17 588 OAI21XL $T=2943600 1864800 0 0 $X=2939300 $Y=1860800
X153 735 292 591 587 17 386 OAI21XL $T=2989800 1764000 1 180 $X=2959100 $Y=1760000
X154 600 292 203 602 17 744 OAI21XL $T=3062400 1864800 1 0 $X=3058100 $Y=1809000
X155 598 292 603 597 17 302 OAI21XL $T=3102000 1764000 1 180 $X=3071300 $Y=1760000
X156 616 292 620 617 17 612 OAI21XL $T=3207600 1562400 0 0 $X=3203300 $Y=1558400
X157 172 292 621 424 17 316 OAI21XL $T=3207600 1764000 1 0 $X=3203300 $Y=1708200
X158 609 292 425 619 17 208 OAI21XL $T=3253800 1864800 0 180 $X=3223100 $Y=1809000
X159 430 292 429 625 17 621 OAI21XL $T=3247200 1764000 1 0 $X=3242900 $Y=1708200
X160 630 292 209 626 17 430 OAI21XL $T=3300000 1864800 0 180 $X=3269300 $Y=1809000
X161 172 292 782 631 17 637 OAI21XL $T=3306600 1965600 1 0 $X=3302300 $Y=1909800
X162 172 292 432 632 17 306 OAI21XL $T=3319800 1965600 0 0 $X=3315500 $Y=1961600
X163 638 292 633 636 17 434 OAI21XL $T=3346200 1764000 0 0 $X=3341900 $Y=1760000
X164 650 292 652 648 17 763 OAI21XL $T=3537600 1562400 0 0 $X=3533300 $Y=1558400
X165 765 292 437 764 17 313 OAI21XL $T=3927000 1461600 1 180 $X=3896300 $Y=1457600
X166 768 292 440 691 17 693 OAI21XL $T=4111800 1663200 1 180 $X=4081100 $Y=1659200
X167 700 292 701 695 17 698 OAI21XL $T=4138200 1864800 1 0 $X=4133900 $Y=1809000
X168 774 55 17 480 784 292 712 AOI21XL $T=996600 1663200 1 0 $X=992300 $Y=1607400
X169 420 586 17 419 785 292 591 AOI21XL $T=2970000 1864800 1 0 $X=2965700 $Y=1809000
X170 421 299 17 736 786 292 740 AOI21XL $T=3003000 1965600 1 0 $X=2998700 $Y=1909800
X171 737 591 17 738 787 292 739 AOI21XL $T=3022800 1864800 1 0 $X=3018500 $Y=1809000
X172 595 744 17 743 788 292 603 AOI21XL $T=3069000 1663200 0 0 $X=3064700 $Y=1659200
X173 423 430 17 608 789 292 425 AOI21XL $T=3174600 1663200 0 0 $X=3170300 $Y=1659200
X174 428 612 17 623 790 292 633 AOI21XL $T=3260400 1663200 1 0 $X=3256100 $Y=1607400
X175 622 425 17 628 791 292 432 AOI21XL $T=3267000 1764000 0 0 $X=3262700 $Y=1760000
X176 209 751 17 753 792 292 782 AOI21XL $T=3280200 1965600 1 0 $X=3275900 $Y=1909800
X177 758 434 17 759 793 292 644 AOI21XL $T=3418800 1864800 0 180 $X=3388100 $Y=1809000
X178 660 313 17 655 794 292 620 AOI21XL $T=3603600 1461600 1 180 $X=3572900 $Y=1457600
X179 438 693 17 767 795 292 437 AOI21XL $T=4085400 1663200 0 180 $X=4054700 $Y=1607400
X180 694 698 17 696 796 292 440 AOI21XL $T=4125000 1764000 1 180 $X=4094300 $Y=1760000
X181 441 327 17 703 797 292 701 AOI21XL $T=4204200 1965600 1 0 $X=4199900 $Y=1909800
X182 11 18 799 798 23 800 446 292 801 17 DFFSXL $T=6600 1663200 0 0 $X=2300 $Y=1659200
X183 11 253 803 802 17 804 445 292 805 17 DFFSXL $T=6600 1864800 0 0 $X=2300 $Y=1860800
X184 11 254 807 806 255 808 332 292 809 17 DFFSXL $T=6600 1965600 0 0 $X=2300 $Y=1961600
X185 11 12 811 810 23 812 444 292 813 17 DFFSXL $T=13200 1562400 0 0 $X=8900 $Y=1558400
X186 11 9 815 814 23 816 447 292 817 17 DFFSXL $T=85800 1562400 1 0 $X=81500 $Y=1506600
X187 11 10 819 818 23 820 448 292 821 17 DFFSXL $T=99000 1461600 0 0 $X=94700 $Y=1457600
X188 8 9 9 822 23 823 334 292 824 17 DFFSXL $T=105600 1764000 1 0 $X=101300 $Y=1708200
X189 16 253 826 825 255 827 449 292 828 17 DFFSXL $T=138600 1965600 1 0 $X=134300 $Y=1909800
X190 16 19 830 829 17 831 454 292 832 17 DFFSXL $T=211200 1864800 0 0 $X=206900 $Y=1860800
X191 16 9 834 833 23 835 704 292 836 17 DFFSXL $T=224400 1461600 0 0 $X=220100 $Y=1457600
X192 16 254 838 837 23 839 14 292 840 17 DFFSXL $T=250800 1764000 1 0 $X=246500 $Y=1708200
X193 16 18 842 841 23 843 452 292 844 17 DFFSXL $T=349800 1562400 0 0 $X=345500 $Y=1558400
X194 34 254 254 845 17 846 339 292 847 17 DFFSXL $T=356400 1864800 1 0 $X=352100 $Y=1809000
X195 8 30 849 848 17 850 461 292 851 17 DFFSXL $T=402600 1764000 1 0 $X=398300 $Y=1708200
X196 45 19 853 852 23 854 404 292 855 17 DFFSXL $T=435600 1461600 0 0 $X=431300 $Y=1457600
X197 45 256 857 856 23 858 463 292 859 17 DFFSXL $T=455400 1562400 1 0 $X=451100 $Y=1506600
X198 16 30 861 860 23 862 773 292 863 17 DFFSXL $T=468600 1663200 1 0 $X=464300 $Y=1607400
X199 8 31 865 864 17 866 263 292 867 17 DFFSXL $T=488400 1965600 1 0 $X=484100 $Y=1909800
X200 45 261 869 868 17 870 460 292 871 17 DFFSXL $T=495000 1965600 0 0 $X=490700 $Y=1961600
X201 8 261 873 872 17 874 464 292 875 17 DFFSXL $T=508200 1864800 0 0 $X=503900 $Y=1860800
X202 11 30 877 876 17 878 465 292 879 17 DFFSXL $T=514800 1864800 1 0 $X=510500 $Y=1809000
X203 16 108 881 880 17 882 467 292 883 17 DFFSXL $T=528000 1764000 1 0 $X=523700 $Y=1708200
X204 34 262 885 884 17 886 466 292 887 17 DFFSXL $T=547800 1764000 0 0 $X=543500 $Y=1760000
X205 8 38 889 888 23 890 342 292 891 17 DFFSXL $T=561000 1461600 0 0 $X=556700 $Y=1457600
X206 52 258 893 892 17 894 36 292 895 17 DFFSXL $T=706200 1965600 0 0 $X=701900 $Y=1961600
X207 34 108 897 896 17 898 478 292 899 17 DFFSXL $T=818400 1461600 0 0 $X=814100 $Y=1457600
X208 47 108 901 900 17 902 774 292 774 17 DFFSXL $T=871200 1663200 1 0 $X=866900 $Y=1607400
X209 62 108 904 903 17 905 479 292 906 17 DFFSXL $T=871200 1764000 1 0 $X=866900 $Y=1708200
X210 62 54 908 907 274 909 481 292 910 17 DFFSXL $T=904200 1965600 1 0 $X=899900 $Y=1909800
X211 75 54 912 911 274 913 67 292 914 17 DFFSXL $T=950400 1864800 0 0 $X=946100 $Y=1860800
X212 62 38 916 915 274 917 483 292 918 17 DFFSXL $T=957000 1764000 0 0 $X=952700 $Y=1760000
X213 47 276 920 919 73 921 489 292 922 17 DFFSXL $T=1003200 1562400 0 0 $X=998900 $Y=1558400
X214 34 276 924 923 73 925 348 292 926 17 DFFSXL $T=1016400 1461600 0 0 $X=1012100 $Y=1457600
X215 75 38 928 927 274 929 485 292 930 17 DFFSXL $T=1082400 1764000 1 0 $X=1078100 $Y=1708200
X216 75 108 932 931 73 933 484 292 934 17 DFFSXL $T=1095600 1663200 0 0 $X=1091300 $Y=1659200
X217 45 30 936 935 274 937 493 292 938 17 DFFSXL $T=1102200 1965600 0 0 $X=1097900 $Y=1961600
X218 62 262 940 939 274 941 492 292 942 17 DFFSXL $T=1194600 1864800 1 0 $X=1190300 $Y=1809000
X219 45 54 944 943 274 945 491 292 946 17 DFFSXL $T=1214400 1864800 0 0 $X=1210100 $Y=1860800
X220 62 276 948 947 274 949 713 292 950 17 DFFSXL $T=1221000 1764000 0 0 $X=1216700 $Y=1760000
X221 75 90 952 951 73 953 353 292 954 17 DFFSXL $T=1320000 1562400 1 0 $X=1315700 $Y=1506600
X222 92 38 956 955 274 957 407 292 958 17 DFFSXL $T=1346400 1663200 0 0 $X=1342100 $Y=1659200
X223 5 38 960 959 274 961 505 292 962 17 DFFSXL $T=1346400 1965600 1 0 $X=1342100 $Y=1909800
X224 92 276 964 963 274 965 515 292 966 17 DFFSXL $T=1386000 1663200 1 0 $X=1381700 $Y=1607400
X225 100 38 968 967 274 969 716 292 970 17 DFFSXL $T=1491600 1764000 1 0 $X=1487300 $Y=1708200
X226 100 108 972 971 17 973 722 292 974 17 DFFSXL $T=1584000 1764000 0 0 $X=1579700 $Y=1760000
X227 92 71 976 975 17 977 723 292 978 17 DFFSXL $T=1617000 1663200 0 0 $X=1612700 $Y=1659200
X228 100 276 980 979 17 981 519 292 982 17 DFFSXL $T=1722600 1764000 0 0 $X=1718300 $Y=1760000
X229 100 71 984 983 17 985 721 292 986 17 DFFSXL $T=1742400 1663200 1 0 $X=1738100 $Y=1607400
X230 102 276 988 987 17 989 526 292 990 17 DFFSXL $T=1749000 1461600 0 0 $X=1744700 $Y=1457600
X231 88 98 992 991 17 993 106 292 994 17 DFFSXL $T=1749000 1562400 1 0 $X=1744700 $Y=1506600
X232 88 108 996 995 17 997 524 292 998 17 DFFSXL $T=1755600 1864800 1 0 $X=1751300 $Y=1809000
X233 127 108 1000 999 17 1001 725 292 1002 17 DFFSXL $T=1821600 1965600 1 0 $X=1817300 $Y=1909800
X234 125 120 1004 1003 17 1005 367 292 1006 17 DFFSXL $T=1848000 1965600 0 0 $X=1843700 $Y=1961600
X235 127 19 1008 1007 17 1009 123 292 1010 17 DFFSXL $T=1867800 1764000 0 0 $X=1863500 $Y=1760000
X236 125 71 1012 1011 17 1013 778 292 1014 17 DFFSXL $T=1881000 1663200 0 0 $X=1876700 $Y=1659200
X237 125 108 1016 1015 17 1017 728 292 1018 17 DFFSXL $T=1881000 1864800 0 0 $X=1876700 $Y=1860800
X238 125 276 1020 1019 17 1021 727 292 1022 17 DFFSXL $T=1887600 1562400 0 0 $X=1883300 $Y=1558400
X239 134 116 1024 1023 17 1025 416 292 1026 17 DFFSXL $T=2006400 1864800 1 0 $X=2002100 $Y=1809000
X240 127 71 1028 1027 17 1029 417 292 1030 17 DFFSXL $T=2032800 1663200 1 0 $X=2028500 $Y=1607400
X241 152 120 1032 1031 17 1033 543 292 1034 17 DFFSXL $T=2138400 1764000 0 0 $X=2134100 $Y=1760000
X242 152 90 1036 1035 17 1037 542 292 1038 17 DFFSXL $T=2151600 1764000 1 0 $X=2147300 $Y=1708200
X243 127 98 1040 1039 17 1041 147 292 1042 17 DFFSXL $T=2158200 1663200 1 0 $X=2153900 $Y=1607400
X244 152 54 1044 1043 151 1045 290 292 1046 17 DFFSXL $T=2164800 1965600 0 0 $X=2160500 $Y=1961600
X245 146 548 1048 1047 17 1049 730 292 1050 17 DFFSXL $T=2191200 1461600 0 0 $X=2186900 $Y=1457600
X246 146 546 1052 1051 17 1053 544 292 1054 17 DFFSXL $T=2197800 1562400 1 0 $X=2193500 $Y=1506600
X247 152 71 1056 1055 17 1057 550 292 1058 17 DFFSXL $T=2211000 1864800 0 0 $X=2206700 $Y=1860800
X248 152 116 1060 1059 17 1061 541 292 1062 17 DFFSXL $T=2263800 1764000 0 0 $X=2259500 $Y=1760000
X249 146 552 1064 1063 17 1065 555 292 1066 17 DFFSXL $T=2283600 1663200 1 0 $X=2279300 $Y=1607400
X250 157 54 1068 1067 17 1069 731 292 1070 17 DFFSXL $T=2283600 1663200 0 0 $X=2279300 $Y=1659200
X251 157 90 1072 1071 17 1073 547 292 1074 17 DFFSXL $T=2323200 1764000 1 0 $X=2318900 $Y=1708200
X252 157 116 1076 1075 17 1077 545 292 1078 17 DFFSXL $T=2415600 1764000 0 0 $X=2411300 $Y=1760000
X253 146 556 1080 1079 17 1081 557 292 1082 17 DFFSXL $T=2448600 1663200 0 0 $X=2444300 $Y=1659200
X254 157 71 1084 1083 17 1085 378 292 1086 17 DFFSXL $T=2501400 1965600 0 0 $X=2497100 $Y=1961600
X255 146 564 1088 1087 17 1089 559 292 1090 17 DFFSXL $T=2574000 1864800 1 0 $X=2569700 $Y=1809000
X256 167 168 1092 1091 17 1093 380 292 295 17 DFFSXL $T=2593800 1562400 1 0 $X=2589500 $Y=1506600
X257 175 592 1095 1094 17 1096 570 292 1097 17 DFFSXL $T=2745600 1965600 0 0 $X=2741300 $Y=1961600
X258 175 573 1099 1098 17 1100 296 292 1101 17 DFFSXL $T=2758800 1864800 0 0 $X=2754500 $Y=1860800
X259 175 578 1103 1102 17 1104 574 292 1105 17 DFFSXL $T=2811600 1864800 1 0 $X=2807300 $Y=1809000
X260 175 577 1107 1106 17 1108 576 292 1109 17 DFFSXL $T=2818200 1764000 0 0 $X=2813900 $Y=1760000
X261 200 745 1111 1110 309 1112 580 292 781 17 DFFSXL $T=3102000 1965600 1 0 $X=3097700 $Y=1909800
X262 200 594 1114 1113 309 1115 427 292 749 17 DFFSXL $T=3102000 1965600 0 0 $X=3097700 $Y=1961600
X263 212 755 1117 1116 225 1118 431 292 629 17 DFFSXL $T=3319800 1562400 0 0 $X=3315500 $Y=1558400
X264 212 635 1120 1119 225 1121 596 292 624 17 DFFSXL $T=3326400 1663200 1 0 $X=3322100 $Y=1607400
X265 212 642 1123 1122 309 1124 641 292 645 17 DFFSXL $T=3352800 1764000 1 0 $X=3348500 $Y=1708200
X266 212 760 1126 1125 311 1127 762 292 1128 17 DFFSXL $T=3412200 1965600 0 0 $X=3407900 $Y=1961600
X267 212 763 1130 1129 309 1131 650 292 1132 17 DFFSXL $T=3597000 1663200 0 0 $X=3592700 $Y=1659200
X268 212 665 665 1133 309 1134 317 292 1135 17 DFFSXL $T=3610200 1764000 1 0 $X=3605900 $Y=1708200
X269 212 656 1137 1136 309 1138 658 292 1139 17 DFFSXL $T=3616800 1864800 0 0 $X=3612500 $Y=1860800
X270 322 308 1141 1140 309 1142 1143 292 402 17 DFFSXL $T=3729000 1965600 0 0 $X=3724700 $Y=1961600
X271 318 316 316 1144 309 1145 679 292 1146 17 DFFSXL $T=3735600 1663200 0 0 $X=3731300 $Y=1659200
X272 318 637 1148 1147 309 1149 676 292 1150 17 DFFSXL $T=3742200 1764000 0 0 $X=3737900 $Y=1760000
X273 318 308 1152 1151 309 1153 1154 292 436 17 DFFSXL $T=3768600 1864800 0 0 $X=3764300 $Y=1860800
X274 322 320 320 1155 309 1156 681 292 1157 17 DFFSXL $T=3861000 1965600 1 0 $X=3856700 $Y=1909800
X275 598 292 597 1158 17 601 NAND2BXL $T=3069000 1764000 1 0 $X=3064700 $Y=1708200
X276 600 292 602 1159 17 746 NAND2BXL $T=3095400 1864800 1 0 $X=3091100 $Y=1809000
X277 616 292 617 1160 17 611 NAND2BXL $T=3201000 1562400 0 180 $X=3170300 $Y=1506600
X278 638 292 636 1161 17 752 NAND2BXL $T=3339600 1764000 0 180 $X=3308900 $Y=1708200
X279 765 292 764 1162 17 672 NAND2BXL $T=3920400 1562400 0 180 $X=3889700 $Y=1506600
X280 768 292 691 691 17 770 NAND2BXL $T=4111800 1764000 1 0 $X=4107500 $Y=1708200
X281 700 292 695 1163 17 772 NAND2BXL $T=4144800 1864800 0 0 $X=4140500 $Y=1860800
X282 672 437 292 17 669 XOR2XL $T=3834600 1562400 1 0 $X=3830300 $Y=1506600
X283 770 440 292 17 684 XOR2XL $T=4144800 1663200 0 0 $X=4140500 $Y=1659200
X284 772 701 292 17 692 XOR2XL $T=4230600 1864800 0 180 $X=4173500 $Y=1809000
X285 402 216 1165 436 1164 1166 1167 674 292 17 671 CMPR32X1 $T=3973200 1663200 0 180 $X=3830300 $Y=1607400
X286 396 398 1169 639 1168 639 1170 687 292 17 766 CMPR32X1 $T=3913800 1864800 1 0 $X=3909500 $Y=1809000
X287 601 603 292 17 748 XOR2X1 $T=3102000 1764000 1 0 $X=3097700 $Y=1708200
X288 746 203 292 17 627 XOR2X1 $T=3128400 1864800 0 0 $X=3124100 $Y=1860800
X289 611 620 292 17 754 XOR2X1 $T=3260400 1562400 1 0 $X=3256100 $Y=1506600
X290 752 633 292 17 757 XOR2X1 $T=3286800 1663200 0 0 $X=3282500 $Y=1659200
X291 641 761 292 17 758 XOR2X1 $T=3471600 1764000 1 180 $X=3414500 $Y=1760000
X292 749 198 17 206 292 606 424 AOI211XL $T=3227400 1864800 0 180 $X=3190100 $Y=1809000
X293 781 198 17 206 292 618 631 AOI211XL $T=3240600 1965600 1 0 $X=3236300 $Y=1909800
X294 304 198 17 206 292 614 632 AOI211XL $T=3240600 1965600 0 0 $X=3236300 $Y=1961600
X295 362 406 292 17 283 OR2XL $T=1650000 1965600 0 0 $X=1645700 $Y=1961600
X296 187 427 292 17 420 OR2XL $T=2963400 1663200 0 0 $X=2959100 $Y=1659200
X297 427 549 292 17 595 OR2XL $T=3022800 1663200 0 0 $X=3018500 $Y=1659200
X298 605 545 292 17 423 OR2XL $T=3128400 1663200 1 0 $X=3124100 $Y=1607400
X299 624 431 292 17 428 OR2XL $T=3280200 1663200 1 180 $X=3249500 $Y=1659200
X300 762 179 292 17 760 OR2XL $T=3458400 1864800 1 180 $X=3427700 $Y=1860800
X301 657 640 292 17 660 OR2XL $T=3630000 1562400 0 0 $X=3625700 $Y=1558400
X302 671 678 292 17 438 OR2XL $T=3999600 1663200 1 0 $X=3995300 $Y=1607400
X303 766 615 292 17 694 OR2XL $T=4059000 1764000 0 0 $X=4054700 $Y=1760000
X304 771 401 292 17 441 OR2XL $T=4184400 1965600 0 0 $X=4180100 $Y=1961600
X305 387 1171 302 292 17 303 XNOR2XL $T=3022800 1965600 0 0 $X=3018500 $Y=1961600
X306 593 1172 744 292 17 605 XNOR2XL $T=3069000 1663200 1 0 $X=3064700 $Y=1607400
X307 426 1173 612 292 17 433 XNOR2XL $T=3201000 1562400 1 180 $X=3143900 $Y=1558400
X308 690 1174 693 292 17 670 XNOR2XL $T=4092000 1663200 1 0 $X=4087700 $Y=1607400
X309 702 1175 327 292 17 689 XNOR2XL $T=4158000 1965600 1 180 $X=4100900 $Y=1961600
X310 699 1176 698 292 17 686 XNOR2XL $T=4144800 1764000 0 0 $X=4140500 $Y=1760000
X311 68 273 477 292 488 17 OAI2BB1XL $T=1069200 1965600 1 0 $X=1064900 $Y=1909800
X312 55 277 494 292 516 17 OAI2BB1XL $T=1260600 1461600 1 180 $X=1223300 $Y=1457600
X313 66 713 498 292 501 17 OAI2BB1XL $T=1313400 1461600 0 0 $X=1309100 $Y=1457600
X314 27 444 25 292 80 17 OAI2BB1X1 $T=310200 1764000 0 0 $X=305900 $Y=1760000
X315 292 17 11 19 1177 1178 23 443 1179 8 19 1180 23 450 1181 ICV_1 $T=0 1764000 0 0 $X=-4300 $Y=1760000
X316 292 17 8 10 1182 1183 23 333 1184 16 257 1185 23 15 1186 ICV_1 $T=92400 1864800 1 0 $X=88100 $Y=1809000
X317 292 17 8 12 1187 1188 23 26 1189 8 18 1190 23 457 1191 ICV_1 $T=217800 1663200 0 0 $X=213500 $Y=1659200
X318 292 17 45 10 1192 1193 255 336 1194 45 258 1195 17 340 1196 ICV_1 $T=237600 1965600 0 0 $X=233300 $Y=1961600
X319 292 17 16 261 1197 1198 17 462 1199 16 38 38 17 468 1200 ICV_1 $T=475200 1663200 0 0 $X=470900 $Y=1659200
X320 292 17 52 262 1201 1202 17 472 1203 47 98 1204 17 474 1205 ICV_1 $T=640200 1965600 1 0 $X=635900 $Y=1909800
X321 292 17 34 38 1206 1207 17 473 1208 47 38 1209 17 710 1210 ICV_1 $T=739200 1562400 1 0 $X=734900 $Y=1506600
X322 292 17 75 276 1211 1212 73 495 1213 75 71 1214 73 496 1215 ICV_1 $T=1128600 1562400 0 0 $X=1124300 $Y=1558400
X323 292 17 34 71 1216 1217 73 499 1218 88 276 1219 274 504 1220 ICV_1 $T=1221000 1764000 1 0 $X=1216700 $Y=1708200
X324 292 17 88 38 1221 1222 274 503 1223 5 276 1224 274 514 1225 ICV_1 $T=1320000 1864800 1 0 $X=1315700 $Y=1809000
X325 292 17 102 90 1226 1227 73 715 1228 102 120 120 17 410 1229 ICV_1 $T=1478400 1461600 0 0 $X=1474100 $Y=1457600
X326 292 17 5 108 1230 1231 274 520 1232 92 108 1233 17 527 1234 ICV_1 $T=1557600 1965600 1 0 $X=1553300 $Y=1909800
X327 292 17 88 71 1235 1236 17 525 1237 127 276 1238 17 535 1239 ICV_1 $T=1749000 1764000 1 0 $X=1744700 $Y=1708200
X328 292 17 157 120 1240 1241 17 553 1242 146 732 732 17 562 1243 ICV_1 $T=2475000 1864800 0 0 $X=2470700 $Y=1860800
X329 292 17 146 563 1244 1245 17 733 1246 175 567 1247 17 571 1248 ICV_1 $T=2554200 1764000 1 0 $X=2549900 $Y=1708200
X330 292 17 175 568 1249 1250 17 566 1251 175 579 1252 17 565 1253 ICV_1 $T=2692800 1663200 0 0 $X=2688500 $Y=1659200
X331 292 17 175 572 1254 1255 17 558 1256 175 584 1257 225 561 1258 ICV_1 $T=2758800 1663200 1 0 $X=2754500 $Y=1607400
X332 292 17 212 756 1259 1260 309 390 761 212 435 1261 311 653 1262 ICV_1 $T=3333000 1965600 1 0 $X=3328700 $Y=1909800
X333 292 17 212 647 1263 1264 225 607 657 212 661 1265 309 640 666 ICV_1 $T=3451800 1562400 1 0 $X=3447500 $Y=1506600
X334 24 454 17 450 28 29 404 456 292 AOI222XL $T=369600 1764000 0 0 $X=365300 $Y=1760000
X335 29 74 17 473 269 270 468 490 292 AOI222XL $T=1128600 1663200 0 180 $X=1071500 $Y=1607400
X336 110 407 17 503 101 101 716 282 292 AOI222XL $T=1636800 1864800 1 180 $X=1579700 $Y=1860800
X337 101 507 17 518 101 101 511 361 292 AOI222XL $T=1656600 1663200 0 180 $X=1599500 $Y=1607400
X338 115 112 17 524 101 110 527 720 292 AOI222XL $T=1689600 1864800 0 0 $X=1685300 $Y=1860800
X339 101 525 17 723 110 101 721 721 292 AOI222XL $T=1702800 1562400 0 0 $X=1698500 $Y=1558400
X340 145 369 17 728 286 130 725 725 292 AOI222XL $T=2039400 1965600 1 180 $X=1982300 $Y=1961600
X341 101 519 17 504 101 101 521 514 292 AOI222X1 $T=1636800 1864800 0 180 $X=1579700 $Y=1809000
X342 532 292 97 17 521 530 NAND3XL $T=1854600 1562400 1 180 $X=1823900 $Y=1558400
X343 414 292 538 17 537 522 NAND3XL $T=2032800 1663200 0 180 $X=2002100 $Y=1607400
X344 179 292 383 17 382 385 NAND3XL $T=2890800 1461600 0 0 $X=2886500 $Y=1457600
X345 445 17 27 24 449 20 292 AOI22XL $T=290400 1965600 1 0 $X=286100 $Y=1909800
X346 446 17 27 24 452 455 292 AOI22XL $T=303600 1562400 0 0 $X=299300 $Y=1558400
X347 448 17 27 24 337 403 292 AOI22XL $T=369600 1461600 0 0 $X=365300 $Y=1457600
X348 704 17 24 27 447 458 292 AOI22XL $T=369600 1562400 1 0 $X=365300 $Y=1506600
X349 457 17 28 29 259 706 292 AOI22XL $T=376200 1864800 0 0 $X=371900 $Y=1860800
X350 462 17 24 29 460 459 292 AOI22XL $T=382800 1965600 1 0 $X=378500 $Y=1909800
X351 464 17 28 27 341 707 292 AOI22XL $T=627000 1965600 0 0 $X=622700 $Y=1961600
X352 466 17 269 270 345 708 292 AOI22XL $T=851400 1663200 0 180 $X=814100 $Y=1607400
X353 471 17 269 55 476 477 292 AOI22XL $T=844800 1764000 0 0 $X=840500 $Y=1760000
X354 467 17 270 66 479 709 292 AOI22XL $T=897600 1663200 0 0 $X=893300 $Y=1659200
X355 478 17 269 70 484 482 292 AOI22XL $T=1029600 1663200 1 0 $X=1025300 $Y=1607400
X356 65 17 68 66 486 494 292 AOI22XL $T=1042800 1562400 1 0 $X=1038500 $Y=1506600
X357 483 17 66 70 485 487 292 AOI22XL $T=1042800 1663200 0 0 $X=1038500 $Y=1659200
X358 481 17 66 29 491 405 292 AOI22XL $T=1122000 1864800 0 0 $X=1117700 $Y=1860800
X359 472 17 68 66 492 349 292 AOI22XL $T=1122000 1965600 1 0 $X=1117700 $Y=1909800
X360 465 17 78 29 493 350 292 AOI22XL $T=1155000 1864800 0 0 $X=1150700 $Y=1860800
X361 495 17 70 55 489 498 292 AOI22XL $T=1267200 1461600 0 0 $X=1262900 $Y=1457600
X362 82 17 55 269 497 500 292 AOI22XL $T=1267200 1965600 1 0 $X=1262900 $Y=1909800
X363 496 17 70 269 499 502 292 AOI22XL $T=1287000 1663200 1 0 $X=1282700 $Y=1607400
X364 715 17 115 110 513 508 292 AOI22XL $T=1590600 1562400 0 180 $X=1553300 $Y=1506600
X365 526 17 115 110 515 523 292 AOI22XL $T=1722600 1562400 0 180 $X=1685300 $Y=1506600
X366 410 17 115 110 363 777 292 AOI22XL $T=1722600 1965600 1 180 $X=1685300 $Y=1961600
X367 727 17 286 130 535 532 292 AOI22XL $T=1980000 1663200 0 180 $X=1942700 $Y=1607400
X368 726 17 286 130 536 724 292 AOI22XL $T=1999800 1461600 1 180 $X=1962500 $Y=1457600
X369 778 17 286 137 539 538 292 AOI22XL $T=2019600 1663200 0 0 $X=2015300 $Y=1659200
X370 416 17 137 145 541 534 292 AOI22XL $T=2085600 1663200 1 180 $X=2048300 $Y=1659200
X371 136 17 286 137 287 371 292 AOI22XL $T=2079000 1965600 0 0 $X=2074700 $Y=1961600
X372 292 17 137 145 542 415 292 AOI22XL $T=2118600 1764000 0 180 $X=2081300 $Y=1708200
X373 289 17 138 130 417 537 292 AOI22XL $T=2158200 1663200 1 180 $X=2120900 $Y=1659200
X374 729 17 137 145 543 529 292 AOI22XL $T=2151600 1864800 0 0 $X=2147300 $Y=1860800
X375 547 17 138 141 159 411 292 AOI22XL $T=2204400 1663200 1 180 $X=2167100 $Y=1659200
X376 550 17 145 141 293 414 292 AOI22XL $T=2204400 1965600 0 180 $X=2167100 $Y=1909800
X377 549 17 141 138 545 412 292 AOI22XL $T=2224200 1864800 0 180 $X=2186900 $Y=1809000
X378 553 17 138 141 551 531 292 AOI22XL $T=2310000 1965600 0 180 $X=2272700 $Y=1909800
X379 413 292 482 268 711 712 17 NAND4XL $T=996600 1663200 0 0 $X=992300 $Y=1659200
X380 487 292 81 490 406 267 17 NAND4XL $T=1240800 1663200 1 0 $X=1236500 $Y=1607400
X381 502 292 719 721 517 718 17 NAND4XL $T=1669800 1663200 1 0 $X=1665500 $Y=1607400
X382 529 292 94 531 509 777 17 NAND4XL $T=1788600 1965600 1 180 $X=1751300 $Y=1961600
X383 412 292 534 523 533 117 17 NAND4XL $T=1927200 1663200 0 180 $X=1889900 $Y=1607400
X384 724 292 366 415 365 411 17 NAND4XL $T=1953600 1461600 1 180 $X=1916300 $Y=1457600
X385 33 53 292 17 CLKBUFX3 $T=693000 1461600 0 0 $X=688700 $Y=1457600
X386 116 276 292 17 CLKBUFX3 $T=1788600 1864800 0 0 $X=1784300 $Y=1860800
X387 368 3 292 17 CLKBUFX3 $T=2032800 1461600 1 180 $X=2002100 $Y=1457600
X388 298 300 292 17 CLKBUFX3 $T=2923800 1461600 0 0 $X=2919500 $Y=1457600
X389 214 225 17 292 CLKINVX4 $T=3359400 1562400 0 180 $X=3328700 $Y=1506600
X390 705 17 292 260 CLKBUFX2 $T=389400 1663200 1 0 $X=385100 $Y=1607400
X391 575 17 292 181 CLKBUFX2 $T=2791800 1764000 1 180 $X=2761100 $Y=1760000
X392 742 17 292 194 CLKBUFX2 $T=3069000 1562400 0 0 $X=3064700 $Y=1558400
X393 199 17 292 201 CLKBUFX2 $T=3095400 1562400 0 0 $X=3091100 $Y=1558400
X394 319 17 292 233 CLKBUFX2 $T=3748800 1562400 0 180 $X=3718100 $Y=1506600
X395 394 17 292 234 CLKBUFX2 $T=3795000 1461600 1 180 $X=3764300 $Y=1457600
X396 395 17 292 237 CLKBUFX2 $T=3834600 1461600 1 180 $X=3803900 $Y=1457600
X397 323 17 292 238 CLKBUFX2 $T=3874200 1562400 1 180 $X=3843500 $Y=1558400
X398 682 17 292 397 CLKBUFX2 $T=3973200 1663200 1 180 $X=3942500 $Y=1659200
X399 439 17 292 243 CLKBUFX2 $T=4039200 1965600 1 180 $X=4008500 $Y=1961600
X400 418 17 182 418 292 175 AND2X2 $T=2871000 1965600 0 0 $X=2866700 $Y=1961600
X401 312 17 182 1266 292 212 AND2X2 $T=3550800 1864800 0 0 $X=3546500 $Y=1860800
X402 443 292 17 104 BUFX1 $T=92400 1965600 1 0 $X=88100 $Y=1909800
X403 456 292 17 22 BUFX1 $T=363000 1864800 1 180 $X=332300 $Y=1860800
X404 725 292 17 413 BUFX1 $T=1993200 1965600 0 180 $X=1962500 $Y=1909800
X405 540 292 17 132 BUFX1 $T=2065800 1562400 0 180 $X=2035100 $Y=1506600
X406 731 292 17 373 BUFX1 $T=2409000 1864800 0 0 $X=2404700 $Y=1860800
X407 554 292 17 84 BUFX1 $T=2442000 1562400 0 0 $X=2437700 $Y=1558400
X408 717 409 408 720 292 17 528 AND4XL $T=1643400 1864800 0 0 $X=1639100 $Y=1860800
X409 354 17 272 292 CLKINVX3 $T=1425600 1461600 1 180 $X=1401500 $Y=1457600
X410 355 17 96 292 CLKINVX3 $T=1465200 1461600 1 180 $X=1441100 $Y=1457600
X411 370 17 139 292 CLKINVX3 $T=2065800 1461600 0 0 $X=2061500 $Y=1457600
X412 453 270 17 264 451 265 292 AOI22X1 $T=640200 1562400 0 0 $X=635900 $Y=1558400
X413 463 29 17 78 469 46 292 AOI22X1 $T=719400 1461600 0 0 $X=715100 $Y=1457600
X414 470 66 17 55 475 271 292 AOI22X1 $T=838200 1864800 0 0 $X=833900 $Y=1860800
X415 346 68 17 55 710 63 292 AOI22X1 $T=950400 1461600 0 0 $X=946100 $Y=1457600
X416 681 677 317 678 17 292 675 ADDFHXL $T=4026000 1764000 0 180 $X=3876500 $Y=1708200
X417 321 679 615 615 17 292 688 ADDFHXL $T=3887400 1764000 0 0 $X=3883100 $Y=1760000
X418 8 256 1267 23 1268 451 292 1269 17 DFFSX1 $T=145200 1663200 1 0 $X=140900 $Y=1607400
X419 16 256 1270 23 1271 453 292 1272 17 DFFSX1 $T=217800 1562400 1 0 $X=213500 $Y=1506600
X420 11 256 1273 23 1274 469 292 1275 17 DFFSX1 $T=600600 1562400 1 0 $X=596300 $Y=1506600
X421 34 54 1276 17 1277 471 292 1278 17 DFFSX1 $T=640200 1864800 1 0 $X=635900 $Y=1809000
X422 62 256 1279 17 1280 470 292 1281 17 DFFSX1 $T=864600 1764000 0 180 $X=734900 $Y=1708200
X423 62 90 1282 17 1283 343 292 1284 17 DFFSX1 $T=871200 1663200 1 180 $X=741500 $Y=1659200
X424 47 256 1285 17 1286 475 292 1287 17 DFFSX1 $T=765600 1864800 1 0 $X=761300 $Y=1809000
X425 47 54 1288 17 1289 476 292 1290 17 DFFSX1 $T=891000 1864800 1 0 $X=886700 $Y=1809000
X426 47 10 1291 274 1292 51 292 1293 17 DFFSX1 $T=970200 1965600 0 0 $X=965900 $Y=1961600
X427 62 71 1294 274 1295 486 292 1296 17 DFFSX1 $T=1089000 1764000 0 0 $X=1084700 $Y=1760000
X428 34 90 1297 73 1298 352 292 1299 17 DFFSX1 $T=1135200 1562400 1 0 $X=1130900 $Y=1506600
X429 34 120 120 274 1300 497 292 1301 17 DFFSX1 $T=1234200 1965600 0 0 $X=1229900 $Y=1961600
X430 5 120 1302 274 1303 280 292 1304 17 DFFSX1 $T=1491600 1965600 1 180 $X=1361900 $Y=1961600
X431 5 90 1305 274 1306 511 292 1307 17 DFFSX1 $T=1445400 1864800 0 0 $X=1441100 $Y=1860800
X432 92 90 90 274 1308 513 292 1309 17 DFFSX1 $T=1485000 1663200 0 0 $X=1480700 $Y=1659200
X433 88 90 1310 73 1311 507 292 1312 17 DFFSX1 $T=1623600 1562400 1 180 $X=1493900 $Y=1558400
X434 100 90 1313 17 1314 518 292 1315 17 DFFSX1 $T=1867800 1663200 1 180 $X=1738100 $Y=1659200
X435 125 90 1316 17 1317 726 292 1318 17 DFFSX1 $T=1881000 1562400 1 0 $X=1876700 $Y=1506600
X436 134 90 1319 17 1320 292 292 1321 17 DFFSX1 $T=2013000 1764000 0 0 $X=2008700 $Y=1760000
X437 127 90 1322 17 1323 536 292 1324 17 DFFSX1 $T=2019600 1562400 0 0 $X=2015300 $Y=1558400
X438 134 120 1325 17 1326 729 292 1327 17 DFFSX1 $T=2019600 1864800 0 0 $X=2015300 $Y=1860800
X439 134 71 1328 17 1329 539 292 1330 17 DFFSX1 $T=2026200 1965600 1 0 $X=2021900 $Y=1909800
X440 154 116 1331 17 1332 549 292 1333 17 DFFSX1 $T=2343000 1864800 1 0 $X=2338700 $Y=1809000
X441 154 120 1334 17 1335 551 292 1336 17 DFFSX1 $T=2343000 1965600 1 0 $X=2338700 $Y=1909800
X442 154 71 1337 17 1338 293 292 1339 17 DFFSX1 $T=2488200 1965600 1 180 $X=2358500 $Y=1961600
X443 146 569 1340 17 1341 169 292 1342 17 DFFSX1 $T=2745600 1965600 0 180 $X=2615900 $Y=1909800
X444 175 188 1343 17 1344 560 292 1345 17 DFFSX1 $T=2719200 1562400 0 0 $X=2714900 $Y=1558400
X445 182 183 1346 17 1347 575 292 1348 17 DFFSX1 $T=2851200 1562400 0 0 $X=2846900 $Y=1558400
X446 182 384 1349 17 1350 177 292 1351 17 DFFSX1 $T=2897400 1965600 0 0 $X=2893100 $Y=1961600
X447 190 589 1352 225 1353 742 292 1354 17 DFFSX1 $T=2963400 1461600 0 0 $X=2959100 $Y=1457600
X448 212 649 1355 225 1356 639 292 1357 17 DFFSX1 $T=3458400 1663200 1 0 $X=3454100 $Y=1607400
X449 212 651 1358 225 1359 615 292 1360 17 DFFSX1 $T=3478200 1764000 1 0 $X=3473900 $Y=1708200
X450 212 324 1361 225 1362 307 292 1363 17 DFFSX1 $T=3504600 1764000 0 0 $X=3500300 $Y=1760000
X451 212 662 1364 309 1365 216 292 1366 17 DFFSX1 $T=3590400 1663200 1 0 $X=3586100 $Y=1607400
X452 212 663 1367 309 1368 393 292 1369 17 DFFSX1 $T=3590400 1965600 0 0 $X=3586100 $Y=1961600
X453 212 664 1370 309 1371 643 292 1372 17 DFFSX1 $T=3597000 1965600 1 0 $X=3592700 $Y=1909800
X454 182 668 1373 309 1374 667 292 1375 17 DFFSX1 $T=3715800 1562400 0 0 $X=3711500 $Y=1558400
X455 318 320 1376 309 1377 677 292 1378 17 DFFSX1 $T=3755400 1864800 1 0 $X=3751100 $Y=1809000
X456 322 637 1379 309 1380 673 292 1381 17 DFFSX1 $T=3986400 1965600 1 180 $X=3856700 $Y=1961600
X457 241 680 1382 305 1383 682 292 1384 17 DFFSX1 $T=3940200 1562400 1 0 $X=3935900 $Y=1506600
X458 241 683 1385 305 1386 439 292 1387 17 DFFSX1 $T=3960000 1562400 0 0 $X=3955700 $Y=1558400
X459 555 292 126 17 CLKINVX8 $T=2409000 1663200 0 0 $X=2404700 $Y=1659200
X460 762 653 292 654 17 210 435 OAI211XL $T=3478200 1864800 1 0 $X=3473900 $Y=1809000
X461 658 314 292 646 17 210 656 OAI211XL $T=3583800 1864800 0 180 $X=3539900 $Y=1809000
X462 730 87 292 17 INVX4 $T=2316600 1461600 0 0 $X=2312300 $Y=1457600
X463 562 71 292 17 INVX4 $T=2560800 1965600 0 180 $X=2530100 $Y=1909800
X464 733 120 292 17 INVX4 $T=2580600 1764000 1 180 $X=2549900 $Y=1760000
X465 455 292 706 17 32 NAND2X1 $T=422400 1864800 0 0 $X=418100 $Y=1860800
X466 508 292 356 17 358 510 NAND3X1 $T=1511400 1562400 1 0 $X=1507100 $Y=1506600
X467 533 17 530 292 501 364 NOR3XL $T=1914000 1461600 1 180 $X=1883300 $Y=1457600
X468 528 292 17 118 INVX1 $T=1755600 1864800 0 0 $X=1751300 $Y=1860800
X469 338 458 17 292 705 AND2XL $T=429000 1562400 0 180 $X=398300 $Y=1506600
X470 517 516 89 1388 522 17 292 284 OR4X1 $T=1643400 1562400 0 0 $X=1639100 $Y=1558400
X471 64 17 711 409 292 NOR2BXL $T=1036200 1764000 0 180 $X=1005500 $Y=1708200
X472 676 673 643 769 769 292 17 771 ADDFX1 $T=4006200 1965600 1 0 $X=4001900 $Y=1909800
X473 103 50 292 17 16 AND2X4 $T=673200 1764000 0 0 $X=668900 $Y=1760000
X474 143 50 292 17 8 AND2X4 $T=732600 1764000 0 0 $X=728300 $Y=1760000
X475 44 50 292 17 11 AND2X4 $T=739200 1864800 0 0 $X=734900 $Y=1860800
X476 344 50 292 17 45 AND2X4 $T=772200 1562400 0 0 $X=767900 $Y=1558400
X477 291 50 292 17 BUFX12 $T=2329800 1562400 0 0 $X=2325500 $Y=1558400
X478 291 150 292 17 BUFX16 $T=2329800 1562400 1 180 $X=2239700 $Y=1558400
X479 73 292 17 347 INVX3 $T=1115400 1864800 0 180 $X=1084700 $Y=1809000
X480 544 292 17 90 INVX3 $T=2184600 1562400 1 180 $X=2153900 $Y=1558400
X481 557 292 17 54 INVX3 $T=2481600 1764000 1 0 $X=2477300 $Y=1708200
X482 559 292 17 38 INVX3 $T=2521200 1965600 0 180 $X=2490500 $Y=1909800
X483 17 376 375 599 292 NOR2X1 $T=2494800 1461600 1 180 $X=2470700 $Y=1457600
X484 55 474 17 66 266 83 292 AOI22X2 $T=851400 1965600 0 0 $X=847100 $Y=1961600
X485 667 17 292 173 BUFX2 $T=3722400 1764000 1 180 $X=3691700 $Y=1760000
X486 148 1389 292 1390 131 292 17 TLATNXL $T=2105400 1461600 0 0 $X=2101100 $Y=1457600
X487 148 1391 176 1392 554 292 17 TLATNXL $T=2329800 1562400 1 0 $X=2325500 $Y=1506600
X488 148 1393 372 1394 540 292 17 TLATNXL $T=2356200 1461600 0 0 $X=2351900 $Y=1457600
X489 148 1395 161 1396 374 292 17 TLATNXL $T=2402400 1562400 1 0 $X=2398100 $Y=1506600
X490 148 1397 599 1398 153 292 17 TLATNXL $T=2422200 1663200 1 0 $X=2417900 $Y=1607400
X491 148 1399 297 1400 185 292 17 TLATNXL $T=2805000 1461600 0 0 $X=2800700 $Y=1457600
X492 182 1401 297 1402 418 292 17 TLATNXL $T=2884200 1562400 1 0 $X=2879900 $Y=1506600
X493 182 1403 385 1404 235 292 17 TLATNXL $T=3663000 1461600 0 0 $X=3658700 $Y=1457600
X494 167 164 1406 1405 17 162 17 292 379 DFFSX2 $T=2567400 1663200 1 0 $X=2563100 $Y=1607400
X495 167 170 1408 1407 17 294 17 292 165 DFFSX2 $T=2580600 1562400 0 0 $X=2576300 $Y=1558400
X496 167 377 1409 377 17 379 17 292 149 DFFSX2 $T=2607000 1461600 0 0 $X=2602700 $Y=1457600
X497 190 747 1411 1410 305 251 17 292 1412 DFFSX2 $T=3148200 1461600 0 0 $X=3143900 $Y=1457600
X498 190 190 1413 190 305 249 17 292 1414 DFFSX2 $T=3517800 1461600 1 180 $X=3374900 $Y=1457600
X499 300 780 292 161 17 194 301 589 OAI221XL $T=2996400 1562400 1 0 $X=2992100 $Y=1506600
X500 300 741 292 599 17 207 301 388 OAI221XL $T=3069000 1562400 1 0 $X=3064700 $Y=1506600
X501 300 604 292 292 17 251 301 747 OAI221XL $T=3121800 1562400 1 0 $X=3117500 $Y=1506600
X502 300 389 292 288 17 249 301 190 OAI221XL $T=3300000 1461600 0 0 $X=3295700 $Y=1457600
X503 294 292 149 376 288 17 NOR3X2 $T=2580600 1461600 1 180 $X=2530100 $Y=1457600
X504 295 292 17 114 CLKBUFXL $T=2554200 1562400 0 180 $X=2523500 $Y=1506600
X505 160 292 166 17 INVX2 $T=2475000 1562400 1 0 $X=2470700 $Y=1506600
X506 160 292 180 17 INVX2 $T=2501400 1562400 0 0 $X=2497100 $Y=1558400
X507 335 403 35 292 17 NAND2X2 $T=336600 1965600 1 0 $X=332300 $Y=1909800
.ENDS
***************************************
.SUBCKT BUFX4 A Y VSS VDD
** N=5 EP=4 IP=0 FDC=6
M0 VSS A 5 VSS n18 L=1.8e-07 W=9.6e-07 $X=6200 $Y=7000 $D=6
M1 Y 5 VSS VSS n18 L=1.8e-07 W=1.2e-06 $X=14200 $Y=5700 $D=6
M2 VSS 5 Y VSS n18 L=1.8e-07 W=1.2e-06 $X=21400 $Y=5700 $D=6
M3 VDD A 5 VDD p18 L=1.8e-07 W=1.44e-06 $X=6200 $Y=27000 $D=10
M4 Y 5 VDD VDD p18 L=1.8e-07 W=1.76e-06 $X=14200 $Y=27000 $D=10
M5 VDD 5 Y VDD p18 L=1.8e-07 W=1.76e-06 $X=21400 $Y=27000 $D=10
.ENDS
***************************************
.SUBCKT NOR2X2 A B VSS VDD Y
** N=7 EP=5 IP=0 FDC=6
M0 Y A VSS VSS n18 L=1.8e-07 W=1.2e-06 $X=17800 $Y=6400 $D=6
M1 VSS B Y VSS n18 L=1.8e-07 W=1.2e-06 $X=25000 $Y=6400 $D=6
M2 6 B VDD VDD p18 L=1.8e-07 W=1.2e-06 $X=6400 $Y=28000 $D=10
M3 Y A 6 VDD p18 L=1.8e-07 W=1.2e-06 $X=12000 $Y=28000 $D=10
M4 7 A Y VDD p18 L=1.8e-07 W=1.2e-06 $X=19200 $Y=28000 $D=10
M5 VDD B 7 VDD p18 L=1.8e-07 W=1.2e-06 $X=24800 $Y=28000 $D=10
.ENDS
***************************************
.SUBCKT NOR2X4 B VDD VSS A Y
** N=8 EP=5 IP=0 FDC=10
M0 Y B VSS VSS n18 L=1.8e-07 W=1.2e-06 $X=6600 $Y=5700 $D=6
M1 VSS A Y VSS n18 L=1.8e-07 W=1.2e-06 $X=13800 $Y=5700 $D=6
M2 Y A VSS VSS n18 L=1.8e-07 W=1.2e-06 $X=21000 $Y=5700 $D=6
M3 VSS B Y VSS n18 L=1.8e-07 W=1.2e-06 $X=28200 $Y=5700 $D=6
M4 6 B VDD VDD p18 L=1.8e-07 W=1.6e-06 $X=6800 $Y=28700 $D=10
M5 Y A 6 VDD p18 L=1.8e-07 W=1.6e-06 $X=12400 $Y=28700 $D=10
M6 7 A Y VDD p18 L=1.8e-07 W=1.6e-06 $X=19600 $Y=28700 $D=10
M7 VDD B 7 VDD p18 L=1.8e-07 W=1.6e-06 $X=25200 $Y=28700 $D=10
M8 8 B VDD VDD p18 L=1.82333e-07 W=1.55814e-06 $X=32400 $Y=28700 $D=10
M9 Y A 8 VDD p18 L=1.82333e-07 W=1.55814e-06 $X=38000 $Y=28700 $D=10
.ENDS
***************************************
.SUBCKT AND2X1 A B VDD VSS Y
** N=7 EP=5 IP=0 FDC=6
M0 7 A 6 VSS n18 L=1.8e-07 W=3.2e-07 $X=5600 $Y=15050 $D=6
M1 VSS B 7 VSS n18 L=1.8e-07 W=3.2e-07 $X=11200 $Y=15050 $D=6
M2 Y 6 VSS VSS n18 L=1.8e-07 W=6e-07 $X=17300 $Y=12250 $D=6
M3 VDD A 6 VDD p18 L=1.8e-07 W=3.6e-07 $X=4100 $Y=38950 $D=10
M4 VDD B 6 VDD p18 L=1.8e-07 W=3.6e-07 $X=9900 $Y=30350 $D=10
M5 Y 6 VDD VDD p18 L=1.8e-07 W=9e-07 $X=17900 $Y=30350 $D=10
.ENDS
***************************************
.SUBCKT CLKINVX2 A VSS Y VDD
** N=4 EP=4 IP=0 FDC=3
M0 Y A VSS VSS n18 L=1.8e-07 W=6.4e-07 $X=8450 $Y=10500 $D=6
M1 Y A VDD VDD p18 L=1.8e-07 W=9e-07 $X=4600 $Y=27500 $D=10
M2 VDD A Y VDD p18 L=1.8e-07 W=9e-07 $X=11800 $Y=27500 $D=10
.ENDS
***************************************
.SUBCKT OR2X1 A B VSS VDD Y
** N=7 EP=5 IP=0 FDC=6
M0 6 A VSS VSS n18 L=1.8e-07 W=3e-07 $X=4100 $Y=10450 $D=6
M1 VSS B 6 VSS n18 L=1.8e-07 W=3e-07 $X=12100 $Y=15100 $D=6
M2 Y 6 VSS VSS n18 L=1.8e-07 W=6e-07 $X=18100 $Y=12100 $D=6
M3 7 A 6 VDD p18 L=1.8e-07 W=5.6e-07 $X=6400 $Y=33600 $D=10
M4 VDD B 7 VDD p18 L=1.8e-07 W=5.6e-07 $X=12000 $Y=33600 $D=10
M5 Y 6 VDD VDD p18 L=1.8e-07 W=9e-07 $X=18000 $Y=30200 $D=10
.ENDS
***************************************
.SUBCKT ICV_7 1 3 4 6 7 8 9 10 11 12 13 14 15 16 17 18 19 20 21 22
+ 23 24 25 26 28 30 31 32 33 34 37 38 39 40 41 42 43 44 45 47
+ 48 49 51 52 53 54 55 56 57 58 59 60 62 63 64 65 66 67 68 69
+ 70 71 72 73 74 75 76 77 78 79 80 81 82 83 84 85 86 87 88 89
+ 90 91 92 93 94 95 96 97 98 99 100 101 102 103 104 105 106 107 108 109
+ 110 111 112 113 114 115 116 117 118 119 120 122 123 124 125 126 127 128 129 131
+ 132 133 134 135 136 137 138 139 140 141 142 143 144 145 146 147 150 151 152 153
+ 154 155 156 157 159 160 161 162 166 168 170 171 172 173 174 176 177 178 179 180
+ 181 182 183 185 186 187 188 189 190 191 193 194 195 196 197 198 199 200 202 203
+ 204 205 206 207 208 209 210 211 212 213 214 215 216 217 218 219 220 221 222 223
+ 224 225 226 227 228 229 230 231 232 233 234 235 236 237 238 239 240 241 242 243
+ 244 245 246 247 248 249 250 251 252 253 254 255 256 257 258 259 260 261 262 263
+ 264 265 266 267 268 269 270 271 272 273 274 275 276 277 278 279 280 281 282 283
+ 284 285 286 287 288 289 290 291 292 293 294 295 296 297 298 299 300 301 302 303
+ 304 305 306 307 308 309 310 311 312 313 314 315 316 317 318 319 320 321 322 323
+ 324 325 326 327 328 329 330 331 332 333 334 335 336 337 338
*.CALIBRE ICV_CELL 2
** N=994 EP=315 IP=2763 FDC=5685
M0 279 427 591 279 n18 L=1.8e-07 W=3.2e-07 $X=2027700 $Y=1145450 $D=6
M1 237 354 279 279 n18 L=1.8e-07 W=6e-07 $X=2034250 $Y=1142650 $D=6
M2 279 350 237 279 n18 L=1.8e-07 W=6e-07 $X=2041500 $Y=1142650 $D=6
M3 237 591 279 279 n18 L=1.8e-07 W=6e-07 $X=2051200 $Y=1142650 $D=6
M4 207 427 591 207 p18 L=1.8e-07 W=4.8e-07 $X=2025800 $Y=1126950 $D=10
M5 993 354 207 207 p18 L=1.8e-07 W=1.4e-06 $X=2033600 $Y=1117750 $D=10
M6 994 350 993 207 p18 L=1.8e-07 W=1.4e-06 $X=2039200 $Y=1117750 $D=10
M7 237 591 994 207 p18 L=1.8e-07 W=1.4e-06 $X=2045000 $Y=1117750 $D=10
X8 157 207 279 191 CLKINVX1 $T=3280200 1058400 1 0 $X=3275900 $Y=1002600
X9 374 279 207 21 3 NAND2XL $T=442200 1461600 1 0 $X=437900 $Y=1405800
X10 390 279 207 534 47 NAND2XL $T=1102200 1260000 0 0 $X=1097900 $Y=1256000
X11 537 279 207 538 54 NAND2XL $T=1207800 1159200 0 0 $X=1203500 $Y=1155200
X12 288 279 207 57 402 NAND2XL $T=1280400 1360800 0 0 $X=1276100 $Y=1356800
X13 289 279 207 20 587 NAND2XL $T=1326600 1159200 0 180 $X=1302500 $Y=1103400
X14 389 279 207 405 58 NAND2XL $T=1379400 1260000 1 0 $X=1375100 $Y=1204200
X15 422 279 207 545 415 NAND2XL $T=1729200 1159200 1 180 $X=1705100 $Y=1155200
X16 589 279 207 418 590 NAND2XL $T=1749000 1058400 0 180 $X=1724900 $Y=1002600
X17 350 279 207 545 345 NAND2XL $T=1749000 1159200 1 180 $X=1724900 $Y=1155200
X18 78 279 207 80 547 NAND2XL $T=1755600 957600 0 0 $X=1751300 $Y=953600
X19 427 279 207 426 348 NAND2XL $T=1775400 1058400 1 180 $X=1751300 $Y=1054400
X20 348 279 207 350 425 NAND2XL $T=1755600 1159200 0 0 $X=1751300 $Y=1155200
X21 406 279 207 232 233 NAND2XL $T=1874400 1461600 0 180 $X=1850300 $Y=1405800
X22 431 279 207 438 342 NAND2XL $T=1874400 1159200 0 0 $X=1870100 $Y=1155200
X23 551 279 207 440 344 NAND2XL $T=1973400 1159200 0 180 $X=1949300 $Y=1103400
X24 353 279 207 349 354 NAND2XL $T=1960200 1159200 0 0 $X=1955900 $Y=1155200
X25 551 279 207 442 347 NAND2XL $T=1966800 1058400 0 0 $X=1962500 $Y=1054400
X26 440 279 207 86 443 NAND2XL $T=1999800 1159200 0 180 $X=1975700 $Y=1103400
X27 450 279 207 86 112 NAND2XL $T=2270400 1159200 1 0 $X=2266100 $Y=1103400
X28 463 279 207 307 126 NAND2XL $T=2409000 1058400 1 0 $X=2404700 $Y=1002600
X29 126 279 207 125 469 NAND2XL $T=2468400 1159200 0 180 $X=2444300 $Y=1103400
X30 171 279 207 139 473 NAND2XL $T=2574000 1159200 0 180 $X=2549900 $Y=1103400
X31 136 279 207 365 245 NAND2XL $T=2580600 1461600 0 180 $X=2556500 $Y=1405800
X32 9 279 207 137 141 NAND2XL $T=2574000 1159200 1 0 $X=2569700 $Y=1103400
X33 366 279 207 8 480 NAND2XL $T=2580600 1260000 0 0 $X=2576300 $Y=1256000
X34 9 279 207 135 140 NAND2XL $T=2587200 1159200 0 0 $X=2582900 $Y=1155200
X35 138 279 207 249 479 NAND2XL $T=2620200 1360800 0 180 $X=2596100 $Y=1305000
X36 9 279 207 144 143 NAND2XL $T=2666400 1159200 1 180 $X=2642300 $Y=1155200
X37 247 279 207 360 487 NAND2XL $T=2673000 1260000 0 0 $X=2668700 $Y=1256000
X38 9 279 207 489 561 NAND2XL $T=2811600 1360800 0 180 $X=2787500 $Y=1305000
X39 491 279 207 125 313 NAND2XL $T=2851200 1461600 1 0 $X=2846900 $Y=1405800
X40 207 349 423 545 279 NOR2XL $T=1729200 1159200 1 0 $X=1724900 $Y=1103400
X41 207 551 442 353 279 NOR2XL $T=1953600 1058400 1 180 $X=1929500 $Y=1054400
X42 207 350 427 438 279 NOR2XL $T=2006400 1159200 1 180 $X=1982300 $Y=1155200
X43 207 431 438 450 279 NOR2XL $T=2013000 1159200 0 0 $X=2008700 $Y=1155200
X44 207 450 240 552 279 NOR2XL $T=2250600 1260000 0 180 $X=2226500 $Y=1204200
X45 207 465 113 466 279 NOR2XL $T=2323200 1159200 1 0 $X=2318900 $Y=1103400
X46 207 116 118 356 279 NOR2XL $T=2402400 1058400 0 180 $X=2378300 $Y=1002600
X47 207 361 362 451 279 NOR2XL $T=2475000 1260000 1 0 $X=2470700 $Y=1204200
X48 207 237 116 244 279 NOR2XL $T=2501400 957600 1 180 $X=2477300 $Y=953600
X49 207 131 8 369 279 NOR2XL $T=2527800 1360800 0 0 $X=2523500 $Y=1356800
X50 207 479 131 365 279 NOR2XL $T=2600400 1360800 0 180 $X=2576300 $Y=1305000
X51 207 368 361 151 279 NOR2XL $T=2725800 1360800 1 0 $X=2721500 $Y=1305000
X52 347 207 279 426 INVXL $T=1729200 1058400 0 0 $X=1724900 $Y=1054400
X53 53 207 279 346 INVXL $T=1742400 1360800 0 0 $X=1738100 $Y=1356800
X54 348 207 279 348 INVXL $T=1749000 1159200 1 0 $X=1744700 $Y=1103400
X55 353 207 279 351 INVXL $T=1854600 1159200 1 180 $X=1837100 $Y=1155200
X56 90 207 279 83 INVXL $T=1887600 1360800 0 0 $X=1883300 $Y=1356800
X57 302 207 279 453 INVXL $T=2092200 957600 0 0 $X=2087900 $Y=953600
X58 239 207 279 459 INVXL $T=2270400 1058400 0 0 $X=2266100 $Y=1054400
X59 458 207 279 553 INVXL $T=2270400 1260000 1 0 $X=2266100 $Y=1204200
X60 466 207 279 467 INVXL $T=2382600 1159200 0 0 $X=2378300 $Y=1155200
X61 340 207 279 241 INVXL $T=2455200 1360800 1 180 $X=2437700 $Y=1356800
X62 237 207 279 557 INVXL $T=2501400 957600 0 0 $X=2497100 $Y=953600
X63 365 207 279 555 INVXL $T=2534400 1360800 0 180 $X=2516900 $Y=1305000
X64 487 207 279 362 INVXL $T=2673000 1260000 1 180 $X=2655500 $Y=1256000
X65 363 207 279 253 INVXL $T=2719200 1058400 1 0 $X=2714900 $Y=1002600
X66 455 207 279 592 INVXL $T=2791800 1159200 0 0 $X=2787500 $Y=1155200
X67 485 207 279 420 INVXL $T=2791800 1260000 1 0 $X=2787500 $Y=1204200
X68 151 207 279 593 INVXL $T=2890800 1461600 1 0 $X=2886500 $Y=1405800
X69 9 207 279 491 INVXL $T=2897400 1360800 0 0 $X=2893100 $Y=1356800
X70 454 207 279 566 INVXL $T=2910600 1360800 0 0 $X=2906300 $Y=1356800
X71 461 207 279 594 INVXL $T=2937000 1159200 0 0 $X=2932700 $Y=1155200
X72 456 207 279 595 INVXL $T=2950200 1159200 1 0 $X=2945900 $Y=1103400
X73 476 207 279 596 INVXL $T=3016200 1360800 1 0 $X=3011900 $Y=1305000
X74 474 207 279 572 INVXL $T=3069000 1058400 0 0 $X=3064700 $Y=1054400
X75 462 207 279 573 INVXL $T=3108600 1360800 0 0 $X=3104300 $Y=1356800
X76 357 207 279 496 INVXL $T=3148200 1260000 0 0 $X=3143900 $Y=1256000
X77 339 207 279 576 INVXL $T=3168000 1159200 1 0 $X=3163700 $Y=1103400
X78 499 207 279 599 INVXL $T=3260400 1360800 1 0 $X=3256100 $Y=1305000
X79 372 207 279 598 INVXL $T=3267000 1260000 1 0 $X=3262700 $Y=1204200
X80 303 207 279 320 INVXL $T=3280200 1461600 1 0 $X=3275900 $Y=1405800
X81 416 207 279 579 INVXL $T=3300000 1058400 0 0 $X=3295700 $Y=1054400
X82 336 207 279 511 INVXL $T=4072200 1058400 0 180 $X=4054700 $Y=1002600
X83 193 207 279 517 INVXL $T=4078800 1058400 1 180 $X=4061300 $Y=1054400
X84 273 207 279 373 INVXL $T=4085400 1058400 0 180 $X=4067900 $Y=1002600
X85 276 207 279 516 INVXL $T=4085400 1159200 0 180 $X=4067900 $Y=1103400
X86 274 207 279 518 INVXL $T=4085400 1260000 0 180 $X=4067900 $Y=1204200
X87 275 207 279 523 INVXL $T=4085400 1260000 1 180 $X=4067900 $Y=1256000
X88 277 207 279 519 INVXL $T=4085400 1360800 0 180 $X=4067900 $Y=1305000
X89 338 207 279 520 INVXL $T=4092000 1058400 1 180 $X=4074500 $Y=1054400
X90 278 207 279 522 INVXL $T=4092000 1360800 1 180 $X=4074500 $Y=1356800
X91 337 207 279 524 INVXL $T=4098600 1058400 0 180 $X=4081100 $Y=1002600
X92 292 279 291 228 207 290 OAI21XL $T=1597200 957600 1 180 $X=1566500 $Y=953600
X93 430 279 231 86 207 435 OAI21XL $T=1801800 1260000 0 0 $X=1797500 $Y=1256000
X94 472 279 132 125 207 133 OAI21XL $T=2521200 1159200 1 0 $X=2516900 $Y=1103400
X95 237 279 557 306 207 310 OAI21XL $T=2527800 957600 0 0 $X=2523500 $Y=953600
X96 479 279 475 360 207 477 OAI21XL $T=2574000 1260000 0 180 $X=2543300 $Y=1204200
X97 142 279 139 464 207 559 OAI21XL $T=2607000 1058400 1 180 $X=2576300 $Y=1054400
X98 480 279 134 478 207 147 OAI21XL $T=2620200 1159200 0 0 $X=2615900 $Y=1155200
X99 472 279 150 125 207 560 OAI21XL $T=2706000 1260000 0 180 $X=2675300 $Y=1204200
X100 156 279 489 157 207 490 OAI21XL $T=2877600 1058400 0 180 $X=2846900 $Y=1002600
X101 434 552 207 109 600 279 458 AOI21XL $T=2197800 1159200 0 0 $X=2193500 $Y=1155200
X102 356 237 207 114 601 279 554 AOI21XL $T=2362800 1058400 0 180 $X=2332100 $Y=1002600
X103 480 134 207 131 602 279 478 AOI21XL $T=2580600 1159200 1 180 $X=2549900 $Y=1155200
X104 13 12 603 12 205 604 374 279 605 207 DFFSXL $T=231000 1461600 1 0 $X=226700 $Y=1405800
X105 14 204 607 606 205 608 375 279 609 207 DFFSXL $T=264000 1360800 0 0 $X=259700 $Y=1356800
X106 14 280 611 610 205 612 17 279 613 207 DFFSXL $T=277200 1260000 0 0 $X=272900 $Y=1256000
X107 14 12 615 614 205 616 376 279 617 207 DFFSXL $T=297000 1260000 1 0 $X=292700 $Y=1204200
X108 28 204 619 618 205 620 377 279 621 207 DFFSXL $T=415800 1260000 0 0 $X=411500 $Y=1256000
X109 28 203 623 622 205 624 378 279 625 207 DFFSXL $T=422400 1360800 1 0 $X=418100 $Y=1305000
X110 28 12 627 626 207 628 380 279 629 207 DFFSXL $T=435600 1159200 1 0 $X=431300 $Y=1103400
X111 28 206 631 630 205 632 382 279 633 207 DFFSXL $T=455400 1360800 0 0 $X=451100 $Y=1356800
X112 23 12 12 634 207 635 381 279 636 207 DFFSXL $T=481800 1058400 0 0 $X=477500 $Y=1054400
X113 14 63 638 637 205 639 383 279 640 207 DFFSXL $T=528000 1260000 1 0 $X=523700 $Y=1204200
X114 23 34 642 641 207 643 384 279 644 207 DFFSXL $T=547800 1260000 0 0 $X=543500 $Y=1256000
X115 23 206 646 645 205 647 525 279 648 207 DFFSXL $T=554400 1360800 1 0 $X=550100 $Y=1305000
X116 23 48 650 649 207 651 526 279 652 207 DFFSXL $T=574200 1159200 0 0 $X=569900 $Y=1155200
X117 28 48 654 653 207 655 527 279 656 207 DFFSXL $T=580800 1058400 1 0 $X=576500 $Y=1002600
X118 13 208 658 657 205 659 528 279 660 207 DFFSXL $T=594000 1461600 1 0 $X=589700 $Y=1405800
X119 23 63 662 661 207 663 530 279 664 207 DFFSXL $T=620400 1058400 0 0 $X=616100 $Y=1054400
X120 14 48 666 665 207 667 529 279 668 207 DFFSXL $T=666600 1260000 1 0 $X=662300 $Y=1204200
X121 14 206 670 669 207 671 211 279 672 207 DFFSXL $T=679800 1260000 0 0 $X=675500 $Y=1256000
X122 13 34 674 673 207 675 386 279 676 207 DFFSXL $T=686400 1360800 1 0 $X=682100 $Y=1305000
X123 28 55 55 677 207 678 388 279 679 207 DFFSXL $T=732600 957600 0 0 $X=728300 $Y=953600
X124 30 208 681 680 207 682 284 279 683 207 DFFSXL $T=798600 1461600 1 0 $X=794300 $Y=1405800
X125 30 34 685 684 207 686 585 279 687 207 DFFSXL $T=818400 1360800 0 0 $X=814100 $Y=1356800
X126 14 214 689 688 207 690 392 279 691 207 DFFSXL $T=891000 957600 0 0 $X=886700 $Y=953600
X127 23 37 693 692 207 694 33 279 695 207 DFFSXL $T=943800 1260000 0 0 $X=939500 $Y=1256000
X128 23 346 697 696 207 698 699 279 387 207 DFFSXL $T=950400 1159200 1 0 $X=946100 $Y=1103400
X129 13 45 701 700 207 702 535 279 703 207 DFFSXL $T=1036200 1159200 0 0 $X=1031900 $Y=1155200
X130 13 90 705 704 207 706 396 279 707 207 DFFSXL $T=1036200 1260000 1 0 $X=1031900 $Y=1204200
X131 40 45 709 708 217 710 287 279 711 207 DFFSXL $T=1036200 1461600 1 0 $X=1031900 $Y=1405800
X132 23 45 713 712 207 714 395 279 715 207 DFFSXL $T=1042800 957600 0 0 $X=1038500 $Y=953600
X133 30 214 717 716 217 718 398 279 719 207 DFFSXL $T=1082400 1360800 0 0 $X=1078100 $Y=1356800
X134 14 90 721 720 207 722 539 279 723 207 DFFSXL $T=1148400 1058400 1 0 $X=1144100 $Y=1002600
X135 13 48 725 724 217 726 397 279 727 207 DFFSXL $T=1168200 1260000 1 0 $X=1163900 $Y=1204200
X136 40 55 729 728 217 730 586 279 731 207 DFFSXL $T=1168200 1461600 1 0 $X=1163900 $Y=1405800
X137 23 214 733 732 217 734 399 279 735 207 DFFSXL $T=1174800 957600 0 0 $X=1170500 $Y=953600
X138 28 52 737 736 217 738 403 279 739 207 DFFSXL $T=1287000 1058400 1 0 $X=1282700 $Y=1002600
X139 28 63 741 740 217 742 407 279 743 207 DFFSXL $T=1293600 1260000 0 0 $X=1289300 $Y=1256000
X140 23 90 745 744 224 746 400 279 747 207 DFFSXL $T=1432200 957600 0 0 $X=1427900 $Y=953600
X141 13 214 749 748 224 750 413 279 751 207 DFFSXL $T=1458600 1058400 0 0 $X=1454300 $Y=1054400
X142 66 45 753 752 217 754 293 279 755 207 DFFSXL $T=1518000 1461600 1 0 $X=1513700 $Y=1405800
X143 352 549 757 756 207 758 427 279 423 207 DFFSXL $T=1821600 1159200 1 0 $X=1817300 $Y=1103400
X144 352 436 760 759 207 761 551 279 446 207 DFFSXL $T=1867800 1058400 1 0 $X=1863500 $Y=1002600
X145 352 443 763 762 207 764 442 279 440 207 DFFSXL $T=1993200 1058400 0 0 $X=1988900 $Y=1054400
X146 152 560 766 765 155 767 483 279 482 207 DFFSXL $T=2646600 1360800 0 0 $X=2642300 $Y=1356800
X147 152 561 769 768 155 770 314 279 771 207 DFFSXL $T=2772000 1360800 0 0 $X=2767700 $Y=1356800
X148 243 279 8 772 207 475 NAND2BXL $T=2468400 1360800 0 0 $X=2464100 $Y=1356800
X149 329 279 331 331 207 328 NAND2BXL $T=3762000 957600 1 180 $X=3731300 $Y=953600
X150 113 112 279 125 207 468 OAI21X1 $T=2323200 1058400 0 0 $X=2318900 $Y=1054400
X151 239 116 207 460 279 463 464 AOI211XL $T=2290200 1058400 1 0 $X=2285900 $Y=1002600
X152 116 459 207 554 279 124 238 AOI211XL $T=2336400 957600 0 0 $X=2332100 $Y=953600
X153 242 459 207 471 279 308 457 AOI211XL $T=2415600 957600 0 0 $X=2411300 $Y=953600
X154 465 237 207 556 279 124 128 AOI211XL $T=2442000 1058400 1 0 $X=2437700 $Y=1002600
X155 248 244 207 559 279 242 558 AOI211XL $T=2593800 957600 1 180 $X=2556500 $Y=953600
X156 415 355 279 207 409 OR2XL $T=1511400 1159200 1 180 $X=1480700 $Y=1155200
X157 433 355 279 207 225 OR2XL $T=1564200 1360800 0 180 $X=1533500 $Y=1305000
X158 415 351 279 207 542 OR2XL $T=1570800 1159200 1 180 $X=1540100 $Y=1155200
X159 433 347 279 207 412 OR2XL $T=1570800 1260000 1 180 $X=1540100 $Y=1256000
X160 342 347 279 207 543 OR2XL $T=1597200 1260000 1 180 $X=1566500 $Y=1256000
X161 342 355 279 207 227 OR2XL $T=1603800 1360800 0 180 $X=1573100 $Y=1305000
X162 415 344 279 207 414 OR2XL $T=1617000 1260000 0 180 $X=1586300 $Y=1204200
X163 345 351 279 207 544 OR2XL $T=1610400 1159200 0 0 $X=1606100 $Y=1155200
X164 345 344 279 207 343 OR2XL $T=1656600 1260000 0 180 $X=1625900 $Y=1204200
X165 425 349 279 207 421 OR2XL $T=1749000 1260000 0 180 $X=1718300 $Y=1204200
X166 433 351 279 207 437 OR2XL $T=1821600 1360800 1 0 $X=1817300 $Y=1305000
X167 433 344 279 207 550 OR2XL $T=1914000 1360800 1 0 $X=1909700 $Y=1305000
X168 344 431 279 207 234 OR2XL $T=1953600 1360800 1 0 $X=1949300 $Y=1305000
X169 347 431 279 207 100 OR2XL $T=1999800 1260000 1 0 $X=1995500 $Y=1204200
X170 552 109 279 207 72 OR2XL $T=2184600 1159200 1 180 $X=2153900 $Y=1155200
X171 358 359 279 207 340 OR2XL $T=2455200 1360800 1 0 $X=2450900 $Y=1305000
X172 127 237 279 207 472 OR2XL $T=2514600 1058400 0 180 $X=2483900 $Y=1002600
X173 364 368 279 207 485 OR2XL $T=2633400 1260000 1 0 $X=2629100 $Y=1204200
X174 325 773 324 279 207 323 XNOR2XL $T=3577200 1461600 0 180 $X=3520100 $Y=1405800
X175 21 397 385 279 56 207 OAI2BB1X1 $T=1174800 1260000 0 0 $X=1170500 $Y=1256000
X176 113 450 125 279 514 207 OAI2BB1X1 $T=2409000 1159200 1 0 $X=2404700 $Y=1103400
X177 18 375 207 377 20 19 16 15 279 AOI222XL $T=442200 1360800 1 180 $X=385100 $Y=1356800
X178 18 376 207 380 20 19 381 379 279 AOI222XL $T=455400 1159200 0 0 $X=451100 $Y=1155200
X179 21 396 207 539 18 19 400 401 279 AOI222XL $T=1254000 1058400 0 0 $X=1249700 $Y=1054400
X180 18 529 207 527 20 19 385 526 279 AOI222X1 $T=759000 1159200 0 180 $X=701900 $Y=1103400
X181 451 279 207 474 BUFXL $T=2521200 1159200 1 180 $X=2490500 $Y=1155200
X182 350 279 431 207 423 433 NAND3XL $T=1841400 1159200 1 180 $X=1810700 $Y=1155200
X183 347 279 351 207 86 436 NAND3XL $T=1874400 1058400 1 180 $X=1843700 $Y=1054400
X184 301 279 441 207 445 424 NAND3XL $T=1993200 957600 0 0 $X=1988900 $Y=953600
X185 126 279 472 207 473 556 NAND3XL $T=2442000 1058400 0 0 $X=2437700 $Y=1054400
X186 311 279 134 207 136 364 NAND3XL $T=2567400 1360800 0 180 $X=2536700 $Y=1305000
X187 134 279 136 207 8 358 NAND3XL $T=2574000 1260000 1 180 $X=2543300 $Y=1256000
X188 311 279 134 207 8 361 NAND3XL $T=2560800 1360800 0 0 $X=2556500 $Y=1356800
X189 250 279 248 207 370 484 NAND3XL $T=2646600 1159200 1 0 $X=2642300 $Y=1103400
X190 477 279 125 207 252 486 NAND3XL $T=2666400 1159200 0 0 $X=2662100 $Y=1155200
X191 249 279 482 207 360 359 NAND3XL $T=2712600 1360800 0 180 $X=2681900 $Y=1305000
X192 202 207 19 20 378 281 279 AOI22XL $T=396000 1461600 1 0 $X=391700 $Y=1405800
X193 525 207 42 20 382 24 279 AOI22XL $T=699600 1360800 0 0 $X=695300 $Y=1356800
X194 209 207 42 26 528 282 279 AOI22XL $T=719400 1461600 1 0 $X=715100 $Y=1405800
X195 384 207 42 26 386 283 279 AOI22XL $T=745800 1360800 0 0 $X=741500 $Y=1356800
X196 383 207 38 42 530 389 279 AOI22XL $T=811800 1260000 1 0 $X=807500 $Y=1204200
X197 531 207 38 26 532 390 279 AOI22XL $T=904200 1159200 1 0 $X=899900 $Y=1103400
X198 388 207 20 38 391 341 279 AOI22XL $T=970200 1058400 0 0 $X=965900 $Y=1054400
X199 585 207 44 20 286 285 279 AOI22XL $T=1003200 1360800 0 0 $X=998900 $Y=1356800
X200 393 207 42 73 41 534 279 AOI22XL $T=1089000 1360800 1 0 $X=1084700 $Y=1305000
X201 535 207 26 38 536 537 279 AOI22XL $T=1168200 1159200 1 0 $X=1163900 $Y=1103400
X202 219 207 20 42 395 538 279 AOI22XL $T=1214400 1159200 1 0 $X=1210100 $Y=1103400
X203 586 207 220 73 221 540 279 AOI22XL $T=1313400 1461600 1 0 $X=1309100 $Y=1405800
X204 398 207 44 57 218 406 279 AOI22XL $T=1346400 1360800 0 0 $X=1342100 $Y=1356800
X205 588 207 26 42 408 64 279 AOI22XL $T=1445400 1159200 0 0 $X=1441100 $Y=1155200
X206 411 207 26 44 541 404 279 AOI22XL $T=1498200 1260000 1 180 $X=1460900 $Y=1256000
X207 407 207 20 65 69 405 279 AOI22XL $T=1504800 1260000 0 0 $X=1500500 $Y=1256000
X208 399 207 42 26 413 79 279 AOI22XL $T=1564200 1058400 1 0 $X=1559900 $Y=1002600
X209 71 207 73 26 106 417 279 AOI22XL $T=1643400 957600 0 0 $X=1639100 $Y=953600
X210 75 207 65 216 93 589 279 AOI22XL $T=1669800 1058400 1 0 $X=1665500 $Y=1002600
X211 91 207 44 57 77 418 279 AOI22XL $T=1696200 1058400 0 0 $X=1691900 $Y=1054400
X212 85 207 65 76 297 548 279 AOI22XL $T=1795200 957600 0 0 $X=1790900 $Y=953600
X213 299 207 42 65 298 432 279 AOI22XL $T=1867800 957600 1 180 $X=1830500 $Y=953600
X214 98 207 97 102 236 445 279 AOI22XL $T=2026200 957600 0 0 $X=2021900 $Y=953600
X215 105 207 104 101 122 441 279 AOI22XL $T=2098800 1058400 0 180 $X=2061500 $Y=1002600
X216 369 207 482 8 365 367 279 AOI22XL $T=2653200 1260000 1 180 $X=2615900 $Y=1256000
X217 369 207 249 8 362 370 279 AOI22XL $T=2633400 1360800 1 0 $X=2629100 $Y=1305000
X218 159 207 252 257 360 562 279 AOI22XL $T=2864400 1360800 0 180 $X=2827100 $Y=1305000
X219 547 279 548 432 434 428 207 NAND4XL $T=1801800 1058400 1 0 $X=1797500 $Y=1002600
X220 473 279 246 477 471 464 207 NAND4XL $T=2560800 1058400 1 180 $X=2523500 $Y=1054400
X221 368 279 250 248 481 367 207 NAND4XL $T=2633400 1159200 0 180 $X=2596100 $Y=1103400
X222 447 89 279 207 CLKBUFX3 $T=2032800 1260000 1 180 $X=2002100 $Y=1256000
X223 448 6 279 207 CLKBUFX3 $T=2032800 1360800 0 180 $X=2002100 $Y=1305000
X224 500 172 279 207 CLKBUFX3 $T=3313200 1058400 1 0 $X=3308900 $Y=1002600
X225 81 217 207 279 CLKINVX4 $T=1399200 1461600 1 0 $X=1394900 $Y=1405800
X226 81 226 207 279 CLKINVX4 $T=1445400 1461600 1 0 $X=1441100 $Y=1405800
X227 467 240 207 279 CLKINVX4 $T=2349600 1260000 1 0 $X=2345300 $Y=1204200
X228 81 264 207 279 CLKINVX4 $T=3392400 1058400 0 0 $X=3388100 $Y=1054400
X229 570 207 279 200 CLKBUFX2 $T=3062400 1461600 1 0 $X=3058100 $Y=1405800
X230 493 207 279 189 CLKBUFX2 $T=3095400 1260000 0 0 $X=3091100 $Y=1256000
X231 597 207 279 195 CLKBUFX2 $T=3273600 1360800 0 0 $X=3269300 $Y=1356800
X232 502 207 279 173 CLKBUFX2 $T=3372600 1058400 1 180 $X=3341900 $Y=1054400
X233 503 207 279 10 CLKBUFX2 $T=3372600 1159200 0 180 $X=3341900 $Y=1103400
X234 504 207 279 196 CLKBUFX2 $T=3372600 1360800 0 180 $X=3341900 $Y=1305000
X235 581 207 279 174 CLKBUFX2 $T=3385800 1360800 1 0 $X=3381500 $Y=1305000
X236 583 207 279 194 CLKBUFX2 $T=3458400 1159200 0 0 $X=3454100 $Y=1155200
X237 506 207 279 177 CLKBUFX2 $T=3531000 1360800 0 180 $X=3500300 $Y=1305000
X238 509 207 279 179 CLKBUFX2 $T=3564000 1360800 0 180 $X=3533300 $Y=1305000
X239 508 207 279 181 CLKBUFX2 $T=3570600 1260000 0 180 $X=3539900 $Y=1204200
X240 513 207 279 183 CLKBUFX2 $T=3616800 1260000 0 180 $X=3586100 $Y=1204200
X241 515 207 279 188 CLKBUFX2 $T=3722400 1461600 0 180 $X=3691700 $Y=1405800
X242 521 207 279 190 CLKBUFX2 $T=3907200 1461600 0 180 $X=3876500 $Y=1405800
X243 439 207 72 774 279 352 AND2X2 $T=1914000 1159200 0 0 $X=1909700 $Y=1155200
X244 379 279 207 22 BUFX1 $T=448800 1159200 1 180 $X=418100 $Y=1155200
X245 444 279 207 300 BUFX1 $T=1993200 1461600 0 180 $X=1962500 $Y=1405800
X246 449 279 207 94 BUFX1 $T=2059200 1461600 0 180 $X=2028500 $Y=1405800
X247 483 279 207 138 BUFX1 $T=2659800 1461600 0 180 $X=2629100 $Y=1405800
X248 341 540 404 402 279 207 223 AND4XL $T=1353000 1461600 1 0 $X=1348700 $Y=1405800
X249 409 207 19 279 CLKINVX3 $T=1267200 1159200 0 0 $X=1262900 $Y=1155200
X250 412 207 43 279 CLKINVX3 $T=1485000 1360800 1 180 $X=1460900 $Y=1356800
X251 414 207 65 279 CLKINVX3 $T=1504800 1260000 0 180 $X=1480700 $Y=1204200
X252 225 207 216 279 CLKINVX3 $T=1491600 1360800 1 0 $X=1487300 $Y=1305000
X253 544 207 26 279 CLKINVX3 $T=1623600 957600 1 180 $X=1599500 $Y=953600
X254 343 207 18 279 CLKINVX3 $T=1623600 1058400 1 180 $X=1599500 $Y=1054400
X255 70 207 76 279 CLKINVX3 $T=1683000 1461600 1 0 $X=1678700 $Y=1405800
X256 437 207 88 279 CLKINVX3 $T=1854600 1461600 0 180 $X=1830500 $Y=1405800
X257 550 207 92 279 CLKINVX3 $T=1933800 1461600 0 180 $X=1909700 $Y=1405800
X258 354 207 99 279 CLKINVX3 $T=2032800 1360800 1 0 $X=2028500 $Y=1305000
X259 234 207 101 279 CLKINVX3 $T=2065800 1360800 1 180 $X=2041700 $Y=1356800
X260 103 207 104 279 CLKINVX3 $T=2085600 1461600 0 180 $X=2061500 $Y=1405800
X261 533 42 207 216 212 215 279 AOI22X1 $T=937200 1461600 1 0 $X=932900 $Y=1405800
X262 394 38 207 20 403 59 279 AOI22X1 $T=1339800 1058400 0 0 $X=1335500 $Y=1054400
X263 222 20 207 38 392 62 279 AOI22X1 $T=1412400 1058400 1 0 $X=1408100 $Y=1002600
X264 256 166 279 207 CLKBUFX4 $T=2937000 957600 0 0 $X=2932700 $Y=953600
X265 1 161 279 207 CLKBUFX4 $T=3491400 1360800 0 180 $X=3454100 $Y=1305000
X266 23 55 775 207 776 533 279 777 207 DFFSX1 $T=712800 1058400 1 0 $X=708500 $Y=1002600
X267 14 31 778 207 779 531 279 780 207 DFFSX1 $T=792000 1159200 0 0 $X=787700 $Y=1155200
X268 13 31 781 207 782 532 279 783 207 DFFSX1 $T=811800 1260000 0 0 $X=807500 $Y=1256000
X269 14 55 784 207 785 391 279 786 207 DFFSX1 $T=844800 1058400 0 0 $X=840500 $Y=1054400
X270 23 31 787 207 788 393 279 789 207 DFFSX1 $T=904200 1260000 1 0 $X=899900 $Y=1204200
X271 30 45 790 217 791 39 279 792 207 DFFSX1 $T=950400 1360800 1 0 $X=946100 $Y=1305000
X272 14 52 793 207 794 394 279 795 207 DFFSX1 $T=1016400 1058400 1 0 $X=1012100 $Y=1002600
X273 14 45 796 207 797 536 279 798 207 DFFSX1 $T=1089000 1058400 0 0 $X=1084700 $Y=1054400
X274 40 52 799 217 800 49 279 801 207 DFFSX1 $T=1201200 1360800 1 0 $X=1196900 $Y=1305000
X275 13 52 802 217 803 588 279 804 207 DFFSX1 $T=1300200 1159200 0 0 $X=1295900 $Y=1155200
X276 23 52 805 224 806 408 279 807 207 DFFSX1 $T=1306800 957600 0 0 $X=1302500 $Y=953600
X277 30 55 808 217 809 541 279 810 207 DFFSX1 $T=1333200 1360800 1 0 $X=1328900 $Y=1305000
X278 13 55 811 217 812 411 279 813 207 DFFSX1 $T=1405800 1159200 1 0 $X=1401500 $Y=1103400
X279 352 435 814 207 815 349 279 431 207 DFFSX1 $T=1841400 1260000 0 0 $X=1837100 $Y=1256000
X280 352 429 816 207 817 350 279 422 207 DFFSX1 $T=1854600 1260000 1 0 $X=1850300 $Y=1204200
X281 72 111 818 207 820 819 279 452 207 DFFSX1 $T=2244000 1159200 0 180 $X=2114300 $Y=1103400
X282 72 452 821 207 822 305 279 823 207 DFFSX1 $T=2151600 1058400 1 0 $X=2147300 $Y=1002600
X283 72 457 824 207 825 117 279 116 207 DFFSX1 $T=2204400 957600 0 0 $X=2200100 $Y=953600
X284 72 558 826 251 827 237 279 118 207 DFFSX1 $T=2547600 1058400 1 0 $X=2543300 $Y=1002600
X285 146 484 828 251 829 132 279 153 207 DFFSX1 $T=2679600 1159200 1 0 $X=2675300 $Y=1103400
X286 146 371 830 251 831 137 279 115 207 DFFSX1 $T=2692800 1058400 0 0 $X=2688500 $Y=1054400
X287 72 490 832 251 833 489 279 834 207 DFFSX1 $T=2791800 957600 0 0 $X=2787500 $Y=953600
X288 72 562 835 155 836 565 279 837 207 DFFSX1 $T=2798400 1260000 0 0 $X=2794100 $Y=1256000
X289 146 563 838 251 839 567 279 840 207 DFFSX1 $T=2831400 1058400 0 0 $X=2827100 $Y=1054400
X290 146 564 841 155 842 493 279 843 207 DFFSX1 $T=2890800 1260000 1 0 $X=2886500 $Y=1204200
X291 146 569 844 155 845 570 279 846 207 DFFSX1 $T=2963400 1360800 0 0 $X=2959100 $Y=1356800
X292 146 495 847 155 848 168 279 849 207 DFFSX1 $T=3042600 1260000 1 0 $X=3038300 $Y=1204200
X293 261 262 850 155 851 492 279 852 207 DFFSX1 $T=3088800 957600 0 0 $X=3084500 $Y=953600
X294 146 260 853 155 854 497 279 855 207 DFFSX1 $T=3128400 1360800 1 0 $X=3124100 $Y=1305000
X295 146 574 856 155 857 597 279 858 207 DFFSX1 $T=3135000 1360800 0 0 $X=3130700 $Y=1356800
X296 146 577 859 155 860 578 279 861 207 DFFSX1 $T=3181200 1159200 0 0 $X=3176900 $Y=1155200
X297 261 263 862 264 863 500 279 864 207 DFFSX1 $T=3220800 957600 0 0 $X=3216500 $Y=953600
X298 146 498 865 264 866 581 279 867 207 DFFSX1 $T=3260400 1260000 0 0 $X=3256100 $Y=1256000
X299 146 580 868 155 869 583 279 870 207 DFFSX1 $T=3319800 1159200 0 0 $X=3315500 $Y=1155200
X300 261 321 871 264 872 502 279 873 207 DFFSX1 $T=3379200 1058400 1 0 $X=3374900 $Y=1002600
X301 146 505 874 264 875 504 279 876 207 DFFSX1 $T=3392400 1461600 1 0 $X=3388100 $Y=1405800
X302 261 322 877 264 878 503 279 879 207 DFFSX1 $T=3451800 1058400 0 0 $X=3447500 $Y=1054400
X303 182 266 880 264 881 507 279 882 207 DFFSX1 $T=3471600 1159200 1 0 $X=3467300 $Y=1103400
X304 187 267 883 207 884 327 279 885 207 DFFSX1 $T=3577200 957600 0 0 $X=3572900 $Y=953600
X305 261 268 886 264 887 512 279 888 207 DFFSX1 $T=3577200 1058400 1 0 $X=3572900 $Y=1002600
X306 182 511 889 264 890 506 279 891 207 DFFSX1 $T=3577200 1360800 0 0 $X=3572900 $Y=1356800
X307 182 373 892 264 893 510 279 894 207 DFFSX1 $T=3583800 1260000 0 0 $X=3579500 $Y=1256000
X308 182 269 895 264 896 513 279 897 207 DFFSX1 $T=3682800 1058400 0 0 $X=3678500 $Y=1054400
X309 182 524 898 264 899 508 279 900 207 DFFSX1 $T=3689400 1159200 1 0 $X=3685100 $Y=1103400
X310 182 516 901 264 902 515 279 903 207 DFFSX1 $T=3702600 1260000 1 0 $X=3698300 $Y=1204200
X311 182 517 904 264 905 584 279 906 207 DFFSX1 $T=3715800 1260000 0 0 $X=3711500 $Y=1256000
X312 182 518 907 264 908 509 279 909 207 DFFSX1 $T=3729000 1360800 1 0 $X=3724700 $Y=1305000
X313 182 519 519 264 910 333 279 911 207 DFFSX1 $T=3735600 1461600 1 0 $X=3731300 $Y=1405800
X314 187 332 912 207 913 334 279 914 207 DFFSX1 $T=3788400 957600 0 0 $X=3784100 $Y=953600
X315 182 520 915 264 916 271 279 917 207 DFFSX1 $T=3854400 1260000 0 0 $X=3850100 $Y=1256000
X316 182 523 918 264 919 270 279 920 207 DFFSX1 $T=3986400 1360800 0 180 $X=3856700 $Y=1305000
X317 182 522 921 264 922 521 279 923 207 DFFSX1 $T=3894000 1360800 0 0 $X=3889700 $Y=1356800
X318 182 272 924 264 925 335 279 926 207 DFFSX1 $T=3927000 1461600 1 0 $X=3922700 $Y=1405800
X319 410 279 220 207 CLKINVX8 $T=1465200 1260000 0 180 $X=1421300 $Y=1204200
X320 542 279 20 207 CLKINVX8 $T=1570800 1159200 0 0 $X=1566500 $Y=1155200
X321 543 279 44 207 CLKINVX8 $T=1597200 1260000 0 0 $X=1592900 $Y=1256000
X322 81 279 207 207 CLKINVX8 $T=1683000 1360800 0 0 $X=1678700 $Y=1356800
X323 142 279 171 207 CLKINVX8 $T=2752200 1260000 1 0 $X=2747900 $Y=1204200
X324 296 410 279 417 207 295 419 OAI211XL $T=1735800 957600 1 180 $X=1691900 $Y=953600
X325 348 350 279 425 207 86 429 OAI211XL $T=1768800 1159200 1 0 $X=1764500 $Y=1103400
X326 426 427 279 348 207 86 549 OAI211XL $T=1782000 1058400 0 0 $X=1777700 $Y=1054400
X327 366 8 279 480 207 360 371 OAI211XL $T=2580600 1260000 1 0 $X=2576300 $Y=1204200
X328 81 207 279 207 INVX4 $T=1168200 1360800 0 180 $X=1137500 $Y=1305000
X329 544 21 279 207 INVX4 $T=1643400 1058400 0 0 $X=1639100 $Y=1054400
X330 421 80 279 207 INVX4 $T=1749000 1260000 0 0 $X=1744700 $Y=1256000
X331 466 86 279 207 INVX4 $T=2362800 1159200 1 0 $X=2358500 $Y=1103400
X332 472 9 279 207 INVX4 $T=2692800 1159200 0 0 $X=2688500 $Y=1155200
X333 587 279 401 207 60 NAND2X1 $T=1346400 1159200 1 0 $X=1342100 $Y=1103400
X334 446 279 442 207 355 NAND2X1 $T=2059200 1058400 0 180 $X=2035100 $Y=1002600
X335 483 279 362 207 362 NAND2X1 $T=2633400 1360800 1 180 $X=2609300 $Y=1356800
X336 482 279 362 207 368 NAND2X1 $T=2745600 1260000 1 180 $X=2721500 $Y=1256000
X337 134 279 8 207 8 470 NAND3X1 $T=2488200 1360800 1 0 $X=2483900 $Y=1305000
X338 590 207 424 279 419 428 NOR3XL $T=1755600 1058400 1 0 $X=1751300 $Y=1002600
X339 118 207 117 279 306 463 NOR3XL $T=2409000 957600 1 180 $X=2378300 $Y=953600
X340 136 207 247 279 138 366 NOR3XL $T=2613600 1461600 0 180 $X=2582900 $Y=1405800
X341 348 349 350 207 279 410 OR3X1 $T=1722600 1159200 0 180 $X=1678700 $Y=1103400
X342 360 279 207 131 INVX1 $T=2527800 1159200 0 0 $X=2523500 $Y=1155200
X343 353 207 342 546 279 NOR2BXL $T=1808400 1159200 1 180 $X=1777700 $Y=1155200
X344 465 207 237 460 279 NOR2BXL $T=2310000 1058400 1 180 $X=2279300 $Y=1054400
X345 246 250 279 207 252 AND2X4 $T=2620200 1058400 0 0 $X=2615900 $Y=1054400
X346 488 161 279 207 146 AND2X4 $T=3181200 1260000 0 0 $X=3176900 $Y=1256000
X347 1 279 72 207 CLKBUFX8 $T=2329800 1360800 0 180 $X=2279300 $Y=1305000
X348 316 279 154 207 CLKBUFX8 $T=2937000 1058400 0 180 $X=2886500 $Y=1002600
X349 317 279 4 207 CLKBUFX8 $T=2970000 957600 0 0 $X=2965700 $Y=953600
X350 294 207 230 229 279 NOR2BX1 $T=1643400 1461600 1 0 $X=1639100 $Y=1405800
X351 425 207 431 430 279 NOR2BX1 $T=1795200 1260000 1 0 $X=1790900 $Y=1204200
X352 207 470 362 499 279 NOR2X1 $T=2415600 1360800 1 180 $X=2391500 $Y=1356800
X353 207 470 555 462 279 NOR2X1 $T=2415600 1260000 0 0 $X=2411300 $Y=1256000
X354 207 358 362 279 279 NOR2X1 $T=2455200 1461600 0 180 $X=2431100 $Y=1405800
X355 207 361 555 461 279 NOR2X1 $T=2468400 1260000 0 180 $X=2444300 $Y=1204200
X356 207 359 364 372 279 NOR2X1 $T=2488200 1159200 1 180 $X=2464100 $Y=1155200
X357 207 359 361 455 279 NOR2X1 $T=2488200 1260000 1 180 $X=2464100 $Y=1256000
X358 207 555 475 363 279 NOR2X1 $T=2501400 1260000 0 0 $X=2497100 $Y=1256000
X359 207 362 475 476 279 NOR2X1 $T=2501400 1360800 0 0 $X=2497100 $Y=1356800
X360 20 213 207 19 387 32 279 AOI22X2 $T=778800 1159200 1 0 $X=774500 $Y=1103400
X361 565 207 279 159 BUFX2 $T=2910600 1360800 0 180 $X=2879900 $Y=1305000
X362 567 207 279 162 BUFX2 $T=2950200 1159200 0 180 $X=2919500 $Y=1103400
X363 497 207 279 319 BUFX2 $T=3220800 1461600 1 0 $X=3216500 $Y=1405800
X364 578 207 279 170 BUFX2 $T=3286800 1159200 0 180 $X=3256100 $Y=1103400
X365 507 207 279 178 BUFX2 $T=3544200 1159200 1 180 $X=3513500 $Y=1155200
X366 510 207 279 180 BUFX2 $T=3564000 1260000 1 180 $X=3533300 $Y=1256000
X367 512 207 279 11 BUFX2 $T=3583800 1159200 1 180 $X=3553100 $Y=1155200
X368 161 207 279 182 BUFX2 $T=3577200 1360800 1 0 $X=3572900 $Y=1305000
X369 584 207 279 330 BUFX2 $T=3748800 1360800 1 180 $X=3718100 $Y=1356800
X370 72 927 339 928 67 279 207 TLATNXL $T=1590600 1159200 1 0 $X=1586300 $Y=1103400
X371 72 929 416 930 25 279 207 TLATNXL $T=1636800 1159200 0 0 $X=1632500 $Y=1155200
X372 72 931 420 932 210 279 207 TLATNXL $T=1656600 1260000 0 0 $X=1652300 $Y=1256000
X373 72 933 360 934 74 279 207 TLATNXL $T=1669800 1360800 1 0 $X=1665500 $Y=1305000
X374 72 935 360 936 84 279 207 TLATNXL $T=1755600 1360800 0 0 $X=1751300 $Y=1356800
X375 72 937 451 938 51 279 207 TLATNXL $T=2032800 1260000 0 0 $X=2028500 $Y=1256000
X376 72 72 72 72 439 279 207 TLATNXL $T=2145000 1159200 1 180 $X=2068100 $Y=1155200
X377 72 939 357 357 82 279 207 TLATNXL $T=2145000 1360800 0 180 $X=2068100 $Y=1305000
X378 72 940 454 941 449 279 207 TLATNXL $T=2092200 1360800 0 0 $X=2087900 $Y=1356800
X379 72 942 455 943 447 279 207 TLATNXL $T=2112000 1260000 0 0 $X=2107700 $Y=1256000
X380 72 944 453 945 304 279 207 TLATNXL $T=2125200 957600 0 0 $X=2120900 $Y=953600
X381 72 946 303 947 235 279 207 TLATNXL $T=2125200 1461600 1 0 $X=2120900 $Y=1405800
X382 72 948 456 949 110 279 207 TLATNXL $T=2171400 1360800 1 0 $X=2167100 $Y=1305000
X383 72 950 461 951 448 279 207 TLATNXL $T=2263800 1260000 1 180 $X=2186900 $Y=1256000
X384 72 952 499 953 87 279 207 TLATNXL $T=2204400 1360800 0 0 $X=2200100 $Y=1356800
X385 72 954 372 955 107 279 207 TLATNXL $T=2230800 1159200 0 0 $X=2226500 $Y=1155200
X386 72 956 553 957 119 279 207 TLATNXL $T=2263800 1260000 0 0 $X=2259500 $Y=1256000
X387 72 958 462 959 444 279 207 TLATNXL $T=2283600 1360800 0 0 $X=2279300 $Y=1356800
X388 72 960 469 961 123 279 207 TLATNXL $T=2382600 1159200 1 180 $X=2305700 $Y=1155200
X389 72 962 363 963 108 279 207 TLATNXL $T=2329800 1360800 1 0 $X=2325500 $Y=1305000
X390 72 964 486 965 488 279 207 TLATNXL $T=2719200 1159200 0 0 $X=2714900 $Y=1155200
X391 72 966 476 967 145 279 207 TLATNXL $T=2752200 1461600 1 0 $X=2747900 $Y=1405800
X392 161 968 265 969 326 279 207 TLATNXL $T=3590400 1461600 1 0 $X=3586100 $Y=1405800
X393 182 468 468 468 186 279 207 TLATNXL $T=3603600 1159200 1 0 $X=3599300 $Y=1103400
X394 182 970 514 971 185 279 207 TLATNXL $T=3610200 1159200 0 0 $X=3605900 $Y=1155200
X395 146 481 973 972 251 150 207 279 312 DFFSX2 $T=2653200 957600 0 0 $X=2648900 $Y=953600
X396 146 568 975 974 155 258 207 279 976 DFFSX2 $T=2937000 1260000 0 0 $X=2932700 $Y=1256000
X397 146 487 978 977 155 135 207 279 318 DFFSX2 $T=2963400 1058400 1 0 $X=2959100 $Y=1002600
X398 146 494 980 979 155 198 207 279 981 DFFSX2 $T=3029400 1159200 0 0 $X=3025100 $Y=1155200
X399 146 571 571 982 155 259 207 279 983 DFFSX2 $T=3108600 1058400 1 0 $X=3104300 $Y=1002600
X400 146 575 985 984 155 176 207 279 986 DFFSX2 $T=3154800 1058400 0 0 $X=3150500 $Y=1054400
X401 146 582 988 987 264 199 207 279 989 DFFSX2 $T=3392400 1260000 1 0 $X=3388100 $Y=1204200
X402 146 501 991 990 264 197 207 279 992 DFFSX2 $T=3392400 1360800 0 0 $X=3388100 $Y=1356800
X403 257 253 279 363 207 255 252 254 OAI221XL $T=2831400 1058400 0 180 $X=2780900 $Y=1002600
X404 257 592 279 455 207 162 252 563 OAI221XL $T=2824800 1159200 0 0 $X=2820500 $Y=1155200
X405 257 485 279 420 207 189 252 564 OAI221XL $T=2824800 1260000 1 0 $X=2820500 $Y=1204200
X406 257 566 279 454 207 258 252 568 OAI221XL $T=2923800 1360800 1 0 $X=2919500 $Y=1305000
X407 257 593 279 151 207 200 252 569 OAI221XL $T=2923800 1461600 1 0 $X=2919500 $Y=1405800
X408 257 594 279 461 207 198 252 494 OAI221XL $T=2963400 1159200 0 0 $X=2959100 $Y=1155200
X409 257 595 279 456 207 259 252 571 OAI221XL $T=3016200 1159200 1 0 $X=3011900 $Y=1103400
X410 257 596 279 476 207 168 252 495 OAI221XL $T=3062400 1360800 1 0 $X=3058100 $Y=1305000
X411 257 572 279 474 207 176 252 575 OAI221XL $T=3088800 1159200 1 0 $X=3084500 $Y=1103400
X412 257 573 279 462 207 195 252 574 OAI221XL $T=3102000 1461600 1 0 $X=3097700 $Y=1405800
X413 257 576 279 339 207 170 252 577 OAI221XL $T=3168000 1260000 1 0 $X=3163700 $Y=1204200
X414 257 496 279 357 207 174 252 498 OAI221XL $T=3220800 1260000 1 0 $X=3216500 $Y=1204200
X415 257 599 279 499 207 197 252 501 OAI221XL $T=3286800 1360800 1 0 $X=3282500 $Y=1305000
X416 257 598 279 372 207 199 252 582 OAI221XL $T=3293400 1260000 1 0 $X=3289100 $Y=1204200
X417 257 579 279 416 207 194 252 580 OAI221XL $T=3300000 1159200 1 0 $X=3295700 $Y=1103400
X418 257 340 279 241 207 196 252 505 OAI221XL $T=3306600 1360800 0 0 $X=3302300 $Y=1356800
X419 8 279 243 362 129 207 NOR3X2 $T=2461800 1461600 1 0 $X=2457500 $Y=1405800
X420 309 279 8 245 454 207 NOR3X2 $T=2560800 1461600 0 180 $X=2510300 $Y=1405800
X421 409 279 42 207 INVX2 $T=1247400 1159200 1 180 $X=1223300 $Y=1155200
X422 412 279 73 207 INVX2 $T=1511400 1360800 1 0 $X=1507100 $Y=1305000
X423 227 279 57 207 INVX2 $T=1570800 1360800 0 0 $X=1566500 $Y=1356800
X424 343 279 38 207 INVX2 $T=1603800 1058400 1 0 $X=1599500 $Y=1002600
X425 414 279 65 207 INVX2 $T=1636800 1260000 0 0 $X=1632500 $Y=1256000
X426 421 279 231 207 INVX2 $T=1755600 1360800 1 0 $X=1751300 $Y=1305000
X427 437 279 95 207 INVX2 $T=1914000 1360800 0 0 $X=1909700 $Y=1356800
X428 550 279 97 207 INVX2 $T=1947000 1360800 0 0 $X=1942700 $Y=1356800
X429 100 279 96 207 INVX2 $T=2026200 1461600 0 180 $X=2002100 $Y=1405800
X430 546 65 279 207 BUFX4 $T=1788600 1260000 0 180 $X=1751300 $Y=1204200
X431 315 7 279 207 BUFX4 $T=2910600 1159200 1 180 $X=2873300 $Y=1155200
X432 492 160 279 207 BUFX4 $T=2970000 1058400 0 0 $X=2965700 $Y=1054400
X433 470 359 279 207 357 NOR2X2 $T=2442000 1360800 0 180 $X=2404700 $Y=1305000
X434 368 358 279 207 416 NOR2X2 $T=2448600 1159200 1 180 $X=2411300 $Y=1155200
X435 118 127 279 207 360 NOR2X2 $T=2468400 1058400 0 0 $X=2464100 $Y=1054400
X436 362 364 279 207 456 NOR2X2 $T=2501400 1260000 1 0 $X=2497100 $Y=1204200
X437 355 207 279 345 68 NOR2X4 $T=1511400 1260000 1 0 $X=1507100 $Y=1204200
X438 470 207 279 368 339 NOR2X4 $T=2428800 1260000 0 180 $X=2378300 $Y=1204200
X439 120 356 207 279 465 AND2X1 $T=2395800 1058400 1 180 $X=2365100 $Y=1054400
X440 354 279 102 207 CLKINVX2 $T=2085600 1260000 1 0 $X=2081300 $Y=1204200
X441 342 344 279 207 70 OR2X1 $T=1603800 1360800 0 0 $X=1599500 $Y=1356800
X442 355 431 279 207 103 OR2X1 $T=1966800 1260000 0 0 $X=1962500 $Y=1256000
.ENDS
***************************************
.SUBCKT OAI2BB2XL A0N A1N B1 B0 VSS VDD Y
** N=11 EP=7 IP=0 FDC=10
M0 10 A0N VSS VSS n18 L=1.8e-07 W=3.6e-07 $X=4600 $Y=12600 $D=6
M1 9 A1N 10 VSS n18 L=1.8e-07 W=3.6e-07 $X=10200 $Y=12600 $D=6
M2 VSS B1 8 VSS n18 L=1.8e-07 W=5.6e-07 $X=23200 $Y=7500 $D=6
M3 8 B0 VSS VSS n18 L=1.8e-07 W=5.6e-07 $X=30400 $Y=7500 $D=6
M4 Y 9 8 VSS n18 L=1.8e-07 W=5.6e-07 $X=37600 $Y=7500 $D=6
M5 9 A0N VDD VDD p18 L=1.8e-07 W=4.2e-07 $X=6400 $Y=30000 $D=10
M6 VDD A1N 9 VDD p18 L=1.8e-07 W=4.2e-07 $X=14400 $Y=30000 $D=10
M7 11 B1 VDD VDD p18 L=1.8e-07 W=8.4e-07 $X=20400 $Y=28800 $D=10
M8 Y B0 11 VDD p18 L=1.8e-07 W=8.4e-07 $X=26000 $Y=28800 $D=10
M9 VDD 9 Y VDD p18 L=1.8e-07 W=6.4e-07 $X=33200 $Y=30350 $D=10
.ENDS
***************************************
.SUBCKT MXI2XL S0 B 3 Y A VSS VDD
** N=9 EP=7 IP=0 FDC=10
M0 VSS S0 3 VSS n18 L=1.8e-07 W=3e-07 $X=7600 $Y=12600 $D=6
M1 8 B VSS VSS n18 L=1.8e-07 W=3e-07 $X=15800 $Y=12600 $D=6
M2 Y S0 8 VSS n18 L=1.8e-07 W=5.6e-07 $X=23600 $Y=10000 $D=6
M3 9 3 Y VSS n18 L=1.8e-07 W=5.6e-07 $X=31200 $Y=10000 $D=6
M4 VSS A 9 VSS n18 L=1.8e-07 W=4.2e-07 $X=39400 $Y=11400 $D=6
M5 VDD S0 3 VDD p18 L=1.8e-07 W=4.2e-07 $X=6600 $Y=32300 $D=10
M6 8 B VDD VDD p18 L=1.8e-07 W=4.2e-07 $X=15600 $Y=32300 $D=10
M7 Y 3 8 VDD p18 L=1.8e-07 W=8.4e-07 $X=23400 $Y=28100 $D=10
M8 9 S0 Y VDD p18 L=1.8e-07 W=8.4e-07 $X=31400 $Y=28100 $D=10
M9 VDD A 9 VDD p18 L=1.8e-07 W=6.4e-07 $X=39400 $Y=30100 $D=10
.ENDS
***************************************
.SUBCKT AOI2BB1XL A0N A1N VSS B0 5 VDD Y
** N=9 EP=7 IP=0 FDC=8
M0 5 A0N VSS VSS n18 L=1.8e-07 W=3e-07 $X=4100 $Y=8600 $D=6
M1 VSS A1N 5 VSS n18 L=1.8e-07 W=3e-07 $X=9300 $Y=15400 $D=6
M2 Y B0 VSS VSS n18 L=1.8e-07 W=4.6e-07 $X=15300 $Y=13800 $D=6
M3 VSS 5 Y VSS n18 L=1.8e-07 W=4.6e-07 $X=22600 $Y=13800 $D=6
M4 8 A0N 5 VDD p18 L=1.8e-07 W=5.6e-07 $X=6200 $Y=34600 $D=10
M5 VDD A1N 8 VDD p18 L=1.8e-07 W=5.6e-07 $X=11800 $Y=34600 $D=10
M6 9 B0 VDD VDD p18 L=1.8e-07 W=8.4e-07 $X=17800 $Y=33050 $D=10
M7 Y 5 9 VDD p18 L=1.8e-07 W=8.4e-07 $X=23400 $Y=33050 $D=10
.ENDS
***************************************
.SUBCKT AOI2BB2X1 A1N A0N B1 B0 VDD VSS Y
** N=11 EP=7 IP=0 FDC=10
M0 9 A1N VSS VSS n18 L=1.8e-07 W=3e-07 $X=4600 $Y=13950 $D=6
M1 VSS A0N 9 VSS n18 L=1.8e-07 W=3e-07 $X=12600 $Y=13950 $D=6
M2 10 B1 VSS VSS n18 L=1.8e-07 W=8e-07 $X=18600 $Y=8950 $D=6
M3 Y B0 10 VSS n18 L=1.8e-07 W=8e-07 $X=24200 $Y=8950 $D=6
M4 VSS 9 Y VSS n18 L=1.8e-07 W=6e-07 $X=31400 $Y=8950 $D=6
M5 11 A1N VDD VDD p18 L=1.8e-07 W=5.6e-07 $X=4600 $Y=30400 $D=10
M6 9 A0N 11 VDD p18 L=1.8e-07 W=5.6e-07 $X=10200 $Y=30400 $D=10
M7 VDD B1 8 VDD p18 L=1.83034e-07 W=1.19814e-06 $X=22800 $Y=38450 $D=10
M8 8 B0 VDD VDD p18 L=1.83034e-07 W=1.19814e-06 $X=29200 $Y=33050 $D=10
M9 Y 9 8 VDD p18 L=1.83034e-07 W=1.19814e-06 $X=35600 $Y=38450 $D=10
.ENDS
***************************************
.SUBCKT AOI2BB2XL A1N A0N B1 VDD B0 6 Y VSS
** N=11 EP=8 IP=0 FDC=10
M0 6 A1N VSS VSS n18 L=1.8e-07 W=3e-07 $X=6600 $Y=10150 $D=6
M1 VSS A0N 6 VSS n18 L=1.8e-07 W=3e-07 $X=14600 $Y=10150 $D=6
M2 10 B1 VSS VSS n18 L=1.8e-07 W=5.6e-07 $X=20600 $Y=10400 $D=6
M3 Y B0 10 VSS n18 L=1.8e-07 W=5.6e-07 $X=27200 $Y=10400 $D=6
M4 VSS 6 Y VSS n18 L=1.8e-07 W=4.2e-07 $X=36400 $Y=11800 $D=6
M5 11 A1N VDD VDD p18 L=1.8e-07 W=5.6e-07 $X=4600 $Y=34600 $D=10
M6 6 A0N 11 VDD p18 L=1.8e-07 W=5.6e-07 $X=10200 $Y=34600 $D=10
M7 VDD B1 9 VDD p18 L=1.8e-07 W=8.4e-07 $X=23200 $Y=31750 $D=10
M8 9 B0 VDD VDD p18 L=1.8e-07 W=8.4e-07 $X=29200 $Y=31750 $D=10
M9 Y 6 9 VDD p18 L=1.8e-07 W=8.4e-07 $X=36400 $Y=31750 $D=10
.ENDS
***************************************
.SUBCKT OAI31XL A2 A1 VSS A0 B0 Y VDD
** N=10 EP=7 IP=0 FDC=8
M0 8 A2 VSS VSS n18 L=1.8e-07 W=5.6e-07 $X=4600 $Y=10200 $D=6
M1 VSS A1 8 VSS n18 L=1.8e-07 W=5.6e-07 $X=11800 $Y=10200 $D=6
M2 8 A0 VSS VSS n18 L=1.8e-07 W=5.6e-07 $X=17800 $Y=10200 $D=6
M3 Y B0 8 VSS n18 L=1.8e-07 W=5.6e-07 $X=25000 $Y=10200 $D=6
M4 9 A2 VDD VDD p18 L=1.8e-07 W=9.8e-07 $X=4600 $Y=30400 $D=10
M5 10 A1 9 VDD p18 L=1.8e-07 W=9.8e-07 $X=10200 $Y=30400 $D=10
M6 Y A0 10 VDD p18 L=1.8e-07 W=9.8e-07 $X=15800 $Y=30400 $D=10
M7 VDD B0 Y VDD p18 L=1.8e-07 W=6.4e-07 $X=23000 $Y=30400 $D=10
.ENDS
***************************************
.SUBCKT AND3X1 A B C VSS VDD Y
** N=9 EP=6 IP=0 FDC=8
M0 8 A 7 VSS n18 L=1.8e-07 W=3.8e-07 $X=6600 $Y=10400 $D=6
M1 9 B 8 VSS n18 L=1.8e-07 W=3.8e-07 $X=12200 $Y=10400 $D=6
M2 VSS C 9 VSS n18 L=1.8e-07 W=3.8e-07 $X=17800 $Y=10400 $D=6
M3 Y 7 VSS VSS n18 L=1.8e-07 W=5.6e-07 $X=24100 $Y=10400 $D=6
M4 VDD A 7 VDD p18 L=1.8e-07 W=3.6e-07 $X=6600 $Y=39800 $D=10
M5 VDD B 7 VDD p18 L=1.8e-07 W=3.6e-07 $X=11700 $Y=32650 $D=10
M6 VDD C 7 VDD p18 L=1.8e-07 W=3.6e-07 $X=20300 $Y=27250 $D=10
M7 Y 7 VDD VDD p18 L=1.8e-07 W=9e-07 $X=25000 $Y=35300 $D=10
.ENDS
***************************************
.SUBCKT OAI22XL B1 B0 VSS A0 A1 Y VDD
** N=10 EP=7 IP=0 FDC=8
M0 VSS B1 8 VSS n18 L=1.8e-07 W=5.6e-07 $X=6200 $Y=10150 $D=6
M1 8 B0 VSS VSS n18 L=1.8e-07 W=5.6e-07 $X=14200 $Y=10150 $D=6
M2 Y A0 8 VSS n18 L=1.8e-07 W=5.6e-07 $X=21400 $Y=10150 $D=6
M3 8 A1 Y VSS n18 L=1.8e-07 W=5.6e-07 $X=28600 $Y=10150 $D=6
M4 9 B1 VDD VDD p18 L=1.8e-07 W=8.4e-07 $X=6600 $Y=31250 $D=10
M5 Y B0 9 VDD p18 L=1.8e-07 W=8.4e-07 $X=12200 $Y=31250 $D=10
M6 10 A0 Y VDD p18 L=1.8e-07 W=8.4e-07 $X=19400 $Y=31250 $D=10
M7 VDD A1 10 VDD p18 L=1.8e-07 W=8.4e-07 $X=25000 $Y=31250 $D=10
.ENDS
***************************************
.SUBCKT AOI31XL A2 A1 A0 VDD B0 VSS Y
** N=10 EP=7 IP=0 FDC=8
M0 9 A2 VSS VSS n18 L=1.8e-07 W=6.6e-07 $X=6200 $Y=8950 $D=6
M1 10 A1 9 VSS n18 L=1.8e-07 W=6.6e-07 $X=11800 $Y=8950 $D=6
M2 Y A0 10 VSS n18 L=1.8e-07 W=6.6e-07 $X=17400 $Y=8950 $D=6
M3 VSS B0 Y VSS n18 L=1.8e-07 W=4.2e-07 $X=25000 $Y=11350 $D=6
M4 8 A2 VDD VDD p18 L=1.8e-07 W=8.4e-07 $X=4600 $Y=29400 $D=10
M5 VDD A1 8 VDD p18 L=1.8e-07 W=8.4e-07 $X=11800 $Y=29400 $D=10
M6 8 A0 VDD VDD p18 L=1.8e-07 W=8.4e-07 $X=17800 $Y=29400 $D=10
M7 Y B0 8 VDD p18 L=1.8e-07 W=8.4e-07 $X=25000 $Y=29400 $D=10
.ENDS
***************************************
.SUBCKT AOI32XL A2 A1 A0 VDD B0 B1 VSS Y
** N=12 EP=8 IP=0 FDC=10
M0 10 A2 VSS VSS n18 L=1.8e-07 W=6.6e-07 $X=6200 $Y=8950 $D=6
M1 11 A1 10 VSS n18 L=1.8e-07 W=6.6e-07 $X=11800 $Y=8950 $D=6
M2 Y A0 11 VSS n18 L=1.8e-07 W=6.6e-07 $X=17400 $Y=8950 $D=6
M3 12 B0 Y VSS n18 L=1.8e-07 W=5.6e-07 $X=24600 $Y=8950 $D=6
M4 VSS B1 12 VSS n18 L=1.8e-07 W=5.6e-07 $X=30200 $Y=8950 $D=6
M5 9 A2 VDD VDD p18 L=1.8e-07 W=8.4e-07 $X=6200 $Y=33050 $D=10
M6 VDD A1 9 VDD p18 L=1.8e-07 W=8.4e-07 $X=13400 $Y=33050 $D=10
M7 9 A0 VDD VDD p18 L=1.8e-07 W=8.4e-07 $X=20600 $Y=33050 $D=10
M8 Y B0 9 VDD p18 L=1.8e-07 W=8.4e-07 $X=27800 $Y=33050 $D=10
M9 9 B1 Y VDD p18 L=1.8e-07 W=8.4e-07 $X=35000 $Y=33050 $D=10
.ENDS
***************************************
.SUBCKT ICV_8 2 3 4 5 6 7 8 9 10 11 12 14 15 16 17 18 19 20 21 22
+ 23 24 25 26 27 28 29 30 31 32 33 36 37 38 39 40 41 42 43 44
+ 45 46 47 48 49 50 51 52 53 54 55 56 57 58 59 61 62 63 64 65
+ 66 67 68 69 70 71 72 73 74 75 76 77 78 79 80 81 82 83 84 85
+ 86 87 88 89 90 91 92 93 94 95 96 97 98 99 100 101 102 103 104 105
+ 106 107 108 112 113 114 115 116 118 119 120 121 122 123 125 126 127 129 130 131
+ 132 133 134 135 136 137 138 139 140 141 142 143 144 145 146 147 148 149 150 151
+ 152 153 154 155 156 157 158 159 160 161 162 163 164 165 166 167 168 169 170 171
+ 172 173 174 175 176 177 178 179 180 181 182 183 184 185 186 187 188 190 191 192
+ 193 195 196 197 198 199 200 201 202 203 204 205 206 207 208 210 211 212 213 214
+ 215 217 218 219 220 221 222 223 224 225 226 227 228 229 230 231 232 233 234 235
+ 236 237 238 239 240 241 242 243 244 245 246 247 249
*.CALIBRE ICV_CELL 2
** N=872 EP=233 IP=2507 FDC=4835
M0 864 330 195 195 n18 L=1.8e-07 W=1.04e-06 $X=1828350 $Y=739900 $D=6
M1 865 325 864 195 n18 L=1.8e-07 W=1.04e-06 $X=1833950 $Y=739900 $D=6
M2 866 275 865 195 n18 L=1.8e-07 W=1.04e-06 $X=1839550 $Y=739900 $D=6
M3 319 508 866 195 n18 L=1.8e-07 W=1.04e-06 $X=1845150 $Y=739900 $D=6
M4 195 332 508 195 n18 L=1.8e-07 W=3e-07 $X=1859750 $Y=740350 $D=6
M5 867 57 195 195 n18 L=1.8e-07 W=5e-07 $X=2243600 $Y=660900 $D=6
M6 518 57 867 195 n18 L=1.8e-07 W=5e-07 $X=2249200 $Y=660900 $D=6
M7 195 61 518 195 n18 L=1.8e-07 W=3.8e-07 $X=2257200 $Y=665950 $D=6
M8 518 350 195 195 n18 L=1.8e-07 W=3.8e-07 $X=2263200 $Y=665950 $D=6
M9 195 518 519 195 n18 L=1.8e-07 W=9.6e-07 $X=2277800 $Y=660900 $D=6
M10 145 519 195 195 n18 L=1.8e-07 W=1.2e-06 $X=2285000 $Y=660900 $D=6
M11 195 519 145 195 n18 L=1.8e-07 W=1.2e-06 $X=2292200 $Y=660900 $D=6
M12 195 521 339 195 n18 L=1.8e-07 W=4.2e-07 $X=2303450 $Y=942200 $D=6
M13 520 147 195 195 n18 L=1.8e-07 W=3e-07 $X=2310750 $Y=942200 $D=6
M14 521 523 520 195 n18 L=1.8e-07 W=5.6e-07 $X=2318350 $Y=942200 $D=6
M15 522 143 521 195 n18 L=1.8e-07 W=5.6e-07 $X=2325550 $Y=942200 $D=6
M16 195 73 522 195 n18 L=1.8e-07 W=3e-07 $X=2333150 $Y=942200 $D=6
M17 523 143 195 195 n18 L=1.8e-07 W=3e-07 $X=2341150 $Y=942200 $D=6
M18 195 365 524 195 n18 L=1.8e-07 W=4.8e-07 $X=2494500 $Y=868700 $D=6
M19 524 94 195 195 n18 L=1.8e-07 W=4.8e-07 $X=2503600 $Y=868700 $D=6
M20 195 376 524 195 n18 L=1.8e-07 W=4.8e-07 $X=2511300 $Y=868700 $D=6
M21 98 524 195 195 n18 L=1.8e-07 W=1.2e-06 $X=2519400 $Y=862500 $D=6
M22 195 525 501 195 n18 L=1.8e-07 W=4.2e-07 $X=3247150 $Y=770200 $D=6
M23 525 288 195 195 n18 L=1.8e-07 W=3e-07 $X=3253200 $Y=771400 $D=6
M24 195 289 525 195 n18 L=1.8e-07 W=3e-07 $X=3259200 $Y=771400 $D=6
M25 525 108 195 195 n18 L=1.8e-07 W=3e-07 $X=3265200 $Y=771400 $D=6
M26 319 330 53 53 p18 L=1.84272e-07 W=9.57279e-07 $X=1828200 $Y=720350 $D=10
M27 53 325 319 53 p18 L=1.84272e-07 W=9.57279e-07 $X=1834700 $Y=716250 $D=10
M28 319 275 53 53 p18 L=1.84272e-07 W=9.57279e-07 $X=1841800 $Y=720350 $D=10
M29 53 508 319 53 p18 L=1.84272e-07 W=9.57279e-07 $X=1848300 $Y=716250 $D=10
M30 508 332 53 53 p18 L=1.8e-07 W=4.4e-07 $X=1855750 $Y=721050 $D=10
M31 53 57 517 53 p18 L=1.8e-07 W=8.8e-07 $X=2243600 $Y=684300 $D=10
M32 517 57 53 53 p18 L=1.8e-07 W=8.8e-07 $X=2249700 $Y=684300 $D=10
M33 868 61 517 53 p18 L=1.8e-07 W=8.8e-07 $X=2256900 $Y=684300 $D=10
M34 518 350 868 53 p18 L=1.8e-07 W=8.8e-07 $X=2262500 $Y=684300 $D=10
M35 53 518 519 53 p18 L=1.8e-07 W=1.44e-06 $X=2276750 $Y=682200 $D=10
M36 145 519 53 53 p18 L=1.82016e-07 W=1.80314e-06 $X=2283150 $Y=682200 $D=10
M37 53 519 145 53 p18 L=1.82016e-07 W=1.80314e-06 $X=2289550 $Y=689900 $D=10
M38 53 521 339 53 p18 L=1.8e-07 W=6.4e-07 $X=2305400 $Y=920600 $D=10
M39 520 147 53 53 p18 L=1.8e-07 W=4.2e-07 $X=2311450 $Y=922800 $D=10
M40 521 143 520 53 p18 L=1.8e-07 W=8.4e-07 $X=2318650 $Y=918600 $D=10
M41 522 523 521 53 p18 L=1.8e-07 W=8.4e-07 $X=2326800 $Y=918600 $D=10
M42 53 73 522 53 p18 L=1.8e-07 W=4.2e-07 $X=2334400 $Y=920700 $D=10
M43 523 143 53 53 p18 L=1.8e-07 W=4.2e-07 $X=2341600 $Y=920700 $D=10
M44 869 365 524 53 p18 L=1.8e-07 W=1.12e-06 $X=2498600 $Y=887000 $D=10
M45 870 94 869 53 p18 L=1.8e-07 W=1.12e-06 $X=2504600 $Y=887000 $D=10
M46 53 376 870 53 p18 L=1.8e-07 W=1.12e-06 $X=2510200 $Y=887000 $D=10
M47 98 524 53 53 p18 L=1.8e-07 W=1.74e-06 $X=2519400 $Y=884100 $D=10
M48 53 525 501 53 p18 L=1.8e-07 W=6.4e-07 $X=3248400 $Y=787650 $D=10
M49 871 288 53 53 p18 L=1.8e-07 W=6.6e-07 $X=3254400 $Y=787650 $D=10
M50 872 289 871 53 p18 L=1.8e-07 W=6.6e-07 $X=3260000 $Y=787650 $D=10
M51 525 108 872 53 p18 L=1.8e-07 W=6.6e-07 $X=3265600 $Y=787650 $D=10
X52 300 195 53 296 316 NAND2XL $T=1663200 756000 0 0 $X=1658900 $Y=752000
X53 256 195 53 320 22 NAND2XL $T=1749000 554400 0 180 $X=1724900 $Y=498600
X54 320 195 53 258 27 NAND2XL $T=1755600 554400 1 0 $X=1751300 $Y=498600
X55 258 195 53 322 30 NAND2XL $T=1801800 554400 0 180 $X=1777700 $Y=498600
X56 256 195 53 322 40 NAND2XL $T=1808400 554400 0 0 $X=1804100 $Y=550400
X57 270 195 53 323 480 NAND2XL $T=1828200 655200 1 180 $X=1804100 $Y=651200
X58 263 195 53 272 260 NAND2XL $T=1867800 554400 1 180 $X=1843700 $Y=550400
X59 325 195 53 336 335 NAND2XL $T=1887600 756000 1 0 $X=1883300 $Y=700200
X60 312 195 53 218 345 NAND2XL $T=2065800 957600 1 0 $X=2061500 $Y=901800
X61 278 195 53 271 139 NAND2XL $T=2131800 856800 1 0 $X=2127500 $Y=801000
X62 356 195 53 62 141 NAND2XL $T=2263800 453600 0 0 $X=2259500 $Y=449600
X63 66 195 53 359 354 NAND2XL $T=2283600 655200 0 180 $X=2259500 $Y=599400
X64 70 195 53 83 52 NAND2XL $T=2356200 554400 0 180 $X=2332100 $Y=498600
X65 74 195 53 282 362 NAND2XL $T=2362800 756000 0 180 $X=2338700 $Y=700200
X66 72 195 53 76 281 NAND2XL $T=2376000 453600 0 180 $X=2351900 $Y=397800
X67 282 195 53 283 75 NAND2XL $T=2376000 453600 0 0 $X=2371700 $Y=449600
X68 226 195 53 375 165 NAND2XL $T=2567400 856800 1 0 $X=2563100 $Y=801000
X69 97 195 53 369 495 NAND2XL $T=2600400 856800 0 0 $X=2596100 $Y=852800
X70 106 195 53 170 386 NAND2XL $T=2910600 453600 0 180 $X=2886500 $Y=397800
X71 231 195 53 170 383 NAND2XL $T=2950200 453600 0 180 $X=2926100 $Y=397800
X72 233 195 53 170 387 NAND2XL $T=2983200 453600 0 180 $X=2959100 $Y=397800
X73 172 195 53 170 389 NAND2XL $T=3022800 453600 0 180 $X=2998700 $Y=397800
X74 173 195 53 170 390 NAND2XL $T=3055800 453600 0 180 $X=3031700 $Y=397800
X75 398 195 53 170 496 NAND2XL $T=3069000 453600 1 180 $X=3044900 $Y=449600
X76 399 195 53 170 497 NAND2XL $T=3088800 554400 0 180 $X=3064700 $Y=498600
X77 400 195 53 170 384 NAND2XL $T=3102000 655200 1 180 $X=3077900 $Y=651200
X78 402 195 53 170 393 NAND2XL $T=3115200 655200 0 180 $X=3091100 $Y=599400
X79 403 195 53 170 394 NAND2XL $T=3121800 655200 0 0 $X=3117500 $Y=651200
X80 408 195 53 170 395 NAND2XL $T=3154800 756000 0 180 $X=3130700 $Y=700200
X81 418 195 53 416 116 NAND2XL $T=3319800 856800 1 180 $X=3295700 $Y=852800
X82 289 195 53 412 422 NAND2XL $T=3333000 856800 1 0 $X=3328700 $Y=801000
X83 291 195 53 290 433 NAND2XL $T=3385800 756000 0 0 $X=3381500 $Y=752000
X84 432 195 53 437 427 NAND2XL $T=3478200 554400 1 180 $X=3454100 $Y=550400
X85 451 195 53 180 449 NAND2XL $T=3709200 957600 0 180 $X=3685100 $Y=901800
X86 245 195 53 182 183 NAND2XL $T=3841200 453600 0 180 $X=3817100 $Y=397800
X87 465 195 53 505 460 NAND2XL $T=3940200 756000 1 180 $X=3916100 $Y=752000
X88 457 195 53 462 461 NAND2XL $T=3927000 756000 1 0 $X=3922700 $Y=700200
X89 188 195 53 185 464 NAND2XL $T=3999600 957600 0 180 $X=3975500 $Y=901800
X90 126 195 53 125 526 NAND2XL $T=4012800 453600 1 0 $X=4008500 $Y=397800
X91 192 195 53 470 471 NAND2XL $T=4171200 453600 0 180 $X=4147100 $Y=397800
X92 53 301 297 296 195 NOR2XL $T=1537800 856800 0 180 $X=1513700 $Y=801000
X93 53 306 303 132 195 NOR2XL $T=1603800 957600 0 180 $X=1579700 $Y=901800
X94 53 254 260 472 195 NOR2XL $T=1696200 655200 0 180 $X=1672100 $Y=599400
X95 53 319 327 253 195 NOR2XL $T=1709400 554400 1 180 $X=1685300 $Y=550400
X96 53 254 251 317 195 NOR2XL $T=1702800 554400 1 0 $X=1698500 $Y=498600
X97 53 319 260 311 195 NOR2XL $T=1722600 655200 0 180 $X=1698500 $Y=599400
X98 53 261 251 310 195 NOR2XL $T=1735800 554400 1 180 $X=1711700 $Y=550400
X99 53 261 260 477 195 NOR2XL $T=1768800 655200 0 180 $X=1744700 $Y=599400
X100 53 261 269 255 195 NOR2XL $T=1801800 554400 1 180 $X=1777700 $Y=550400
X101 53 326 480 258 195 NOR2XL $T=1801800 655200 1 180 $X=1777700 $Y=651200
X102 53 480 325 256 195 NOR2XL $T=1808400 655200 0 180 $X=1784300 $Y=599400
X103 53 260 324 259 195 NOR2XL $T=1815000 453600 1 180 $X=1790900 $Y=449600
X104 53 251 324 135 195 NOR2XL $T=1834800 453600 1 180 $X=1810700 $Y=449600
X105 53 272 267 322 195 NOR2XL $T=1834800 655200 0 180 $X=1810700 $Y=599400
X106 53 261 327 331 195 NOR2XL $T=1821600 554400 1 0 $X=1817300 $Y=498600
X107 53 264 327 211 195 NOR2XL $T=1861200 453600 1 180 $X=1837100 $Y=449600
X108 53 263 272 320 195 NOR2XL $T=1874400 554400 0 180 $X=1850300 $Y=498600
X109 53 264 260 333 195 NOR2XL $T=1867800 453600 0 0 $X=1863500 $Y=449600
X110 53 319 251 268 195 NOR2XL $T=1867800 655200 1 0 $X=1863500 $Y=599400
X111 53 264 251 266 195 NOR2XL $T=1874400 554400 1 0 $X=1870100 $Y=498600
X112 53 264 269 481 195 NOR2XL $T=1874400 554400 0 0 $X=1870100 $Y=550400
X113 53 275 332 323 195 NOR2XL $T=1894200 756000 1 180 $X=1870100 $Y=752000
X114 53 270 269 336 195 NOR2XL $T=1907400 756000 1 0 $X=1903100 $Y=700200
X115 53 275 335 278 195 NOR2XL $T=2065800 756000 0 0 $X=2061500 $Y=752000
X116 53 144 70 63 195 NOR2XL $T=2303400 453600 1 180 $X=2279300 $Y=449600
X117 53 70 83 72 195 NOR2XL $T=2310000 453600 0 0 $X=2305700 $Y=449600
X118 53 71 365 68 195 NOR2XL $T=2395800 856800 0 180 $X=2371700 $Y=801000
X119 53 96 358 283 195 NOR2XL $T=2382600 655200 1 0 $X=2378300 $Y=599400
X120 53 44 366 80 195 NOR2XL $T=2395800 453600 0 0 $X=2391500 $Y=449600
X121 53 151 361 81 195 NOR2XL $T=2442000 856800 1 180 $X=2417900 $Y=852800
X122 53 86 103 92 195 NOR2XL $T=2468400 756000 1 0 $X=2464100 $Y=700200
X123 53 94 151 375 195 NOR2XL $T=2494800 856800 1 0 $X=2490500 $Y=801000
X124 53 78 224 369 195 NOR2XL $T=2501400 957600 1 0 $X=2497100 $Y=901800
X125 53 376 361 97 195 NOR2XL $T=2567400 856800 1 180 $X=2543300 $Y=852800
X126 53 416 412 290 195 NOR2XL $T=3300000 856800 1 180 $X=3275900 $Y=852800
X127 53 288 411 418 195 NOR2XL $T=3313200 856800 1 0 $X=3308900 $Y=801000
X128 298 53 195 312 INVXL $T=1636800 957600 1 0 $X=1632500 $Y=901800
X129 256 53 195 254 INVXL $T=1742400 655200 0 180 $X=1724900 $Y=599400
X130 321 53 195 478 INVXL $T=1768800 856800 0 180 $X=1751300 $Y=801000
X131 258 53 195 324 INVXL $T=1782000 453600 0 0 $X=1777700 $Y=449600
X132 320 53 195 327 INVXL $T=1821600 554400 0 180 $X=1804100 $Y=498600
X133 322 53 195 269 INVXL $T=1828200 554400 0 0 $X=1823900 $Y=550400
X134 265 53 195 274 INVXL $T=2032800 756000 1 0 $X=2028500 $Y=700200
X135 278 53 195 515 INVXL $T=2131800 856800 0 180 $X=2114300 $Y=801000
X136 46 53 195 347 INVXL $T=2131800 655200 1 0 $X=2127500 $Y=599400
X137 490 53 195 343 INVXL $T=2184600 856800 0 180 $X=2167100 $Y=801000
X138 344 53 195 356 INVXL $T=2230800 453600 0 0 $X=2226500 $Y=449600
X139 357 53 195 321 INVXL $T=2263800 856800 0 180 $X=2246300 $Y=801000
X140 146 53 195 142 INVXL $T=2303400 453600 0 180 $X=2285900 $Y=397800
X141 280 53 195 360 INVXL $T=2303400 756000 1 180 $X=2285900 $Y=752000
X142 281 53 195 282 INVXL $T=2382600 554400 0 180 $X=2365100 $Y=498600
X143 81 53 195 71 INVXL $T=2422200 856800 1 180 $X=2404700 $Y=852800
X144 369 53 195 365 INVXL $T=2455200 856800 0 0 $X=2450900 $Y=852800
X145 83 53 195 494 INVXL $T=2461800 655200 1 0 $X=2457500 $Y=599400
X146 226 53 195 363 INVXL $T=2527800 856800 0 180 $X=2510300 $Y=801000
X147 97 53 195 97 INVXL $T=2626800 856800 0 0 $X=2622500 $Y=852800
X148 431 53 195 424 INVXL $T=3458400 856800 1 180 $X=3440900 $Y=852800
X149 433 53 195 178 INVXL $T=3590400 856800 0 0 $X=3586100 $Y=852800
X150 449 53 195 448 INVXL $T=3616800 856800 1 180 $X=3599300 $Y=852800
X151 461 53 195 451 INVXL $T=3755400 856800 1 180 $X=3737900 $Y=852800
X152 460 53 195 462 INVXL $T=3940200 756000 0 0 $X=3935900 $Y=752000
X153 466 53 195 465 INVXL $T=3966600 856800 0 180 $X=3949100 $Y=801000
X154 464 53 195 506 INVXL $T=3979800 957600 0 180 $X=3962300 $Y=901800
X155 129 53 195 176 INVXL $T=4078800 856800 0 180 $X=4061300 $Y=801000
X156 190 53 195 177 INVXL $T=4085400 856800 1 180 $X=4067900 $Y=852800
X157 249 53 195 247 INVXL $T=4092000 856800 0 180 $X=4074500 $Y=801000
X158 191 53 195 246 INVXL $T=4092000 957600 0 180 $X=4074500 $Y=901800
X159 193 53 195 175 INVXL $T=4098600 856800 1 180 $X=4081100 $Y=852800
X160 472 195 252 308 53 305 OAI21XL $T=1623600 655200 0 180 $X=1592900 $Y=599400
X161 310 195 17 473 53 299 OAI21XL $T=1623600 554400 0 0 $X=1619300 $Y=550400
X162 311 195 86 313 53 302 OAI21XL $T=1623600 655200 0 0 $X=1619300 $Y=651200
X163 255 195 38 507 53 307 OAI21XL $T=1656600 554400 0 180 $X=1625900 $Y=498600
X164 253 195 44 315 53 304 OAI21XL $T=1696200 453600 1 180 $X=1665500 $Y=449600
X165 317 195 25 474 53 133 OAI21XL $T=1702800 453600 0 180 $X=1672100 $Y=397800
X166 477 195 41 318 53 314 OAI21XL $T=1729200 655200 1 180 $X=1698500 $Y=651200
X167 259 195 32 479 53 26 OAI21XL $T=1788600 453600 0 180 $X=1757900 $Y=397800
X168 266 195 36 509 53 213 OAI21XL $T=1907400 453600 1 0 $X=1903100 $Y=397800
X169 331 195 37 482 53 514 OAI21XL $T=1933800 554400 1 0 $X=1929500 $Y=498600
X170 481 195 57 483 53 279 OAI21XL $T=1940400 655200 1 0 $X=1936100 $Y=599400
X171 325 195 336 335 53 513 OAI21XL $T=1940400 756000 0 0 $X=1936100 $Y=752000
X172 333 195 33 510 53 484 OAI21XL $T=1947000 453600 0 0 $X=1942700 $Y=449600
X173 40 195 40 485 53 338 OAI21XL $T=1947000 554400 0 0 $X=1942700 $Y=550400
X174 268 195 273 511 53 340 OAI21XL $T=1966800 655200 0 0 $X=1962500 $Y=651200
X175 40 195 40 486 53 342 OAI21XL $T=2006400 655200 1 0 $X=2002100 $Y=599400
X176 19 195 49 487 53 140 OAI21XL $T=2125200 453600 1 0 $X=2120900 $Y=397800
X177 59 195 52 49 53 277 OAI21XL $T=2224200 453600 1 180 $X=2193500 $Y=449600
X178 59 195 144 49 53 344 OAI21XL $T=2230800 453600 0 180 $X=2200100 $Y=397800
X179 265 195 139 89 53 222 OAI21XL $T=2204400 856800 1 0 $X=2200100 $Y=801000
X180 142 195 62 356 53 353 OAI21XL $T=2244000 554400 1 0 $X=2239700 $Y=498600
X181 62 195 52 358 53 349 OAI21XL $T=2290200 554400 1 180 $X=2259500 $Y=550400
X182 142 195 62 356 53 352 OAI21XL $T=2316600 554400 1 180 $X=2285900 $Y=550400
X183 74 195 282 362 53 341 OAI21XL $T=2329800 756000 0 180 $X=2299100 $Y=700200
X184 94 195 99 227 53 372 OAI21XL $T=2560800 957600 0 180 $X=2530100 $Y=901800
X185 495 195 99 162 53 88 OAI21XL $T=2620200 856800 1 0 $X=2615900 $Y=801000
X186 501 195 115 116 53 413 OAI21XL $T=3227400 756000 1 180 $X=3196700 $Y=752000
X187 422 195 291 116 53 405 OAI21XL $T=3366000 756000 1 180 $X=3335300 $Y=752000
X188 422 195 291 433 53 431 OAI21XL $T=3399000 856800 0 0 $X=3394700 $Y=852800
X189 437 195 432 427 53 414 OAI21XL $T=3451800 554400 1 180 $X=3421100 $Y=550400
X190 448 195 434 503 53 293 OAI21XL $T=3583800 957600 1 0 $X=3579500 $Y=901800
X191 192 195 470 471 53 469 OAI21XL $T=4125000 453600 1 0 $X=4120700 $Y=397800
X192 132 16 53 312 527 195 206 AOI21XL $T=1636800 957600 0 180 $X=1606100 $Y=901800
X193 134 472 53 24 528 195 308 AOI21XL $T=1663200 655200 0 180 $X=1632500 $Y=599400
X194 134 310 53 24 529 195 473 AOI21XL $T=1683000 554400 1 180 $X=1652300 $Y=550400
X195 134 311 53 24 530 195 313 AOI21XL $T=1689600 655200 1 180 $X=1658900 $Y=651200
X196 134 255 53 24 531 195 507 AOI21XL $T=1696200 554400 0 180 $X=1665500 $Y=498600
X197 316 476 53 478 532 195 309 AOI21XL $T=1729200 756000 1 180 $X=1698500 $Y=752000
X198 134 317 53 24 533 195 474 AOI21XL $T=1735800 453600 0 180 $X=1705100 $Y=397800
X199 134 253 53 24 534 195 315 AOI21XL $T=1735800 453600 1 180 $X=1705100 $Y=449600
X200 134 477 53 24 535 195 318 AOI21XL $T=1742400 655200 0 0 $X=1738100 $Y=651200
X201 134 259 53 24 536 195 479 AOI21XL $T=1782000 453600 1 180 $X=1751300 $Y=449600
X202 134 135 53 24 537 195 210 AOI21XL $T=1801800 453600 1 0 $X=1797500 $Y=397800
X203 134 211 53 24 538 195 212 AOI21XL $T=1834800 453600 1 0 $X=1830500 $Y=397800
X204 251 269 53 265 539 195 334 AOI21XL $T=1867800 655200 0 0 $X=1863500 $Y=651200
X205 134 266 53 24 540 195 509 AOI21XL $T=1874400 453600 1 0 $X=1870100 $Y=397800
X206 134 333 53 24 541 195 510 AOI21XL $T=1900800 453600 0 0 $X=1896500 $Y=449600
X207 134 331 53 24 542 195 482 AOI21XL $T=1900800 554400 1 0 $X=1896500 $Y=498600
X208 134 481 53 24 543 195 483 AOI21XL $T=1900800 554400 0 0 $X=1896500 $Y=550400
X209 271 339 53 40 544 195 332 AOI21XL $T=1940400 756000 1 180 $X=1909700 $Y=752000
X210 134 268 53 24 545 195 511 AOI21XL $T=1933800 655200 0 0 $X=1929500 $Y=651200
X211 270 269 53 336 546 195 512 AOI21XL $T=1940400 756000 1 0 $X=1936100 $Y=700200
X212 40 51 53 24 547 195 485 AOI21XL $T=2006400 655200 0 180 $X=1975700 $Y=599400
X213 40 69 53 24 548 195 486 AOI21XL $T=2065800 655200 0 180 $X=2035100 $Y=599400
X214 275 335 53 278 549 195 488 AOI21XL $T=2118600 756000 0 0 $X=2114300 $Y=752000
X215 329 355 53 334 550 195 276 AOI21XL $T=2230800 756000 0 180 $X=2200100 $Y=700200
X216 407 3 53 170 551 195 498 AOI21XL $T=3135000 856800 0 180 $X=3104300 $Y=801000
X217 290 411 53 413 552 195 410 AOI21XL $T=3247200 856800 1 0 $X=3242900 $Y=801000
X218 422 397 53 425 553 195 502 AOI21XL $T=3385800 756000 1 0 $X=3381500 $Y=700200
X219 448 434 53 433 554 195 503 AOI21XL $T=3577200 856800 1 180 $X=3546500 $Y=852800
X220 11 14 556 555 53 557 196 195 558 53 DFFSXL $T=792000 957600 1 0 $X=787700 $Y=901800
X221 11 12 560 559 53 561 197 195 562 53 DFFSXL $T=930600 957600 1 0 $X=926300 $Y=901800
X222 11 198 564 563 53 565 199 195 566 53 DFFSXL $T=1062600 856800 0 0 $X=1058300 $Y=852800
X223 11 31 568 567 131 569 570 195 201 53 DFFSXL $T=1214400 856800 1 0 $X=1210100 $Y=801000
X224 11 200 572 571 202 573 203 195 574 53 DFFSXL $T=1247400 957600 1 0 $X=1243100 $Y=901800
X225 15 302 302 575 131 576 86 195 577 53 DFFSXL $T=1485000 655200 0 0 $X=1480700 $Y=651200
X226 15 304 579 578 131 580 44 195 581 53 DFFSXL $T=1511400 453600 0 0 $X=1507100 $Y=449600
X227 15 205 583 582 131 584 16 195 585 53 DFFSXL $T=1551000 856800 0 0 $X=1546700 $Y=852800
X228 262 328 587 586 53 588 326 195 325 53 DFFSXL $T=1795200 856800 1 0 $X=1790900 $Y=801000
X229 262 276 590 589 53 591 272 195 592 53 DFFSXL $T=1841400 957600 1 0 $X=1837100 $Y=901800
X230 15 484 594 593 53 595 33 195 55 53 DFFSXL $T=1947000 453600 1 0 $X=1942700 $Y=397800
X231 262 343 597 596 53 598 275 195 599 53 DFFSXL $T=2013000 856800 0 0 $X=2008700 $Y=852800
X232 15 340 601 600 53 602 273 195 82 53 DFFSXL $T=2072400 756000 1 0 $X=2068100 $Y=700200
X233 284 153 604 603 158 605 367 195 606 53 DFFSXL $T=2475000 554400 1 0 $X=2470700 $Y=498600
X234 284 154 608 607 158 609 368 195 610 53 DFFSXL $T=2475000 655200 1 0 $X=2470700 $Y=599400
X235 284 155 612 611 158 613 229 195 614 53 DFFSXL $T=2488200 453600 1 0 $X=2483900 $Y=397800
X236 284 225 616 615 158 617 370 195 618 53 DFFSXL $T=2494800 453600 0 0 $X=2490500 $Y=449600
X237 284 159 620 619 158 621 378 195 622 53 DFFSXL $T=2567400 655200 0 0 $X=2563100 $Y=651200
X238 284 161 624 623 158 625 157 195 626 53 DFFSXL $T=2600400 554400 0 0 $X=2596100 $Y=550400
X239 284 163 628 627 158 629 230 195 630 53 DFFSXL $T=2620200 453600 1 0 $X=2615900 $Y=397800
X240 284 164 632 631 167 633 371 195 634 53 DFFSXL $T=2640000 453600 0 0 $X=2635700 $Y=449600
X241 284 383 636 635 158 637 377 195 638 53 DFFSXL $T=2692800 655200 1 0 $X=2688500 $Y=599400
X242 284 384 640 639 158 641 385 195 642 53 DFFSXL $T=2719200 756000 1 0 $X=2714900 $Y=700200
X243 284 104 644 643 167 645 374 195 646 53 DFFSXL $T=2725800 554400 0 0 $X=2721500 $Y=550400
X244 284 386 648 647 167 649 152 195 650 53 DFFSXL $T=2752200 453600 1 0 $X=2747900 $Y=397800
X245 284 387 652 651 167 653 382 195 654 53 DFFSXL $T=2778600 453600 0 0 $X=2774300 $Y=449600
X246 284 389 656 655 167 657 373 195 658 53 DFFSXL $T=2824800 655200 1 0 $X=2820500 $Y=599400
X247 284 168 660 659 167 661 381 195 662 53 DFFSXL $T=2844600 756000 1 0 $X=2840300 $Y=700200
X248 284 496 496 663 167 664 169 195 665 53 DFFSXL $T=2857800 554400 0 0 $X=2853500 $Y=550400
X249 284 390 667 666 167 668 107 195 669 53 DFFSXL $T=2910600 453600 0 0 $X=2906300 $Y=449600
X250 284 393 671 670 167 672 396 195 673 53 DFFSXL $T=2963400 655200 1 0 $X=2959100 $Y=599400
X251 284 395 675 674 167 676 171 195 677 53 DFFSXL $T=2970000 756000 0 0 $X=2965700 $Y=752000
X252 284 394 679 678 167 680 499 195 681 53 DFFSXL $T=2976600 756000 1 0 $X=2972300 $Y=700200
X253 284 497 683 682 167 684 287 195 685 53 DFFSXL $T=2989800 554400 0 0 $X=2985500 $Y=550400
X254 113 401 687 686 167 688 398 195 689 53 DFFSXL $T=3102000 453600 0 0 $X=3097700 $Y=449600
X255 113 235 235 690 167 691 172 195 692 53 DFFSXL $T=3108600 453600 1 0 $X=3104300 $Y=397800
X256 113 404 694 693 167 695 402 195 696 53 DFFSXL $T=3115200 554400 0 0 $X=3110900 $Y=550400
X257 113 406 698 697 167 699 403 195 700 53 DFFSXL $T=3128400 655200 1 0 $X=3124100 $Y=599400
X258 113 409 702 701 167 703 408 195 704 53 DFFSXL $T=3161400 655200 0 0 $X=3157100 $Y=651200
X259 113 414 706 705 167 707 399 195 708 53 DFFSXL $T=3247200 554400 1 0 $X=3242900 $Y=498600
X260 113 421 710 709 167 711 400 195 712 53 DFFSXL $T=3286800 554400 0 0 $X=3282500 $Y=550400
X261 16 195 132 713 53 301 NAND2BXL $T=1590600 856800 0 180 $X=1559900 $Y=801000
X262 441 195 438 714 53 435 NAND2BXL $T=3531000 756000 0 180 $X=3500300 $Y=700200
X263 108 411 53 289 195 288 420 AOI211XL $T=3273600 756000 0 0 $X=3269300 $Y=752000
X264 115 418 53 420 195 419 428 AOI211XL $T=3366000 856800 1 0 $X=3361700 $Y=801000
X265 306 312 195 53 475 OR2XL $T=1755600 957600 0 180 $X=1724900 $Y=901800
X266 319 269 195 53 40 OR2XL $T=1894200 655200 0 0 $X=1889900 $Y=651200
X267 68 280 195 53 65 OR2XL $T=2336400 756000 1 180 $X=2305700 $Y=752000
X268 47 353 493 195 54 53 OAI2BB1XL $T=2230800 554400 1 180 $X=2193500 $Y=550400
X269 330 195 323 53 326 261 NAND3XL $T=1801800 756000 0 180 $X=1771100 $Y=700200
X270 330 195 325 53 323 264 NAND3XL $T=1834800 655200 0 0 $X=1830500 $Y=651200
X271 346 195 489 53 516 348 NAND3XL $T=2171400 554400 1 0 $X=2167100 $Y=498600
X272 76 195 283 53 146 66 NAND3XL $T=2369400 453600 1 180 $X=2338700 $Y=449600
X273 96 195 76 53 358 59 NAND3XL $T=2369400 655200 0 180 $X=2338700 $Y=599400
X274 96 195 358 53 148 364 NAND3XL $T=2369400 554400 0 0 $X=2365100 $Y=550400
X275 361 195 151 53 78 90 NAND3XL $T=2442000 957600 1 0 $X=2437700 $Y=901800
X276 376 195 361 53 369 160 NAND3XL $T=2567400 856800 0 0 $X=2563100 $Y=852800
X277 99 195 97 53 369 228 NAND3XL $T=2626800 957600 0 180 $X=2596100 $Y=901800
X278 459 195 185 53 188 466 NAND3XL $T=3966600 856800 0 0 $X=3962300 $Y=852800
X279 252 53 20 207 21 208 195 AOI22XL $T=1663200 957600 1 0 $X=1658900 $Y=901800
X280 513 53 274 329 341 328 195 AOI22XL $T=1966800 756000 0 0 $X=1962500 $Y=752000
X281 38 53 39 215 273 214 195 AOI22XL $T=1966800 957600 1 0 $X=1962500 $Y=901800
X282 274 53 263 329 67 337 195 AOI22XL $T=2052600 756000 1 180 $X=2015300 $Y=752000
X283 42 53 21 17 344 346 195 AOI22XL $T=2072400 453600 0 0 $X=2068100 $Y=449600
X284 217 53 23 33 137 219 195 AOI22XL $T=2079000 453600 1 0 $X=2074700 $Y=397800
X285 43 53 344 277 51 487 195 AOI22XL $T=2125200 453600 0 0 $X=2120900 $Y=449600
X286 277 53 45 37 141 516 195 AOI22XL $T=2125200 554400 1 0 $X=2120900 $Y=498600
X287 25 53 49 252 349 489 195 AOI22XL $T=2145000 554400 0 0 $X=2140700 $Y=550400
X288 48 53 141 55 137 220 195 AOI22XL $T=2151600 453600 1 0 $X=2147300 $Y=397800
X289 354 53 138 41 352 492 195 AOI22XL $T=2224200 655200 1 180 $X=2186900 $Y=651200
X290 64 53 349 69 354 493 195 AOI22XL $T=2250600 655200 0 180 $X=2213300 $Y=599400
X291 282 53 149 49 362 351 195 AOI22XL $T=2343000 655200 1 180 $X=2305700 $Y=651200
X292 67 53 148 70 76 355 195 AOI22XL $T=2409000 756000 0 180 $X=2371700 $Y=700200
X293 291 53 442 411 446 447 195 AOI22XL $T=3517800 756000 0 0 $X=3513500 $Y=752000
X294 181 53 182 455 463 504 195 AOI22XL $T=3775200 453600 1 0 $X=3770900 $Y=397800
X295 126 53 455 186 181 452 195 AOI22XL $T=3973200 554400 0 180 $X=3935900 $Y=498600
X296 179 53 186 125 126 467 195 AOI22XL $T=3966600 453600 0 0 $X=3962300 $Y=449600
X297 162 195 160 97 380 165 53 NAND4XL $T=2646600 856800 1 0 $X=2642300 $Y=801000
X298 370 9 195 53 CLKBUFX3 $T=2468400 453600 0 180 $X=2437700 $Y=397800
X299 374 10 195 53 CLKBUFX3 $T=2488200 554400 1 180 $X=2457500 $Y=550400
X300 28 167 53 195 CLKINVX4 $T=3049200 856800 1 0 $X=3044900 $Y=801000
X301 364 53 195 62 CLKBUFX2 $T=2422200 554400 0 180 $X=2391500 $Y=498600
X302 371 53 195 85 CLKBUFX2 $T=2455200 453600 1 180 $X=2424500 $Y=449600
X303 367 53 195 130 CLKBUFX2 $T=2455200 554400 0 180 $X=2424500 $Y=498600
X304 368 53 195 58 CLKBUFX2 $T=2455200 655200 0 180 $X=2424500 $Y=599400
X305 385 53 195 93 CLKBUFX2 $T=2739000 756000 1 180 $X=2708300 $Y=752000
X306 392 53 195 118 CLKBUFX2 $T=3260400 756000 1 0 $X=3256100 $Y=700200
X307 391 53 195 241 CLKBUFX2 $T=3346200 655200 0 0 $X=3341900 $Y=651200
X308 136 53 29 715 195 262 AND2X2 $T=1986600 856800 0 0 $X=1982300 $Y=852800
X309 366 53 70 716 195 103 AND2X2 $T=2508000 756000 1 0 $X=2503700 $Y=700200
X310 388 53 114 717 195 286 AND2X2 $T=2923800 856800 0 0 $X=2919500 $Y=852800
X311 415 53 114 718 195 113 AND2X2 $T=3260400 554400 0 0 $X=3256100 $Y=550400
X312 443 53 114 719 195 119 AND2X2 $T=3689400 856800 0 0 $X=3685100 $Y=852800
X313 435 417 426 430 425 53 195 NAND4BXL $T=3498000 655200 0 180 $X=3454100 $Y=599400
X314 463 455 245 187 526 53 195 NAND4BXL $T=3953400 453600 1 0 $X=3949100 $Y=397800
X315 28 53 131 195 CLKINVX3 $T=1795200 957600 0 180 $X=1771100 $Y=901800
X316 28 53 53 195 CLKINVX3 $T=2158200 856800 0 0 $X=2153900 $Y=852800
X317 28 53 158 195 CLKINVX3 $T=2679600 856800 1 0 $X=2675300 $Y=801000
X318 377 6 195 53 CLKBUFX4 $T=2541000 655200 1 180 $X=2503700 $Y=651200
X319 381 5 195 53 CLKBUFX4 $T=2686200 756000 1 180 $X=2648900 $Y=752000
X320 287 18 195 53 CLKBUFX4 $T=2970000 856800 0 0 $X=2965700 $Y=852800
X321 15 294 720 131 721 297 195 722 53 DFFSX1 $T=1339800 756000 0 0 $X=1335500 $Y=752000
X322 15 295 723 131 724 303 195 725 53 DFFSX1 $T=1412400 856800 0 0 $X=1408100 $Y=852800
X323 15 299 726 131 727 17 195 43 53 DFFSX1 $T=1478400 554400 0 0 $X=1474100 $Y=550400
X324 15 307 728 131 729 38 195 204 53 DFFSX1 $T=1617000 554400 0 180 $X=1487300 $Y=498600
X325 15 309 730 131 731 300 195 732 53 DFFSX1 $T=1617000 756000 1 180 $X=1487300 $Y=752000
X326 15 305 733 131 734 252 195 64 53 DFFSX1 $T=1511400 756000 1 0 $X=1507100 $Y=700200
X327 15 314 735 131 736 41 195 47 53 DFFSX1 $T=1643400 756000 1 0 $X=1639100 $Y=700200
X328 15 475 737 131 738 306 195 739 53 DFFSX1 $T=1683000 856800 0 0 $X=1678700 $Y=852800
X329 262 329 740 131 741 270 195 330 53 DFFSX1 $T=1815000 856800 0 0 $X=1810700 $Y=852800
X330 262 337 742 53 743 267 195 263 53 DFFSX1 $T=1933800 856800 1 0 $X=1929500 $Y=801000
X331 15 514 744 53 745 37 195 48 53 DFFSX1 $T=1980000 554400 1 0 $X=1975700 $Y=498600
X332 15 338 746 53 747 45 195 51 53 DFFSX1 $T=2006400 554400 0 0 $X=2002100 $Y=550400
X333 15 342 748 53 749 138 195 69 53 DFFSX1 $T=2046000 655200 0 0 $X=2041700 $Y=651200
X334 29 221 750 53 751 94 195 361 53 DFFSX1 $T=2191200 856800 0 0 $X=2186900 $Y=852800
X335 29 279 752 158 753 57 195 87 53 DFFSX1 $T=2343000 756000 0 0 $X=2338700 $Y=752000
X336 29 91 754 158 755 151 195 376 53 DFFSX1 $T=2475000 756000 0 0 $X=2470700 $Y=752000
X337 29 162 756 158 757 105 195 758 53 DFFSX1 $T=2706000 856800 1 0 $X=2701700 $Y=801000
X338 286 379 759 158 760 391 195 761 53 DFFSX1 $T=2844600 756000 0 0 $X=2840300 $Y=752000
X339 286 165 762 158 763 392 195 764 53 DFFSX1 $T=2851200 856800 1 0 $X=2846900 $Y=801000
X340 286 232 765 158 766 166 195 767 53 DFFSX1 $T=2989800 957600 0 180 $X=2860100 $Y=901800
X341 114 498 768 167 769 500 195 770 53 DFFSX1 $T=3049200 856800 0 0 $X=3044900 $Y=852800
X342 114 410 771 237 772 416 195 289 53 DFFSX1 $T=3174600 957600 1 0 $X=3170300 $Y=901800
X343 113 236 236 167 773 173 195 774 53 DFFSX1 $T=3234000 453600 0 0 $X=3229700 $Y=449600
X344 113 240 240 167 775 238 195 776 53 DFFSX1 $T=3392400 453600 0 180 $X=3262700 $Y=397800
X345 114 424 424 237 777 288 195 412 53 DFFSX1 $T=3359400 957600 1 0 $X=3355100 $Y=901800
X346 114 502 778 53 779 397 195 780 53 DFFSX1 $T=3385800 655200 0 0 $X=3381500 $Y=651200
X347 114 429 781 53 782 437 195 404 53 DFFSX1 $T=3399000 554400 1 0 $X=3394700 $Y=498600
X348 114 428 783 53 784 411 195 291 53 DFFSX1 $T=3418800 856800 1 0 $X=3414500 $Y=801000
X349 114 436 785 53 786 417 195 787 53 DFFSX1 $T=3445200 453600 1 0 $X=3440900 $Y=397800
X350 114 445 788 53 789 439 195 127 53 DFFSX1 $T=3623400 554400 1 180 $X=3493700 $Y=550400
X351 114 444 790 53 791 426 195 792 53 DFFSX1 $T=3531000 554400 1 0 $X=3526700 $Y=498600
X352 119 440 793 53 794 441 195 795 53 DFFSX1 $T=3590400 756000 1 0 $X=3586100 $Y=700200
X353 119 447 796 53 797 442 195 798 53 DFFSX1 $T=3590400 756000 0 0 $X=3586100 $Y=752000
X354 119 293 799 53 800 434 195 801 53 DFFSX1 $T=3603600 856800 1 0 $X=3599300 $Y=801000
X355 114 243 802 53 804 803 195 436 53 DFFSX1 $T=3636600 453600 1 0 $X=3632300 $Y=397800
X356 114 179 805 53 807 806 195 429 53 DFFSX1 $T=3636600 453600 0 0 $X=3632300 $Y=449600
X357 114 450 808 53 809 423 195 810 53 DFFSX1 $T=3636600 554400 0 0 $X=3632300 $Y=550400
X358 114 452 811 53 813 812 195 444 53 DFFSX1 $T=3663000 554400 1 0 $X=3658700 $Y=498600
X359 119 244 814 53 815 188 195 816 53 DFFSX1 $T=3715800 957600 1 0 $X=3711500 $Y=901800
X360 119 453 817 53 818 505 195 819 53 DFFSX1 $T=3722400 756000 0 0 $X=3718100 $Y=752000
X361 119 454 820 53 821 457 195 822 53 DFFSX1 $T=3729000 756000 1 0 $X=3724700 $Y=700200
X362 114 504 823 53 825 824 195 450 53 DFFSX1 $T=3755400 655200 1 0 $X=3751100 $Y=599400
X363 119 456 826 53 827 459 195 828 53 DFFSX1 $T=3775200 856800 0 0 $X=3770900 $Y=852800
X364 122 121 829 53 830 182 195 463 53 DFFSX1 $T=3801600 554400 1 0 $X=3797300 $Y=498600
X365 122 123 831 53 832 455 195 181 53 DFFSX1 $T=3821400 453600 0 0 $X=3817100 $Y=449600
X366 114 458 833 53 834 432 195 835 53 DFFSX1 $T=3854400 554400 0 0 $X=3850100 $Y=550400
X367 114 468 836 53 837 446 195 838 53 DFFSX1 $T=3973200 655200 1 0 $X=3968900 $Y=599400
X368 114 467 839 53 841 840 195 458 53 DFFSX1 $T=4111800 554400 1 180 $X=3982100 $Y=550400
X369 122 469 842 53 844 843 195 470 53 DFFSX1 $T=4012800 453600 0 0 $X=4008500 $Y=449600
X370 114 470 845 53 847 846 195 468 53 DFFSX1 $T=4059000 554400 1 0 $X=4054700 $Y=498600
X371 103 195 102 53 CLKINVX8 $T=2607000 756000 1 0 $X=2602700 $Y=700200
X372 76 144 195 281 53 52 265 OAI211XL $T=2356200 554400 1 180 $X=2312300 $Y=550400
X373 289 108 195 412 53 411 407 OAI211XL $T=3234000 856800 0 180 $X=3190100 $Y=801000
X374 438 290 195 435 53 291 440 OAI211XL $T=3458400 756000 0 0 $X=3454100 $Y=752000
X375 180 451 195 449 53 178 242 OAI211XL $T=3669600 856800 1 180 $X=3625700 $Y=852800
X376 457 462 195 461 53 178 454 OAI211XL $T=3920400 756000 0 180 $X=3876500 $Y=700200
X377 505 465 195 460 53 178 453 OAI211XL $T=3920400 856800 0 180 $X=3876500 $Y=801000
X378 185 188 195 464 53 178 184 OAI211XL $T=3953400 957600 0 180 $X=3909500 $Y=901800
X379 459 506 195 466 53 178 456 OAI211XL $T=3960000 856800 1 180 $X=3916100 $Y=852800
X380 366 112 195 53 INVX4 $T=2851200 856800 0 0 $X=2846900 $Y=852800
X381 272 195 267 53 251 NAND2X1 $T=1861200 655200 0 180 $X=1837100 $Y=599400
X382 67 195 366 53 156 NAND2X1 $T=2851200 856800 1 180 $X=2827100 $Y=852800
X383 348 53 50 195 56 491 NOR3XL $T=2164800 453600 0 0 $X=2160500 $Y=449600
X384 151 53 94 195 79 280 NOR3XL $T=2428800 957600 0 180 $X=2398100 $Y=901800
X385 372 53 151 195 78 150 NOR3XL $T=2494800 957600 0 180 $X=2464100 $Y=901800
X386 430 53 427 195 423 421 NOR3XL $T=3418800 655200 0 180 $X=3388100 $Y=599400
X387 495 95 53 195 379 AND2XL $T=2620200 756000 0 0 $X=2615900 $Y=752000
X388 296 53 300 271 195 NOR2BXL $T=1663200 856800 0 180 $X=1632500 $Y=801000
X389 115 53 174 292 195 NOR2BXL $T=3359400 856800 0 0 $X=3355100 $Y=852800
X390 434 53 433 425 195 NOR2BXL $T=3458400 756000 0 180 $X=3427700 $Y=700200
X391 257 29 195 53 15 AND2X4 $T=1749000 554400 0 0 $X=1744700 $Y=550400
X392 285 114 195 53 284 AND2X4 $T=2877600 655200 0 0 $X=2873300 $Y=651200
X393 373 195 84 53 CLKBUFX8 $T=2494800 655200 1 180 $X=2444300 $Y=651200
X394 378 195 2 53 CLKBUFX8 $T=2580600 756000 0 180 $X=2530100 $Y=700200
X395 500 195 3 53 CLKBUFX8 $T=3095400 957600 0 180 $X=3044900 $Y=901800
X396 28 195 53 53 INVX3 $T=3557400 856800 1 0 $X=3553100 $Y=801000
X397 280 53 147 147 195 NOR2BX1 $T=2389200 957600 0 180 $X=2358500 $Y=901800
X398 53 271 265 298 195 NOR2X1 $T=1735800 856800 0 180 $X=1711700 $Y=801000
X399 53 83 67 146 195 NOR2X1 $T=2316600 453600 1 0 $X=2312300 $Y=397800
X400 53 49 96 149 195 NOR2X1 $T=2415600 655200 1 180 $X=2391500 $Y=651200
X401 166 53 195 120 BUFX2 $T=3003000 957600 1 0 $X=2998700 $Y=901800
X402 499 53 195 234 BUFX2 $T=3095400 756000 0 0 $X=3091100 $Y=752000
X403 29 848 345 345 257 195 53 TLATNXL $T=2105400 957600 1 0 $X=2101100 $Y=901800
X404 29 849 380 850 388 195 53 TLATNXL $T=2719200 856800 0 0 $X=2714900 $Y=852800
X405 114 851 405 852 285 195 53 TLATNXL $T=3121800 756000 0 0 $X=3117500 $Y=752000
X406 114 853 419 854 415 195 53 TLATNXL $T=3306600 756000 1 0 $X=3302300 $Y=700200
X407 114 855 431 856 443 195 53 TLATNXL $T=3471600 856800 0 0 $X=3467300 $Y=852800
X408 100 101 858 857 158 49 53 195 358 DFFSX2 $T=2653200 957600 1 0 $X=2648900 $Y=901800
X409 78 195 79 71 73 53 NOR3X2 $T=2409000 856800 1 180 $X=2358500 $Y=852800
X410 116 195 170 53 INVX2 $T=3161400 856800 1 0 $X=3157100 $Y=801000
X411 321 89 24 195 53 NAND2X2 $T=2257200 756000 1 180 $X=2219900 $Y=752000
X412 148 149 223 195 53 NAND2X2 $T=2428800 453600 0 180 $X=2391500 $Y=397800
X413 97 365 89 195 53 NAND2X2 $T=2488200 856800 0 180 $X=2450900 $Y=801000
X414 382 4 195 53 BUFX4 $T=2712600 756000 0 180 $X=2675300 $Y=700200
X415 396 8 195 53 BUFX4 $T=3042600 856800 0 180 $X=3005300 $Y=801000
X416 397 7 195 53 BUFX4 $T=3049200 856800 1 180 $X=3011900 $Y=852800
X417 265 316 195 53 40 NOR2X2 $T=1742400 756000 0 0 $X=1738100 $Y=752000
X418 147 73 195 53 265 NOR2X2 $T=2303400 856800 0 180 $X=2266100 $Y=801000
X419 359 357 53 195 329 AND2X1 $T=2290200 756000 0 180 $X=2259500 $Y=700200
X420 81 365 53 195 77 AND2X1 $T=2435400 856800 0 180 $X=2404700 $Y=801000
X421 446 442 446 442 195 53 438 OAI2BB2XL $T=3583800 655200 1 180 $X=3533300 $Y=651200
X422 292 127 859 445 439 195 53 MXI2XL $T=3531000 655200 1 0 $X=3526700 $Y=599400
X423 296 300 195 265 860 53 476 AOI2BB1XL $T=1669800 856800 1 0 $X=1665500 $Y=801000
X424 144 62 195 49 49 53 49 AOI2BB1XL $T=2263800 453600 0 180 $X=2226500 $Y=397800
X425 435 434 195 433 861 53 419 AOI2BB1XL $T=3451800 756000 1 180 $X=3414500 $Y=752000
X426 423 401 401 423 53 195 409 AOI2BB2X1 $T=3379200 655200 0 180 $X=3328700 $Y=599400
X427 426 414 414 426 53 195 401 AOI2BB2X1 $T=3438600 453600 1 180 $X=3388100 $Y=449600
X428 512 265 265 53 329 265 329 195 AOI2BB2XL $T=1973400 756000 1 0 $X=1969100 $Y=700200
X429 417 409 409 53 417 862 406 195 AOI2BB2XL $T=3326400 655200 0 180 $X=3275900 $Y=599400
X430 418 416 288 53 174 863 239 195 AOI2BB2XL $T=3352800 957600 0 180 $X=3302300 $Y=901800
X431 148 83 195 96 49 359 53 OAI31XL $T=2455200 756000 0 180 $X=2411300 $Y=700200
X432 494 283 148 195 53 366 AND3X1 $T=2448600 554400 1 180 $X=2411300 $Y=550400
X433 351 321 195 265 488 490 53 OAI22XL $T=2197800 756000 1 180 $X=2153900 $Y=752000
X434 363 71 195 78 360 357 53 OAI22XL $T=2356200 856800 0 180 $X=2312300 $Y=801000
X435 271 515 274 53 24 195 218 AOI31XL $T=2105400 856800 0 180 $X=2068100 $Y=801000
X436 491 492 347 53 57 195 350 AOI31XL $T=2178000 655200 1 0 $X=2173700 $Y=599400
X437 301 298 297 53 296 298 195 294 AOI32XL $T=1491600 856800 0 180 $X=1441100 $Y=801000
X438 306 298 303 53 132 298 195 295 AOI32XL $T=1564200 957600 0 180 $X=1513700 $Y=901800
.ENDS
***************************************
.SUBCKT OAI22X2 B1 VSS B0 A1 VDD A0 Y
** N=12 EP=7 IP=0 FDC=16
M0 VSS B0 8 VSS n18 L=1.8e-07 W=7.8e-07 $X=6200 $Y=10550 $D=6
M1 8 B1 VSS VSS n18 L=1.8e-07 W=7.8e-07 $X=12200 $Y=10550 $D=6
M2 VSS B1 8 VSS n18 L=1.8e-07 W=7.8e-07 $X=19400 $Y=10550 $D=6
M3 8 B0 VSS VSS n18 L=1.8e-07 W=7.8e-07 $X=25400 $Y=10550 $D=6
M4 Y A0 8 VSS n18 L=1.8e-07 W=7.8e-07 $X=32600 $Y=10550 $D=6
M5 8 A1 Y VSS n18 L=1.8e-07 W=7.8e-07 $X=39800 $Y=10550 $D=6
M6 Y A1 8 VSS n18 L=1.8e-07 W=7.8e-07 $X=45800 $Y=10550 $D=6
M7 8 A0 Y VSS n18 L=1.8e-07 W=7.8e-07 $X=53000 $Y=10550 $D=6
M8 9 B0 Y VDD p18 L=1.8e-07 W=1.2e-06 $X=6200 $Y=29450 $D=10
M9 VDD B1 9 VDD p18 L=1.8e-07 W=1.2e-06 $X=12200 $Y=29450 $D=10
M10 10 B1 VDD VDD p18 L=1.8e-07 W=1.2e-06 $X=19400 $Y=29450 $D=10
M11 Y B0 10 VDD p18 L=1.8e-07 W=1.2e-06 $X=25100 $Y=29450 $D=10
M12 11 A0 Y VDD p18 L=1.8e-07 W=1.2e-06 $X=32300 $Y=29450 $D=10
M13 VDD A1 11 VDD p18 L=1.8e-07 W=1.2e-06 $X=37900 $Y=29450 $D=10
M14 12 A1 VDD VDD p18 L=1.8e-07 W=1.2e-06 $X=45100 $Y=29450 $D=10
M15 Y A0 12 VDD p18 L=1.8e-07 W=1.2e-06 $X=50700 $Y=29450 $D=10
.ENDS
***************************************
.SUBCKT ICV_9 1 2 3 4 5 6 7 8 9 10 11 12 13 14 15 16 17 18 19 20
+ 21 22 23 24 25 26 27 28 29 30 31 32 33 34 35 36 37 38 39 40
+ 41 42 43 44 45 46 47 49 50 51 52 53 54 55 56 57 58 60 61 62
+ 63 64 65 67 68 69 70 71 72 73 74 75 76 77 78 79 80 81 82 83
+ 84 85 86 87 88 89 90 91 92 93 94 95 96 97 98 99 100 101 102 103
+ 104 105 106 107 108 109 110 111 112 113 114 115 116 117 118 119 121 122 123 124
+ 125 126 127 128 132 133 134 135 136 137 138 139 140 141 142 143 144 145 146 147
+ 148 149 150 151 152 153 154 155 156 157 158 159 160 161 162 163 164 165 166 167
+ 168 169 170 171 172 173
*.CALIBRE ICV_CELL 2
** N=487 EP=166 IP=1632 FDC=2589
M0 122 171 133 133 n18 L=1.87493e-07 W=1.21284e-06 $X=3877200 $Y=33400 $D=6
M1 133 171 122 133 n18 L=1.84622e-07 W=1.17971e-06 $X=3884800 $Y=39200 $D=6
M2 122 171 133 133 n18 L=1.84622e-07 W=1.17971e-06 $X=3891600 $Y=33400 $D=6
M3 133 171 122 133 n18 L=1.87372e-07 W=1.23284e-06 $X=3898400 $Y=40000 $D=6
M4 373 332 133 133 n18 L=1.8e-07 W=6.6e-07 $X=4044200 $Y=134100 $D=6
M5 327 375 373 133 n18 L=1.8e-07 W=6.6e-07 $X=4052400 $Y=135300 $D=6
M6 374 335 327 133 n18 L=1.8e-07 W=6.6e-07 $X=4060000 $Y=135300 $D=6
M7 133 336 374 133 n18 L=1.8e-07 W=6.6e-07 $X=4067700 $Y=134800 $D=6
M8 375 335 133 133 n18 L=1.8e-07 W=3e-07 $X=4076000 $Y=134800 $D=6
M9 122 171 60 60 p18 L=1.84048e-07 W=1.79627e-06 $X=3877200 $Y=14500 $D=10
M10 60 171 122 60 p18 L=1.84048e-07 W=1.79627e-06 $X=3884400 $Y=5900 $D=10
M11 122 171 60 60 p18 L=1.84048e-07 W=1.79627e-06 $X=3891600 $Y=14500 $D=10
M12 60 171 122 60 p18 L=1.84048e-07 W=1.79627e-06 $X=3898800 $Y=5900 $D=10
M13 373 332 60 60 p18 L=1.8e-07 W=1e-06 $X=4044200 $Y=113500 $D=10
M14 327 335 373 60 p18 L=1.8e-07 W=1e-06 $X=4052200 $Y=113500 $D=10
M15 374 375 327 60 p18 L=1.8e-07 W=1e-06 $X=4060200 $Y=113500 $D=10
M16 60 336 374 60 p18 L=1.8e-07 W=1e-06 $X=4067800 $Y=113500 $D=10
M17 375 335 60 60 p18 L=1.8e-07 W=4.6e-07 $X=4077000 $Y=116300 $D=10
X18 235 133 60 192 247 NAND2XL $T=2125200 252000 0 0 $X=2120900 $Y=248000
X19 240 133 60 26 21 NAND2XL $T=2125200 352800 1 0 $X=2120900 $Y=297000
X20 30 133 60 188 91 NAND2XL $T=2197800 352800 1 0 $X=2193500 $Y=297000
X21 43 133 60 251 178 NAND2XL $T=2224200 252000 0 180 $X=2200100 $Y=196200
X22 38 133 60 251 187 NAND2XL $T=2250600 252000 0 180 $X=2226500 $Y=196200
X23 35 133 60 43 180 NAND2XL $T=2277000 252000 0 180 $X=2252900 $Y=196200
X24 35 133 60 347 190 NAND2XL $T=2283600 252000 1 0 $X=2279300 $Y=196200
X25 41 133 60 38 249 NAND2XL $T=2329800 252000 0 180 $X=2305700 $Y=196200
X26 41 133 60 43 236 NAND2XL $T=2369400 252000 1 180 $X=2345300 $Y=248000
X27 352 133 60 109 155 NAND2XL $T=2574000 352800 0 180 $X=2549900 $Y=297000
X28 353 133 60 109 104 NAND2XL $T=2593800 352800 0 180 $X=2569700 $Y=297000
X29 261 133 60 109 154 NAND2XL $T=2620200 352800 1 180 $X=2596100 $Y=348800
X30 355 133 60 109 112 NAND2XL $T=2646600 352800 1 180 $X=2622500 $Y=348800
X31 198 133 60 109 157 NAND2XL $T=2673000 352800 1 180 $X=2648900 $Y=348800
X32 200 133 60 109 159 NAND2XL $T=2699400 352800 1 180 $X=2675300 $Y=348800
X33 265 133 60 260 356 NAND2XL $T=2719200 252000 1 180 $X=2695100 $Y=248000
X34 201 133 60 206 358 NAND2XL $T=2732400 151200 1 180 $X=2708300 $Y=147200
X35 359 133 60 109 160 NAND2XL $T=2739000 352800 1 180 $X=2714900 $Y=348800
X36 361 133 60 109 161 NAND2XL $T=2778600 352800 1 180 $X=2754500 $Y=348800
X37 266 133 60 49 267 NAND2XL $T=2785200 50400 0 0 $X=2780900 $Y=46400
X38 274 133 60 49 262 NAND2XL $T=2811600 151200 1 180 $X=2787500 $Y=147200
X39 362 133 60 271 265 NAND2XL $T=2811600 252000 1 180 $X=2787500 $Y=248000
X40 276 133 60 275 271 NAND2XL $T=2838000 151200 1 180 $X=2813900 $Y=147200
X41 203 133 60 266 274 NAND2XL $T=2851200 50400 1 180 $X=2827100 $Y=46400
X42 278 133 60 109 162 NAND2XL $T=2857800 352800 1 180 $X=2833700 $Y=348800
X43 279 133 60 282 372 NAND2XL $T=2877600 352800 0 0 $X=2873300 $Y=348800
X44 365 133 60 287 210 NAND2XL $T=2937000 252000 1 0 $X=2932700 $Y=196200
X45 49 133 60 109 163 NAND2XL $T=2989800 352800 1 180 $X=2965700 $Y=348800
X46 53 133 60 211 286 NAND2XL $T=3036000 151200 0 180 $X=3011900 $Y=95400
X47 49 133 60 53 366 NAND2XL $T=3062400 352800 1 180 $X=3038300 $Y=348800
X48 310 133 60 315 215 NAND2XL $T=3762000 252000 1 0 $X=3757700 $Y=196200
X49 368 133 60 321 317 NAND2XL $T=3847800 151200 0 0 $X=3843500 $Y=147200
X50 322 133 60 313 216 NAND2XL $T=3874200 252000 0 180 $X=3850100 $Y=196200
X51 319 133 60 321 168 NAND2XL $T=3880800 252000 0 0 $X=3876500 $Y=248000
X52 128 133 60 316 324 NAND2XL $T=3907200 352800 0 180 $X=3883100 $Y=297000
X53 318 133 60 327 330 NAND2XL $T=4012800 252000 0 0 $X=4008500 $Y=248000
X54 60 192 244 241 133 NOR2XL $T=2158200 252000 0 180 $X=2134100 $Y=196200
X55 60 30 26 244 133 NOR2XL $T=2184600 252000 0 180 $X=2160500 $Y=196200
X56 60 192 97 188 133 NOR2XL $T=2329800 352800 1 180 $X=2305700 $Y=348800
X57 60 201 269 272 133 NOR2XL $T=2758800 151200 1 0 $X=2754500 $Y=95400
X58 60 203 269 208 133 NOR2XL $T=2805000 50400 0 0 $X=2800700 $Y=46400
X59 60 274 277 276 133 NOR2XL $T=2844600 151200 0 0 $X=2840300 $Y=147200
X60 60 206 207 283 133 NOR2XL $T=2877600 252000 0 0 $X=2873300 $Y=248000
X61 60 280 283 282 133 NOR2XL $T=2963400 352800 1 180 $X=2939300 $Y=348800
X62 60 49 287 264 133 NOR2XL $T=2976600 252000 1 180 $X=2952500 $Y=248000
X63 60 49 280 211 133 NOR2XL $T=2996400 252000 0 0 $X=2992100 $Y=248000
X64 60 166 125 316 133 NOR2XL $T=3768600 352800 1 180 $X=3744500 $Y=348800
X65 60 309 216 315 133 NOR2XL $T=3781800 252000 1 0 $X=3777500 $Y=196200
X66 244 60 133 243 INVXL $T=2125200 151200 0 180 $X=2107700 $Y=95400
X67 26 60 133 251 INVXL $T=2184600 252000 1 0 $X=2180300 $Y=196200
X68 34 60 133 347 INVXL $T=2296800 352800 1 0 $X=2292500 $Y=297000
X69 99 60 133 192 INVXL $T=2343000 352800 1 180 $X=2325500 $Y=348800
X70 205 60 133 260 INVXL $T=2679600 252000 0 0 $X=2675300 $Y=248000
X71 203 60 133 201 INVXL $T=2706000 151200 1 0 $X=2701700 $Y=95400
X72 207 60 133 269 INVXL $T=2798400 151200 0 180 $X=2780900 $Y=95400
X73 199 60 133 363 INVXL $T=2811600 252000 0 0 $X=2807300 $Y=248000
X74 208 60 133 268 INVXL $T=2838000 252000 0 180 $X=2820500 $Y=196200
X75 285 60 133 275 INVXL $T=2923800 151200 1 180 $X=2906300 $Y=147200
X76 49 60 133 365 INVXL $T=2923800 151200 0 0 $X=2919500 $Y=147200
X77 280 60 133 199 INVXL $T=2950200 352800 1 0 $X=2945900 $Y=297000
X78 288 60 133 277 INVXL $T=2989800 151200 1 180 $X=2972300 $Y=147200
X79 289 60 133 287 INVXL $T=2996400 252000 1 180 $X=2978900 $Y=248000
X80 121 60 133 165 INVXL $T=3471600 151200 0 180 $X=3454100 $Y=95400
X81 318 60 133 321 INVXL $T=3913800 252000 1 180 $X=3896300 $Y=248000
X82 327 60 133 334 INVXL $T=4039200 252000 0 0 $X=4034900 $Y=248000
X83 11 133 86 339 60 218 OAI21XL $T=1696200 352800 1 180 $X=1665500 $Y=348800
X84 15 133 86 340 60 223 OAI21XL $T=1729200 352800 1 180 $X=1698500 $Y=348800
X85 86 133 14 341 60 231 OAI21XL $T=1749000 352800 0 0 $X=1744700 $Y=348800
X86 89 133 235 139 60 232 OAI21XL $T=1854600 352800 1 180 $X=1823900 $Y=348800
X87 140 133 12 141 60 237 OAI21XL $T=1874400 352800 0 0 $X=1870100 $Y=348800
X88 183 133 24 92 60 145 OAI21XL $T=2125200 352800 0 0 $X=2120900 $Y=348800
X89 150 133 30 188 60 146 OAI21XL $T=2296800 352800 1 180 $X=2266100 $Y=348800
X90 265 133 260 356 60 355 OAI21XL $T=2719200 352800 0 180 $X=2688500 $Y=297000
X91 203 133 266 207 60 263 OAI21XL $T=2752200 151200 0 180 $X=2721500 $Y=95400
X92 279 133 282 372 60 51 OAI21XL $T=2904000 352800 0 0 $X=2899700 $Y=348800
X93 365 133 266 208 60 364 OAI21XL $T=2943600 151200 0 180 $X=2912900 $Y=95400
X94 291 133 116 52 60 288 OAI21XL $T=3042600 252000 0 180 $X=3011900 $Y=196200
X95 215 133 214 314 60 308 OAI21XL $T=3748800 252000 0 0 $X=3744500 $Y=248000
X96 167 133 126 125 60 124 OAI21XL $T=3808200 352800 1 180 $X=3777500 $Y=348800
X97 322 133 313 216 60 299 OAI21XL $T=3867600 252000 1 180 $X=3836900 $Y=248000
X98 324 133 127 320 60 369 OAI21XL $T=3874200 352800 0 180 $X=3843500 $Y=297000
X99 11 183 60 87 376 133 339 AOI21XL $T=1709400 352800 0 180 $X=1678700 $Y=297000
X100 15 228 60 87 377 133 340 AOI21XL $T=1749000 352800 0 180 $X=1718300 $Y=297000
X101 14 233 60 87 378 133 341 AOI21XL $T=1815000 352800 1 180 $X=1784300 $Y=348800
X102 36 347 60 149 379 133 246 AOI21XL $T=2296800 352800 0 180 $X=2266100 $Y=297000
X103 267 274 60 269 380 133 259 AOI21XL $T=2745600 50400 0 0 $X=2741300 $Y=46400
X104 285 266 60 277 381 133 284 AOI21XL $T=2970000 151200 1 180 $X=2939300 $Y=147200
X105 199 115 60 290 382 133 289 AOI21XL $T=3003000 352800 0 180 $X=2972300 $Y=297000
X106 366 52 60 115 383 133 290 AOI21XL $T=3036000 352800 0 180 $X=3005300 $Y=297000
X107 125 166 60 316 384 133 319 AOI21XL $T=3768600 352800 1 0 $X=3764300 $Y=297000
X108 215 214 60 318 385 133 314 AOI21XL $T=3775200 252000 0 0 $X=3770900 $Y=248000
X109 309 216 60 315 386 133 368 AOI21XL $T=3801600 252000 1 0 $X=3797300 $Y=196200
X110 324 127 60 318 387 133 320 AOI21XL $T=3834600 252000 1 180 $X=3803900 $Y=248000
X111 172 331 60 334 388 133 333 AOI21XL $T=4105200 252000 1 180 $X=4074500 $Y=248000
X112 85 13 390 389 83 391 16 133 238 60 DFFSXL $T=1768800 252000 1 0 $X=1764500 $Y=196200
X113 85 232 393 392 83 394 235 133 17 60 DFFSXL $T=1768800 352800 1 0 $X=1764500 $Y=297000
X114 57 292 396 395 118 397 52 133 398 60 DFFSXL $T=3082200 352800 0 0 $X=3077900 $Y=348800
X115 210 133 288 399 60 273 NAND2BXL $T=2996400 252000 0 180 $X=2965700 $Y=196200
X116 291 133 116 400 60 285 NAND2BXL $T=3075600 252000 0 180 $X=3044900 $Y=196200
X117 322 133 321 401 60 370 NAND2BXL $T=3887400 252000 1 0 $X=3883100 $Y=196200
X118 126 133 321 402 60 329 NAND2BXL $T=3966600 352800 1 0 $X=3962300 $Y=297000
X119 259 205 133 60 352 XOR2XL $T=2620200 252000 0 180 $X=2563100 $Y=196200
X120 117 295 133 60 293 XOR2XL $T=3280200 252000 1 180 $X=3223100 $Y=248000
X121 119 297 133 60 117 XOR2XL $T=3286800 352800 1 180 $X=3229700 $Y=348800
X122 293 296 133 60 164 XOR2XL $T=3247200 252000 1 0 $X=3242900 $Y=196200
X123 53 211 133 286 60 203 OAI21X1 $T=2996400 151200 0 180 $X=2959100 $Y=95400
X124 116 115 60 52 280 133 AOI21X1 $T=3029400 352800 1 180 $X=2998700 $Y=348800
X125 21 228 60 343 133 344 245 AOI211XL $T=2079000 252000 0 0 $X=2074700 $Y=248000
X126 242 192 60 27 133 147 345 AOI211XL $T=2151600 352800 1 0 $X=2147300 $Y=297000
X127 264 207 60 259 133 206 354 AOI211XL $T=2666400 252000 0 180 $X=2629100 $Y=196200
X128 206 201 60 204 133 270 202 AOI211XL $T=2745600 151200 0 0 $X=2741300 $Y=147200
X129 210 207 60 208 133 206 362 AOI211XL $T=2864400 252000 1 180 $X=2827100 $Y=248000
X130 124 318 133 60 61 OR2XL $T=3801600 352800 1 0 $X=3797300 $Y=297000
X131 299 318 133 60 325 OR2XL $T=3913800 252000 1 0 $X=3909500 $Y=196200
X132 172 334 133 60 173 OR2XL $T=4125000 252000 0 0 $X=4120700 $Y=248000
X133 8 321 327 133 371 60 OAI2BB1XL $T=3946800 252000 1 0 $X=3942500 $Y=196200
X134 97 133 39 60 38 191 NAND3XL $T=2336400 352800 0 180 $X=2305700 $Y=297000
X135 274 133 210 60 275 281 NAND3XL $T=2871000 151200 0 0 $X=2866700 $Y=147200
X136 331 133 63 60 327 318 NAND3XL $T=4006200 252000 1 180 $X=3975500 $Y=248000
X137 174 60 24 189 91 346 133 AOI22XL $T=2250600 352800 0 180 $X=2213300 $Y=297000
X138 198 60 199 207 262 357 133 AOI22XL $T=2659800 151200 0 0 $X=2655500 $Y=147200
X139 365 60 272 284 281 209 133 AOI22XL $T=2923800 252000 0 180 $X=2886500 $Y=196200
X140 213 60 312 310 309 298 133 AOI22XL $T=3742200 151200 0 180 $X=3704900 $Y=95400
X141 214 60 310 311 213 307 133 AOI22XL $T=3755400 252000 0 180 $X=3718100 $Y=196200
X142 346 133 148 345 32 245 60 NAND4XL $T=2224200 352800 1 180 $X=2186900 $Y=348800
X143 348 58 133 60 CLKBUFX3 $T=2442000 352800 1 0 $X=2437700 $Y=297000
X144 349 56 133 60 CLKBUFX3 $T=2448600 352800 0 0 $X=2444300 $Y=348800
X145 196 3 133 60 CLKBUFX3 $T=2494800 151200 0 180 $X=2464100 $Y=95400
X146 350 55 133 60 CLKBUFX3 $T=2501400 352800 1 0 $X=2497100 $Y=297000
X147 106 4 133 60 CLKBUFX3 $T=2534400 252000 1 180 $X=2503700 $Y=248000
X148 156 2 133 60 CLKBUFX3 $T=2560800 151200 0 180 $X=2530100 $Y=95400
X149 257 54 133 60 CLKBUFX3 $T=2547600 252000 0 0 $X=2543300 $Y=248000
X150 43 181 60 133 CLKINVX4 $T=2395800 252000 1 180 $X=2365100 $Y=248000
X151 338 60 133 132 CLKBUFX2 $T=1544400 50400 1 180 $X=1513700 $Y=46400
X152 219 60 133 70 CLKBUFX2 $T=1597200 50400 1 180 $X=1566500 $Y=46400
X153 222 60 133 79 CLKBUFX2 $T=1623600 50400 0 180 $X=1592900 $Y=-5400
X154 221 60 133 73 CLKBUFX2 $T=1623600 50400 1 180 $X=1592900 $Y=46400
X155 224 60 133 77 CLKBUFX2 $T=1676400 50400 0 180 $X=1645700 $Y=-5400
X156 225 60 133 74 CLKBUFX2 $T=1696200 50400 1 180 $X=1665500 $Y=46400
X157 226 60 133 75 CLKBUFX2 $T=1729200 50400 0 180 $X=1698500 $Y=-5400
X158 227 60 133 71 CLKBUFX2 $T=1735800 50400 1 180 $X=1705100 $Y=46400
X159 230 60 133 72 CLKBUFX2 $T=1782000 50400 1 180 $X=1751300 $Y=46400
X160 342 60 133 78 CLKBUFX2 $T=1788600 50400 0 180 $X=1757900 $Y=-5400
X161 234 60 133 76 CLKBUFX2 $T=1808400 50400 1 180 $X=1777700 $Y=46400
X162 179 60 133 80 CLKBUFX2 $T=1993200 50400 0 180 $X=1962500 $Y=-5400
X163 184 60 133 84 CLKBUFX2 $T=2052600 50400 0 180 $X=2021900 $Y=-5400
X164 186 60 133 81 CLKBUFX2 $T=2092200 50400 0 180 $X=2061500 $Y=-5400
X165 255 60 133 82 CLKBUFX2 $T=2376000 50400 1 0 $X=2371700 $Y=-5400
X166 152 60 133 68 CLKBUFX2 $T=2475000 252000 1 180 $X=2444300 $Y=248000
X167 253 60 133 107 CLKBUFX2 $T=2468400 50400 1 0 $X=2464100 $Y=-5400
X168 153 60 133 69 CLKBUFX2 $T=2494800 352800 0 180 $X=2464100 $Y=297000
X169 250 60 133 108 CLKBUFX2 $T=2514600 50400 1 0 $X=2510300 $Y=-5400
X170 351 60 133 111 CLKBUFX2 $T=2554200 151200 0 0 $X=2549900 $Y=147200
X171 256 60 133 113 CLKBUFX2 $T=2580600 50400 0 0 $X=2576300 $Y=46400
X172 258 60 133 114 CLKBUFX2 $T=2626800 50400 0 0 $X=2622500 $Y=46400
X173 217 60 64 403 133 62 AND2X2 $T=3960000 352800 0 0 $X=3955700 $Y=348800
X174 229 133 60 174 BUFX1 $T=1775400 252000 1 180 $X=1744700 $Y=248000
X175 177 133 60 138 BUFX1 $T=1966800 50400 0 180 $X=1936100 $Y=-5400
X176 34 133 60 176 BUFX1 $T=2257200 252000 0 0 $X=2252900 $Y=248000
X177 252 133 60 100 BUFX1 $T=2409000 50400 1 0 $X=2404700 $Y=-5400
X178 248 133 60 101 BUFX1 $T=2442000 50400 1 0 $X=2437700 $Y=-5400
X179 197 133 60 105 BUFX1 $T=2508000 50400 0 0 $X=2503700 $Y=46400
X180 254 133 60 110 BUFX1 $T=2547600 50400 1 0 $X=2543300 $Y=-5400
X181 195 133 60 158 BUFX1 $T=2587200 50400 1 0 $X=2582900 $Y=-5400
X182 50 133 60 123 BUFX1 $T=3643200 252000 0 0 $X=3638900 $Y=248000
X183 64 133 60 326 BUFX1 $T=4184400 151200 0 180 $X=4153700 $Y=95400
X184 122 60 60 133 CLKINVX3 $T=3603600 352800 1 0 $X=3599300 $Y=297000
X185 85 135 404 83 405 136 133 229 60 DFFSX1 $T=1531200 352800 0 0 $X=1526900 $Y=348800
X186 85 218 406 83 407 9 133 183 60 DFFSX1 $T=1537800 352800 1 0 $X=1533500 $Y=297000
X187 85 223 408 83 409 10 133 228 60 DFFSX1 $T=1636800 252000 1 0 $X=1632500 $Y=196200
X188 85 231 410 83 411 18 133 233 60 DFFSX1 $T=1894200 252000 0 0 $X=1889900 $Y=248000
X189 85 237 412 60 413 12 133 189 60 DFFSX1 $T=1907400 352800 1 0 $X=1903100 $Y=297000
X190 85 142 414 60 415 143 133 239 60 DFFSX1 $T=1920600 352800 0 0 $X=1916300 $Y=348800
X191 57 293 416 118 417 53 133 418 60 DFFSX1 $T=3088800 252000 0 0 $X=3084500 $Y=248000
X192 67 294 419 118 420 297 133 421 60 DFFSX1 $T=3181200 151200 0 0 $X=3176900 $Y=147200
X193 67 298 422 118 424 423 133 294 60 DFFSX1 $T=3306600 151200 0 0 $X=3302300 $Y=147200
X194 67 299 425 118 427 426 133 367 60 DFFSX1 $T=3306600 252000 0 0 $X=3302300 $Y=248000
X195 67 300 428 118 429 295 133 430 60 DFFSX1 $T=3319800 352800 1 0 $X=3315500 $Y=297000
X196 67 367 431 60 432 296 133 433 60 DFFSX1 $T=3432000 252000 1 0 $X=3427700 $Y=196200
X197 67 303 434 60 435 301 133 292 60 DFFSX1 $T=3451800 352800 1 0 $X=3447500 $Y=297000
X198 67 304 436 60 437 302 133 438 60 DFFSX1 $T=3458400 352800 0 0 $X=3454100 $Y=348800
X199 67 214 439 60 441 440 133 303 60 DFFSX1 $T=3524400 151200 0 0 $X=3520100 $Y=147200
X200 67 305 442 60 444 443 133 300 60 DFFSX1 $T=3557400 252000 1 0 $X=3553100 $Y=196200
X201 67 307 445 60 447 446 133 304 60 DFFSX1 $T=3636600 352800 1 0 $X=3632300 $Y=297000
X202 212 306 448 60 449 310 133 213 60 DFFSX1 $T=3643200 50400 0 0 $X=3638900 $Y=46400
X203 212 308 450 60 451 311 133 214 60 DFFSX1 $T=3656400 151200 0 0 $X=3652100 $Y=147200
X204 212 317 452 60 453 312 133 309 60 DFFSX1 $T=3768600 151200 1 0 $X=3764300 $Y=95400
X205 62 369 454 60 455 169 133 127 60 DFFSX1 $T=3834600 352800 0 0 $X=3830300 $Y=348800
X206 212 325 456 60 457 313 133 458 60 DFFSX1 $T=3900600 151200 1 0 $X=3896300 $Y=95400
X207 212 370 459 60 460 322 133 461 60 DFFSX1 $T=3920400 151200 0 0 $X=3916100 $Y=147200
X208 62 328 462 60 463 128 133 170 60 DFFSX1 $T=4118400 352800 1 180 $X=3988700 $Y=348800
X209 62 329 464 60 465 126 133 466 60 DFFSX1 $T=4006200 352800 1 0 $X=4001900 $Y=297000
X210 62 333 467 60 468 331 133 469 60 DFFSX1 $T=4026000 252000 1 0 $X=4021700 $Y=196200
X211 326 65 470 60 472 471 133 337 60 DFFSX1 $T=4065600 151200 0 0 $X=4061300 $Y=147200
X212 326 336 473 60 474 335 133 475 60 DFFSX1 $T=4237200 50400 1 180 $X=4107500 $Y=46400
X213 326 337 476 60 477 332 133 336 60 DFFSX1 $T=4243800 50400 0 180 $X=4114100 $Y=-5400
X214 268 266 133 358 60 357 200 OAI211XL $T=2739000 252000 0 180 $X=2695100 $Y=196200
X215 268 264 133 271 60 273 360 OAI211XL $T=2752200 252000 0 0 $X=2747900 $Y=248000
X216 315 310 133 215 60 321 306 OAI211XL $T=3801600 151200 0 0 $X=3797300 $Y=147200
X217 128 316 133 324 60 321 328 OAI211XL $T=3920400 352800 1 0 $X=3916100 $Y=297000
X218 36 133 38 60 182 NAND2X1 $T=2336400 252000 1 180 $X=2312300 $Y=248000
X219 281 280 60 133 278 AND2XL $T=2937000 352800 0 180 $X=2906300 $Y=297000
X220 272 60 264 270 133 NOR2BXL $T=2818200 252000 0 180 $X=2787500 $Y=196200
X221 1 133 67 60 CLKBUFX8 $T=4191000 151200 0 0 $X=4186700 $Y=147200
X222 210 60 208 276 133 270 279 AOI211X1 $T=2884200 252000 0 180 $X=2846900 $Y=196200
X223 60 277 275 207 133 NOR2X1 $T=2851200 151200 0 180 $X=2827100 $Y=95400
X224 60 273 285 206 133 NOR2X1 $T=2943600 252000 1 180 $X=2919500 $Y=248000
X225 326 478 371 479 323 133 60 TLATNXL $T=3960000 50400 0 0 $X=3955700 $Y=46400
X226 326 480 330 481 217 133 60 TLATNXL $T=4039200 50400 0 0 $X=4034900 $Y=46400
X227 6 246 133 188 60 239 247 29 OAI221XL $T=2244000 252000 1 180 $X=2193500 $Y=248000
X228 220 133 60 134 CLKBUFXL $T=1597200 50400 0 180 $X=1566500 $Y=-5400
X229 17 133 60 242 CLKBUFXL $T=2039400 352800 1 0 $X=2035100 $Y=297000
X230 43 36 175 133 60 NAND2X2 $T=2382600 352800 0 180 $X=2345300 $Y=297000
X231 99 151 194 133 60 NAND2X2 $T=2389200 352800 1 180 $X=2351900 $Y=348800
X232 291 289 133 60 266 NOR2X2 $T=3042600 151200 1 180 $X=3005300 $Y=147200
X233 323 64 60 133 212 AND2X1 $T=3894000 151200 0 0 $X=3889700 $Y=147200
X234 86 133 137 60 CLKINVX2 $T=1749000 352800 1 180 $X=1724900 $Y=348800
X235 38 133 193 60 CLKINVX2 $T=2329800 252000 1 0 $X=2325500 $Y=196200
X236 38 133 185 60 CLKINVX2 $T=2349600 252000 1 0 $X=2345300 $Y=196200
X237 203 206 263 262 133 60 198 OAI2BB2XL $T=2699400 151200 0 180 $X=2648900 $Y=95400
X238 354 260 354 353 205 133 60 MXI2XL $T=2633400 252000 1 180 $X=2582900 $Y=248000
X239 202 260 482 261 205 133 60 MXI2XL $T=2679600 252000 1 180 $X=2629100 $Y=248000
X240 360 205 483 359 260 133 60 MXI2XL $T=2778600 352800 0 180 $X=2728100 $Y=297000
X241 209 260 484 361 205 133 60 MXI2XL $T=2831400 352800 0 180 $X=2780900 $Y=297000
X242 302 292 485 119 301 133 60 MXI2XL $T=3432000 352800 1 180 $X=3381500 $Y=348800
X243 94 30 133 192 486 60 240 AOI2BB1XL $T=2191200 252000 1 180 $X=2153900 $Y=248000
X244 313 309 309 60 313 487 305 133 AOI2BB2XL $T=3729000 252000 1 180 $X=3678500 $Y=248000
X245 267 277 133 53 364 204 60 OAI31XL $T=2864400 50400 0 0 $X=2860100 $Y=46400
X246 115 53 49 133 60 291 AND3X1 $T=3029400 252000 0 0 $X=3025100 $Y=248000
X247 180 194 133 185 228 338 60 OAI22XL $T=1828200 151200 0 180 $X=1784300 $Y=95400
X248 178 33 133 193 174 222 60 OAI22XL $T=1874400 50400 1 180 $X=1830500 $Y=46400
X249 178 194 133 185 233 219 60 OAI22XL $T=1874400 151200 0 180 $X=1830500 $Y=95400
X250 236 176 133 185 6 221 60 OAI22XL $T=1907400 151200 1 180 $X=1863500 $Y=147200
X251 236 33 133 185 23 220 60 OAI22XL $T=1920600 151200 0 180 $X=1876700 $Y=95400
X252 175 33 133 193 7 226 60 OAI22XL $T=1927200 50400 1 180 $X=1883300 $Y=46400
X253 175 176 133 185 5 225 60 OAI22XL $T=1927200 151200 1 0 $X=1922900 $Y=95400
X254 30 180 133 185 238 227 60 OAI22XL $T=1973400 151200 1 180 $X=1929500 $Y=147200
X255 178 176 133 193 183 224 60 OAI22XL $T=1960200 50400 0 0 $X=1955900 $Y=46400
X256 180 33 133 193 37 342 60 OAI22XL $T=2006400 50400 0 0 $X=2002100 $Y=46400
X257 240 18 133 16 241 344 60 OAI22XL $T=2032800 252000 0 0 $X=2028500 $Y=248000
X258 181 243 133 185 242 230 60 OAI22XL $T=2098800 50400 1 180 $X=2054900 $Y=46400
X259 246 19 133 188 143 343 60 OAI22XL $T=2112000 352800 1 180 $X=2068100 $Y=348800
X260 240 233 133 238 241 22 60 OAI22XL $T=2079000 252000 1 0 $X=2074700 $Y=196200
X261 181 7 133 33 182 248 60 OAI22XL $T=2158200 50400 1 180 $X=2114300 $Y=46400
X262 181 183 133 176 187 250 60 OAI22XL $T=2158200 50400 0 0 $X=2153900 $Y=46400
X263 181 28 133 30 249 177 60 OAI22XL $T=2197800 151200 1 180 $X=2153900 $Y=147200
X264 181 5 133 176 182 252 60 OAI22XL $T=2204400 151200 1 0 $X=2200100 $Y=95400
X265 181 174 133 33 187 253 60 OAI22XL $T=2211000 50400 0 0 $X=2206700 $Y=46400
X266 181 190 133 193 31 234 60 OAI22XL $T=2211000 151200 0 0 $X=2206700 $Y=147200
X267 194 249 133 46 181 184 60 OAI22XL $T=2296800 151200 1 180 $X=2252900 $Y=147200
X268 181 31 133 193 190 197 60 OAI22XL $T=2310000 151200 0 0 $X=2305700 $Y=147200
X269 181 37 133 33 191 254 60 OAI22XL $T=2356200 50400 1 180 $X=2312300 $Y=46400
X270 42 181 133 193 40 179 60 OAI22XL $T=2356200 151200 0 180 $X=2312300 $Y=95400
X271 181 40 133 193 42 195 60 OAI22XL $T=2409000 50400 1 180 $X=2365100 $Y=46400
X272 181 98 133 193 44 186 60 OAI22XL $T=2409000 151200 0 180 $X=2365100 $Y=95400
X273 175 194 133 185 189 350 60 OAI22XL $T=2389200 352800 1 0 $X=2384900 $Y=297000
X274 30 175 133 185 239 348 60 OAI22XL $T=2395800 352800 0 0 $X=2391500 $Y=348800
X275 236 194 133 193 46 257 60 OAI22XL $T=2402400 252000 1 0 $X=2398100 $Y=196200
X276 30 236 133 185 28 349 60 OAI22XL $T=2409000 252000 0 0 $X=2404700 $Y=248000
X277 181 44 133 193 98 256 60 OAI22XL $T=2415600 50400 0 0 $X=2411300 $Y=46400
X278 181 102 133 193 45 255 60 OAI22XL $T=2475000 151200 1 180 $X=2431100 $Y=147200
X279 181 103 133 47 185 196 60 OAI22XL $T=2468400 252000 1 0 $X=2464100 $Y=196200
X280 181 45 133 185 102 258 60 OAI22XL $T=2521200 151200 1 180 $X=2477300 $Y=147200
X281 103 185 133 47 181 351 60 OAI22XL $T=2521200 252000 1 0 $X=2516900 $Y=196200
X282 194 133 182 189 60 181 88 OAI22X2 $T=1980000 151200 1 0 $X=1975700 $Y=95400
X283 239 133 181 30 60 182 90 OAI22X2 $T=1980000 151200 0 0 $X=1975700 $Y=147200
X284 194 133 191 228 60 181 20 OAI22X2 $T=2105400 151200 0 180 $X=2041700 $Y=95400
X285 194 133 187 233 60 181 144 OAI22X2 $T=2145000 151200 1 180 $X=2081300 $Y=147200
X286 30 133 191 238 60 181 25 OAI22X2 $T=2191200 151200 0 180 $X=2127500 $Y=95400
X287 242 133 181 243 60 193 93 OAI22X2 $T=2151600 50400 1 0 $X=2147300 $Y=-5400
X288 23 133 181 33 60 249 95 OAI22X2 $T=2250600 50400 1 0 $X=2246300 $Y=-5400
X289 6 133 181 176 60 249 96 OAI22X2 $T=2250600 151200 1 0 $X=2246300 $Y=95400
X290 280 133 283 363 60 279 205 OAI22X2 $T=2897400 352800 0 180 $X=2833700 $Y=297000
.ENDS
***************************************
.SUBCKT sar_digi_paper_core clk w_wr_data[20] w_wr_data[23] w_wr_data[2] w_wr_data[19] w_wr_data[22] w_wr_data[28] w_wr_data[17] w_wr_data[26] w_wr_data[25] w_wr_data[29] w_wr_data[24] w_wr_data[27] w_wr_data[21] w_wr_addr[2] w_wr_data[18] w_wr_addr[3] w_wr_addr[4] w_wr_en raw_code_valid_o
+ raw_code_o[0] raw_code_o[3] raw_code_o[1] calib_overrange dac_n_force[0] dac_n_force[1] dac_n_force[2] raw_code_o[6] raw_code_o[9] dac_n_force[3] raw_code_o[10] raw_code_o[2] raw_code_o[7] raw_code_o[13] raw_code_o[4] raw_code_o[11] raw_code_o[8] raw_code_o[12] raw_code_o[14] raw_code_o[15]
+ raw_code_o[5] raw_code_o[17] raw_code_o[16] raw_code_o[19] VDD w_wr_data[0] w_wr_addr[0] calib_overrange_bits[16] calib_overrange_bits[18] calib_overrange_bits[14] calib_overrange_bits[17] calib_overrange_bits[15] calib_overrange_bits[19] calib_overrange_bits[13] srm_decision_bit srm_start calib_overrange_bits[7] srm_decision_valid calib_overrange_bits[12] calib_overrange_bits[11]
+ calib_overrange_bits[10] calib_overrange_bits[9] calib_overrange_bits[8] srm_residue_valid srm_ones_count[4] srm_busy srm_done residue_consume_i calib_overrange_bits[2] calib_overrange_bits[4] calib_overrange_bits[3] calib_overrange_bits[5] calib_overrange_bits[6] srm_total_count[3] srm_ones_count[0] srm_ones_count[1] srm_total_count[4] srm_ones_count[2] srm_ones_count[3] srm_stalled
+ srm_count_shortfall raw_bits_i[3] start_calib calib_mode_en w_wr_data[9] w_wr_data[10] w_wr_data[11] w_wr_data[12] w_wr_data[13] w_wr_data[14] w_wr_data[3] w_wr_data[4] w_wr_data[5] w_wr_data[6] w_wr_data[7] w_wr_data[8] w_wr_data[1] raw_bits_i[17] raw_bits_i[18] raw_bits_i[19]
+ data_valid_i calib_overrange_bits[0] calib_overrange_bits[1] srm_total_count[0] srm_total_count[1] srm_total_count[2] raw_bits_i[12] raw_bits_i[13] raw_bits_i[14] raw_bits_i[15] raw_bits_i[16] srm_residue_o[4] srm_residue_o[5] srm_residue_o[6] srm_residue_o[7] srm_residue_o[8] srm_residue_o[9] raw_bits_i[6] raw_bits_i[7] raw_bits_i[8]
+ raw_bits_i[9] raw_bits_i[10] raw_bits_i[11] srm_residue_o[0] srm_residue_o[1] srm_residue_o[2] srm_residue_o[3] raw_bits_i[2] raw_bits_i[4] raw_bits_i[5] w_wr_data[15] VSS w_wr_data[16] w_wr_addr[1] raw_code_o[18] raw_bits_i[0] raw_bits_i[1] calib_done dac_n_force[4] dac_n_force[5]
+ dac_n_force[6] dac_n_force[7] dac_n_force[8] dac_n_force[9] dac_n_force[10] dac_n_force[11] dac_n_force[12] dac_n_force[13] dac_n_force[14] dac_n_force[15] dac_n_force[16] dac_n_force[17] dac_n_force[18] dac_n_force[19] dac_p_force[0] dac_p_force[1] dac_p_force[2] dac_p_force[3] dac_p_force[4] dac_p_force[5]
+ dac_p_force[6] dac_p_force[7] dac_p_force[8] dac_p_force[9] dac_p_force[10] dac_p_force[11] dac_p_force[12] dac_p_force[13] dac_p_force[14] dac_p_force[15] dac_p_force[16] dac_p_force[17] dac_p_force[18] dac_p_force[19] calib_done_pulse calib_comp_out rst_n dec_clk
** N=1055 EP=178 IP=2675 FDC=50686
X0 1 6 11 19 4 5 7 8 9 13 10 12 3 32 14 171 15 16 17 18
+ 20 21 156 22 23 24 25 26 27 28 29 30 31 33 34 35 48 36 494 37
+ 495 38 343 195 41 w_wr_data[2] 44 46 47 49 52 55 56 58 VDD 78 91 59 62 66
+ 89 63 70 68 71 72 73 75 258 76 77 79 80 81 82 84 83 86 87 88
+ 90 606 92 93 94 95 97 100 101 103 104 114 617 613 105 106 107 108 109 115
+ 110 111 113 116 120 121 204 207 123 125 127 627 129 136 137 139 638 143 w_wr_data[9] w_wr_data[10]
+ w_wr_data[11] w_wr_data[12] w_wr_data[13] w_wr_data[14] w_wr_data[15] 575 w_wr_data[8] 578 247 593 588 586 594 589 496 598 592 602 262 497
+ 498 604 603 610 609 612 582 618 499 631 629 VSS 630 403 634 637 raw_bits_i[0] 641 w_wr_data[16] 573
+ 574 576 577 579 580 581 172 583 584 585 587 590 591 596 597 506 189 599 600 601
+ 276 605 507 607 608 611 614 615 616 619 620 621 622 623 624 625 626 628 632 213
+ 214 633 635 636 639 409 642 raw_bits_i[1] 645
+ ICV_2 $T=0 0 0 0 $X=-4300 $Y=3623400
X1 1 w_wr_data[7] w_wr_data[3] 59 169 687 91 147 163 37 148 158 149 VDD 151 5 152 153 154 155
+ 7 156 157 8 574 164 159 160 12 161 13 162 343 46 165 166 167 168 17 16
+ 80 170 3 35 19 20 171 21 173 174 22 23 25 26 175 27 176 28 177 29
+ 178 583 30 179 31 180 32 181 33 34 56 585 182 38 w_wr_data[0] 184 w_wr_data[19] 63 44 48
+ 185 w_wr_data[22] 49 52 w_wr_data[25] 55 w_wr_data[29] 58 70 195 w_wr_addr[2] 66 w_wr_data[18] 187 496 68 72 188 73 75
+ 76 77 258 190 78 191 79 192 81 193 83 194 262 84 86 196 87 197 198 88
+ 89 92 90 606 507 93 94 95 199 200 97 100 101 103 104 115 105 106 107 109
+ 110 690 691 113 201 114 116 620 120 204 207 624 121 206 403 123 209 626 711 125
+ 211 127 212 136 137 216 143 139 217 218 w_wr_data[4] w_wr_data[5] w_wr_data[6] 231 575 647 648 650 651 652
+ 573 655 587 660 599 577 579 666 580 584 581 665 247 668 592 590 613 672 679 673
+ 675 596 676 600 678 506 601 684 605 603 694 602 689 276 686 498 688 607 609 608
+ 692 615 696 697 616 698 619 701 699 700 702 621 622 625 703 708 713 629 630 300
+ 712 710 717 304 632 709 636 634 714 715 723 409 639 718 306 641 722 642 721 719
+ 724 729 727 646 VSS 649 653 654 656 657 658 576 659 661 578 662 663 664 582 667
+ 494 586 495 588 589 591 593 669 594 670 671 674 677 597 598 680 682 683 681 497
+ 685 604 693 610 611 695 612 614 617 618 499 623 704 705 706 707 627 628 631 716
+ 635 637 305 638 720 725 726 645 728 730
+ ICV_3 $T=0 0 0 0 $X=-4300 $Y=3070400
X2 188 36 163 47 207 49 89 91 147 7 37 220 148 20 149 221 VDD 648 151 222
+ 158 1 78 5 223 649 224 152 56 6 225 156 157 226 168 231 227 159 228 229
+ 160 230 232 87 14 233 234 164 235 166 167 236 169 170 34 171 237 18 3 33
+ 172 46 24 238 13 175 177 178 179 32 239 241 242 w_wr_data[20] w_wr_data[23] 41 63 243 185 244
+ 48 245 w_wr_data[28] w_wr_data[17] 246 w_wr_data[26] 247 251 w_wr_addr[0] 248 w_wr_data[24] 249 w_wr_data[21] 250 252 187 253 254 w_wr_addr[3] 80
+ 70 255 66 256 w_wr_addr[4] 257 258 190 191 259 260 261 77 193 262 263 82 79 264 265
+ 194 266 84 267 200 196 268 197 269 270 198 271 272 273 88 274 92 86 275 761
+ 276 277 279 278 287 350 280 281 282 693 283 512 107 284 285 697 286 103 201 115
+ 772 288 204 290 120 291 292 293 206 294 295 209 296 297 403 211 298 212 299 300
+ 129 216 213 214 302 303 304 143 217 306 308 409 218 313 728 w_wr_data[1] 647 575 17 732
+ 653 654 658 659 657 735 374 736 661 663 682 739 667 28 742 743 411 35 749 669
+ 670 671 w_wr_addr[1] 520 672 384 674 73 510 685 683 679 681 684 509 688 754 762 755 346
+ 759 690 686 511 689 348 694 766 695 698 767 699 507 771 700 702 704 706 705 707
+ 782 711 721 715 719 720 783 633 717 716 786 790 725 726 791 792 795 377 513 646
+ VSS 731 515 733 650 651 652 734 655 656 343 660 662 737 738 15 664 665 740 666
+ 741 344 744 745 668 746 747 748 750 673 675 676 677 678 751 752 680 753 756 757
+ 758 687 760 763 95 691 764 692 765 353 696 768 769 770 620 701 773 774 775 776
+ 703 777 778 779 708 780 781 709 710 712 713 714 784 785 718 787 788 722 723 724
+ 789 727 793 794 729 730
+ ICV_4 $T=0 0 0 0 $X=-4300 $Y=2514600
X3 5 89 7 220 374 221 315 238 316 222 376 1 317 318 515 223 224 319 324 56
+ 153 154 155 80 91 225 156 226 10 227 320 229 321 231 322 323 158 325 163 233
+ 328 234 329 33 236 168 87 34 336 330 149 164 174 331 173 332 334 335 176 181
+ 811 337 812 32 338 241 257 520 46 3 170 339 171 243 244 806 245 13 341 21
+ 185 w_wr_data[27] 251 342 70 66 256 343 268 79 261 345 346 88 509 265 195 w_wr_en 196 347
+ 270 47 348 272 273 86 349 90 276 200 350 279 352 VDD 282 raw_code_o[0] 351 283 353 284
+ 285 354 832 216 356 286 287 103 115 357 826 288 358 204 359 120 290 291 292 293
+ 360 207 361 294 362 777 300 778 298 295 363 296 297 403 365 304 143 313 159 17
+ 575 513 377 796 370 797 731 514 732 739 733 63 802 647 804 738 510 648 749 807
+ 808 803 809 741 740 745 744 766 748 28 747 818 750 752 821 822 754 771 757 813
+ 191 758 763 399 760 511 827 764 829 516 831 833 768 769 835 772 837 773 774 775
+ 847 517 841 779 845 838 783 711 781 842 213 782 214 844 851 785 849 850 786 787
+ 788 409 784 853 854 789 790 794 VSS 798 799 800 801 735 736 805 737 810 742 743
+ 518 814 746 815 519 816 817 384 819 820 751 753 755 756 823 824 411 759 825 762
+ 828 765 830 767 834 770 836 839 776 840 780 211 843 846 848 852 791 855 792 793
+ 795
+ ICV_5 $T=0 0 0 0 $X=-4300 $Y=2010600
X4 230 3 377 49 7 321 37 315 316 370 VDD 1 78 317 4 318 238 372 373 374
+ 319 376 270 80 9 375 158 11 228 320 243 161 378 803 379 324 325 163 233 328
+ 5 189 257 168 231 330 237 382 332 383 164 336 384 385 868 331 647 334 335 180
+ 337 386 338 239 156 32 387 341 46 388 166 390 244 391 170 171 13 392 246 393
+ 411 21 185 249 252 28 342 394 512 520 71 66 343 70 268 259 344 79 345 346
+ 191 262 196 395 758 200 269 347 271 47 348 86 274 88 103 276 825 397 398 277
+ 400 278 350 287 401 280 402 403 raw_code_valid_o 352 404 351 405 353 raw_code_o[1] 216 108 298 354 892
+ 356 407 calib_overrange_bits[16] 357 120 204 408 115 calib_overrange_bits[18] 358 359 207 calib_overrange_bits[17] 360 361 409 365 362 300 363
+ 299 898 raw_code_o[14] raw_code_o[15] 305 raw_code_o[5] raw_code_o[17] 410 raw_code_o[19] calib_overrange_bits[9] calib_overrange_bits[8] 575 63 513 749 56 17 799 192 91
+ 510 801 859 518 804 861 863 812 415 806 648 805 807 866 867 870 813 810 815 820
+ 519 516 831 819 754 823 884 827 824 clk VSS 835 887 889 830 893 894 832 896 897
+ 836 837 839 901 844 850 840 838 902 783 906 904 843 905 846 847 304 908 517 848
+ 711 910 852 raw_bits_i[18] raw_bits_i[17] 855 raw_bits_i[19] data_valid_i 796 797 530 798 514 856 857 734 800 802 858 862
+ 860 864 865 222 869 808 809 811 871 872 873 874 875 814 876 816 877 878 817 818
+ 879 880 881 821 882 267 883 822 885 826 761 532 886 888 828 890 891 829 895 435
+ 111 533 833 834 899 900 841 903 842 845 907 909 849 raw_code_o[18] 851 853 911 854
+ ICV_6 $T=0 0 0 0 $X=-4300 $Y=1457600
X5 clk 375 srm_total_count[1] 235 srm_total_count[2] 890 298 raw_code_o[6] raw_code_o[2] 20 321 370 372 373 856 238 319 376 374 162
+ 377 378 379 335 324 5 257 165 329 411 87 415 382 163 383 859 149 164 384 385
+ 34 386 242 520 156 387 341 182 812 339 388 184 390 244 391 171 13 392 247 393
+ 248 413 347 336 62 414 185 416 417 394 28 300 253 418 254 419 103 255 73 323
+ 343 420 258 421 232 268 346 754 422 77 883 191 758 263 196 423 424 395 266 929
+ 260 425 426 427 428 429 931 430 431 275 432 433 349 434 435 397 436 437 398 399
+ 439 400 278 440 277 441 250 902 401 888 405 402 442 281 407 443 549 404 287 944
+ srm_ones_count[3] 898 947 895 calib_overrange srm_done 216 calib_overrange_bits[7] 120 408 calib_overrange_bits[14] 409 srm_busy raw_code_o[9] calib_overrange_bits[15] calib_overrange_bits[2] raw_code_o[10] raw_code_o[7] raw_code_o[13] raw_code_o[4]
+ raw_code_o[11] 410 raw_code_o[8] 302 303 444 raw_code_o[12] calib_overrange_bits[4] raw_code_o[16] 306 raw_bits_i[3] calib_overrange_bits[12] calib_overrange_bits[11] calib_overrange_bits[13] calib_overrange_bits[10] calib_overrange_bits[3] calib_overrange_bits[5] calib_overrange_bits[6] 530 49
+ 37 318 510 VDD 243 858 860 864 862 912 867 881 332 868 869 914 168 872 916 875
+ 917 873 807 874 920 876 880 21 879 892 264 882 925 935 927 928 207 885 531 532
+ 936 886 938 889 939 891 940 942 897 941 950 945 946 896 calib_overrange_bits[1] calib_overrange_bits[0] 899 487 952 953
+ 901 533 956 957 964 963 907 909 911 raw_bits_i[4] raw_bits_i[13] raw_bits_i[15] raw_bits_i[12] raw_bits_i[14] raw_bits_i[16] VSS 7 857 861 863
+ 865 866 913 870 871 915 918 919 546 877 878 921 451 922 464 452 322 923 924 884
+ 926 930 932 933 934 887 937 271 943 893 894 948 949 951 470 calib_overrange_bits[17] 900 954 955 903
+ 904 905 906 958 959 960 raw_code_o[3] 552 961 908 962 910 raw_bits_i[10] raw_bits_i[11] raw_bits_i[5]
+ ICV_7 $T=0 0 0 0 $X=-4300 $Y=953600
X6 srm_residue_o[9] srm_residue_valid srm_ones_count[4] srm_ones_count[0] srm_ones_count[1] srm_stalled srm_total_count[4] srm_residue_o[4] srm_residue_o[7] 324 411 156 966 546 413 srm_total_count[3] 414 415 446 447
+ 416 968 417 448 449 300 347 450 418 419 922 420 421 453 268 972 422 454 455 423
+ 424 456 457 458 442 975 463 459 VDD 460 461 462 464 srm_residue_o[8] 466 426 465 467 468 469
+ 981 470 427 471 440 428 472 531 429 473 439 474 430 431 475 432 476 943 srm_ones_count[2] srm_residue_o[6]
+ 433 477 434 435 436 437 478 srm_count_shortfall 932 399 441 939 405 start_calib 407 443 403 199 994 480
+ 481 949 residue_consume_i 204 482 487 srm_start 952 calib_mode_en 444 calib_overrange_bits[19] 484 485 554 1010 1013 486 raw_bits_i[6] srm_residue_o[5] 917
+ 919 545 967 547 926 976 925 928 548 978 979 930 549 947 980 931 944 983 934 933
+ 550 985 988 986 946 987 942 995 940 990 941 991 992 895 945 551 998 948 996 951
+ 1000 1001 srm_busy 954 955 956 552 1012 958 1008 1009 553 961 962 1011 1014 960 raw_bits_i[7] raw_bits_i[8] 1015
+ raw_bits_i[9] VSS 912 913 384 914 867 915 868 916 965 918 920 376 921 969 970 971 973 923
+ 346 974 924 565 977 927 929 982 935 984 936 937 938 989 993 997 950 999 srm_total_count[0] 1002
+ 1003 901 1004 953 1005 calib_done 957 1007 959 566 963 964 raw_bits_i[2]
+ ICV_8 $T=0 0 0 0 $X=-4300 $Y=397800
X7 clk srm_residue_o[0] dac_n_force[18] srm_residue_o[1] 458 965 455 srm_decision_bit 414 446 447 416 448 449 450 419 451 452 453 dac_p_force[4]
+ 454 456 457 442 dac_p_force[6] 459 460 461 462 982 463 464 465 466 467 980 468 469 470 471
+ 472 473 474 475 476 477 478 1004 480 481 999 997 dac_n_force[0] dac_n_force[1] dac_n_force[2] 482 dac_n_force[3] VDD 484 485
+ srm_decision_valid dec_clk 486 487 srm_residue_o[2] srm_residue_o[3] dac_n_force[5] dac_n_force[6] dac_n_force[7] dac_n_force[8] dac_n_force[9] dac_n_force[11] dac_n_force[12] dac_n_force[13] dac_n_force[14] dac_n_force[15] dac_n_force[16] dac_n_force[17] dac_n_force[19] 917
+ dac_p_force[0] 966 972 968 dac_p_force[1] 547 dac_p_force[3] 974 565 dac_p_force[7] 549 dac_p_force[10] dac_p_force[8] 943 981 983 dac_p_force[9] dac_p_force[11] 403 946
+ 984 dac_p_force[12] 993 dac_p_force[15] dac_p_force[13] 996 dac_p_force[14] dac_p_force[18] 988 dac_p_force[17] dac_p_force[19] 1000 1001 1002 551 1003 calib_comp_out 300 calib_done_pulse 1007
+ 553 566 1012 1011 dac_n_force[4] VSS dac_n_force[10] 545 417 967 dac_p_force[2] 969 970 971 973 420 dac_p_force[5] 975 976 548
+ 977 978 979 439 550 989 985 986 987 990 dac_p_force[16] 991 992 994 995 998 1005 425 1008 1009
+ 554 1010 1013 rst_n 1014 1015
+ ICV_9 $T=0 0 0 0 $X=-4300 $Y=-5400
.ENDS
***************************************
