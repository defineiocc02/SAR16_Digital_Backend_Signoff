* SPICE NETLIST
***************************************

.SUBCKT nmvt18_ckt D G S B
.ENDS
***************************************
.SUBCKT nmvt33_ckt D G S B
.ENDS
***************************************
.SUBCKT pmvt18_ckt D G S B
.ENDS
***************************************
.SUBCKT nnt18_ckt D G S B
.ENDS
***************************************
.SUBCKT nnt33_ckt D G S B
.ENDS
***************************************
.SUBCKT n18_ckt D G S B
.ENDS
***************************************
.SUBCKT n18_dnw_ckt D G S B T B2
.ENDS
***************************************
.SUBCKT n18_dnw_4t_ckt D G S B
.ENDS
***************************************
.SUBCKT p18_ckt D G S B
.ENDS
***************************************
.SUBCKT p18_dnw_ckt D G S B B2
.ENDS
***************************************
.SUBCKT p18_dnw_4t_ckt D G S B
.ENDS
***************************************
.SUBCKT n33_ckt D G S B
.ENDS
***************************************
.SUBCKT n33_dnw_ckt D G S B T B2
.ENDS
***************************************
.SUBCKT n33_dnw_4t_ckt D G S B
.ENDS
***************************************
.SUBCKT p33_ckt D G S B
.ENDS
***************************************
.SUBCKT p33_dnw_ckt D G S B B2
.ENDS
***************************************
.SUBCKT p33_dnw_4t_ckt D G S B
.ENDS
***************************************
.SUBCKT pvar18_ckt PLUS MINUS
.ENDS
***************************************
.SUBCKT pvar33_ckt PLUS MINUS
.ENDS
***************************************
.SUBCKT pnp18a4_mis_ckt C B E
.ENDS
***************************************
.SUBCKT pnp18a25_mis_ckt C B E
.ENDS
***************************************
.SUBCKT pnp18a100_mis_ckt C B E
.ENDS
***************************************
.SUBCKT pnp33a4_mis_ckt C B E
.ENDS
***************************************
.SUBCKT pnp33a25_mis_ckt C B E
.ENDS
***************************************
.SUBCKT pnp33a100_mis_ckt C B E
.ENDS
***************************************
.SUBCKT npn18a4_mis_ckt C B E SUB
.ENDS
***************************************
.SUBCKT npn18a25_mis_ckt C B E SUB
.ENDS
***************************************
.SUBCKT npn18a100_mis_ckt C B E SUB
.ENDS
***************************************
.SUBCKT npn33a4_mis_ckt C B E SUB
.ENDS
***************************************
.SUBCKT npn33a25_mis_ckt C B E SUB
.ENDS
***************************************
.SUBCKT npn33a100_mis_ckt C B E SUB
.ENDS
***************************************
.SUBCKT EFUSE_res PLUS MINUS
.ENDS
***************************************
.SUBCKT rnwaa_ckt PLUS MINUS SUB
.ENDS
***************************************
.SUBCKT rnwsti_ckt PLUS MINUS SUB
.ENDS
***************************************
.SUBCKT rpdif_ckt PLUS MINUS SUB
.ENDS
***************************************
.SUBCKT rndif_ckt PLUS MINUS SUB
.ENDS
***************************************
.SUBCKT rppo_ckt PLUS MINUS
.ENDS
***************************************
.SUBCKT rppo_3t_ckt PLUS MINUS SUB
.ENDS
***************************************
.SUBCKT rnpo_ckt PLUS MINUS
.ENDS
***************************************
.SUBCKT rnpo_3t_ckt PLUS MINUS SUB
.ENDS
***************************************
.SUBCKT rpdifsab_ckt PLUS MINUS SUB
.ENDS
***************************************
.SUBCKT rndifsab_ckt PLUS MINUS SUB
.ENDS
***************************************
.SUBCKT rpposab_ckt PLUS MINUS
.ENDS
***************************************
.SUBCKT rpposab_3t_ckt PLUS MINUS SUB
.ENDS
***************************************
.SUBCKT rnposab_ckt PLUS MINUS
.ENDS
***************************************
.SUBCKT rnposab_3t_ckt PLUS MINUS SUB
.ENDS
***************************************
.SUBCKT rhrpo_ckt PLUS MINUS
.ENDS
***************************************
.SUBCKT rhrpo_3t_ckt PLUS MINUS SUB
.ENDS
***************************************
.SUBCKT mim_ckt PLUS MINUS
.ENDS
***************************************
.SUBCKT INVXL A VDD VSS Y
** N=4 EP=4 IP=0 FDC=2
M0 Y A VSS VSS n18 L=1.8e-07 W=4.2e-07 $X=4600 $Y=13100 $D=6
M1 Y A VDD VDD p18 L=1.8e-07 W=6.4e-07 $X=4600 $Y=27350 $D=10
.ENDS
***************************************
.SUBCKT OAI21XL A1 VSS A0 B0 VDD Y
** N=8 EP=6 IP=0 FDC=6
M0 VSS A1 7 VSS n18 L=1.8e-07 W=5.6e-07 $X=6200 $Y=12050 $D=6
M1 7 A0 VSS VSS n18 L=1.8e-07 W=5.6e-07 $X=12200 $Y=12800 $D=6
M2 Y B0 7 VSS n18 L=1.8e-07 W=4.9e-07 $X=19400 $Y=13500 $D=6
M3 8 A1 VDD VDD p18 L=1.8e-07 W=8.4e-07 $X=6200 $Y=33000 $D=10
M4 Y A0 8 VDD p18 L=1.8e-07 W=8.4e-07 $X=11800 $Y=33000 $D=10
M5 VDD B0 Y VDD p18 L=1.8e-07 W=6.4e-07 $X=19000 $Y=33000 $D=10
.ENDS
***************************************
.SUBCKT CLKBUFXL A VSS VDD Y
** N=5 EP=4 IP=0 FDC=4
M0 VSS A 5 VSS n18 L=1.8e-07 W=3e-07 $X=6600 $Y=11900 $D=6
M1 Y 5 VSS VSS n18 L=1.8e-07 W=3e-07 $X=12600 $Y=11900 $D=6
M2 VDD A 5 VDD p18 L=1.8e-07 W=3e-07 $X=6600 $Y=27800 $D=10
M3 Y 5 VDD VDD p18 L=1.8e-07 W=1e-06 $X=12600 $Y=27200 $D=10
.ENDS
***************************************
.SUBCKT NAND2XL B VSS VDD A Y
** N=6 EP=5 IP=0 FDC=4
M0 6 B VSS VSS n18 L=1.8e-07 W=5.6e-07 $X=6200 $Y=11200 $D=6
M1 Y A 6 VSS n18 L=1.8e-07 W=5.6e-07 $X=11800 $Y=11200 $D=6
M2 Y B VDD VDD p18 L=1.8e-07 W=6.4e-07 $X=5500 $Y=29750 $D=10
M3 VDD A Y VDD p18 L=1.8e-07 W=6.4e-07 $X=12700 $Y=29750 $D=10
.ENDS
***************************************
.SUBCKT XOR2XL B A VSS VDD Y
** N=9 EP=5 IP=0 FDC=12
M0 VSS A 6 VSS n18 L=1.8e-07 W=3e-07 $X=7150 $Y=10800 $D=6
M1 8 B VSS VSS n18 L=1.8e-07 W=3e-07 $X=13650 $Y=10800 $D=6
M2 9 6 8 VSS n18 L=1.8e-07 W=5.6e-07 $X=23900 $Y=10800 $D=6
M3 7 A 9 VSS n18 L=1.8e-07 W=5.6e-07 $X=31200 $Y=10800 $D=6
M4 VSS 8 7 VSS n18 L=1.8e-07 W=3e-07 $X=38800 $Y=12500 $D=6
M5 Y 9 VSS VSS n18 L=1.8e-07 W=4.6e-07 $X=44800 $Y=10900 $D=6
M6 VDD A 6 VDD p18 L=1.8e-07 W=4.2e-07 $X=6200 $Y=33600 $D=10
M7 8 B VDD VDD p18 L=1.8e-07 W=4.6e-07 $X=12900 $Y=33600 $D=10
M8 9 A 8 VDD p18 L=1.8e-07 W=8.4e-07 $X=23900 $Y=28300 $D=10
M9 7 6 9 VDD p18 L=1.8e-07 W=8.4e-07 $X=31200 $Y=28300 $D=10
M10 VDD 8 7 VDD p18 L=1.8e-07 W=4.6e-07 $X=38800 $Y=29600 $D=10
M11 Y 9 VDD VDD p18 L=1.8e-07 W=6.4e-07 $X=44800 $Y=29600 $D=10
.ENDS
***************************************
.SUBCKT DFFSXL CK D 3 SN 5 QN VSS Q VDD
** N=24 EP=9 IP=0 FDC=34
M0 VSS CK 12 VSS n18 L=1.8e-07 W=3e-07 $X=6700 $Y=12100 $D=6
M1 15 D VSS VSS n18 L=1.8e-07 W=5.6e-07 $X=16750 $Y=7100 $D=6
M2 3 12 15 VSS n18 L=1.8e-07 W=5.6e-07 $X=22350 $Y=7100 $D=6
M3 16 11 3 VSS n18 L=1.8e-07 W=3e-07 $X=29100 $Y=15100 $D=6
M4 VSS 10 16 VSS n18 L=1.8e-07 W=3e-07 $X=34700 $Y=15100 $D=6
M5 17 SN VSS VSS n18 L=1.8e-07 W=3.6e-07 $X=40800 $Y=14800 $D=6
M6 10 3 17 VSS n18 L=1.8e-07 W=3.6e-07 $X=46400 $Y=14800 $D=6
M7 VSS 12 11 VSS n18 L=1.8e-07 W=3e-07 $X=55600 $Y=7000 $D=6
M8 18 10 VSS VSS n18 L=1.8e-07 W=5.6e-07 $X=61600 $Y=14000 $D=6
M9 13 11 18 VSS n18 L=1.8e-07 W=5.6e-07 $X=67200 $Y=14000 $D=6
M10 19 12 13 VSS n18 L=1.8e-07 W=3e-07 $X=73200 $Y=7800 $D=6
M11 VSS 5 19 VSS n18 L=1.8e-07 W=3e-07 $X=79000 $Y=7800 $D=6
M12 20 13 5 VSS n18 L=1.8e-07 W=3.6e-07 $X=90000 $Y=13600 $D=6
M13 VSS SN 20 VSS n18 L=1.8e-07 W=3.6e-07 $X=95600 $Y=13600 $D=6
M14 QN 5 VSS VSS n18 L=1.8e-07 W=4.2e-07 $X=103250 $Y=7150 $D=6
M15 14 5 VSS VSS n18 L=1.8e-07 W=3e-07 $X=103250 $Y=14900 $D=6
M16 Q 14 VSS VSS n18 L=1.8e-07 W=4.2e-07 $X=116250 $Y=12100 $D=6
M17 VDD CK 12 VDD p18 L=1.8e-07 W=4.2e-07 $X=6400 $Y=31800 $D=10
M18 21 D VDD VDD p18 L=1.8e-07 W=8.4e-07 $X=14200 $Y=27600 $D=10
M19 3 11 21 VDD p18 L=1.8e-07 W=8.4e-07 $X=19800 $Y=27600 $D=10
M20 22 12 3 VDD p18 L=1.8e-07 W=4.2e-07 $X=27400 $Y=31600 $D=10
M21 VDD 10 22 VDD p18 L=1.8e-07 W=4.2e-07 $X=33000 $Y=31600 $D=10
M22 10 SN VDD VDD p18 L=1.8e-07 W=4.2e-07 $X=39000 $Y=31600 $D=10
M23 VDD 3 10 VDD p18 L=1.8e-07 W=4.2e-07 $X=47000 $Y=30600 $D=10
M24 11 12 VDD VDD p18 L=1.8e-07 W=4.2e-07 $X=53000 $Y=30600 $D=10
M25 23 10 VDD VDD p18 L=1.8e-07 W=8.4e-07 $X=65600 $Y=29400 $D=10
M26 13 12 23 VDD p18 L=1.8e-07 W=8.4e-07 $X=71200 $Y=29400 $D=10
M27 24 11 13 VDD p18 L=1.8e-07 W=3e-07 $X=78800 $Y=33700 $D=10
M28 VDD 5 24 VDD p18 L=1.8e-07 W=3e-07 $X=84400 $Y=33700 $D=10
M29 5 13 VDD VDD p18 L=1.8e-07 W=4.2e-07 $X=90400 $Y=31300 $D=10
M30 VDD SN 5 VDD p18 L=1.8e-07 W=4.2e-07 $X=97600 $Y=31300 $D=10
M31 14 5 VDD VDD p18 L=1.8e-07 W=4.2e-07 $X=104800 $Y=31300 $D=10
M32 QN 5 VDD VDD p18 L=1.8e-07 W=6.4e-07 $X=104800 $Y=38300 $D=10
M33 Q 14 VDD VDD p18 L=1.8e-07 W=6.4e-07 $X=117400 $Y=29400 $D=10
.ENDS
***************************************
.SUBCKT INVX2 A VSS Y VDD
** N=4 EP=4 IP=0 FDC=3
M0 Y A VSS VSS n18 L=1.8e-07 W=1.2e-06 $X=11000 $Y=5750 $D=6
M1 Y A VDD VDD p18 L=1.8e-07 W=9e-07 $X=4600 $Y=27300 $D=10
M2 VDD A Y VDD p18 L=1.8e-07 W=9e-07 $X=11800 $Y=27300 $D=10
.ENDS
***************************************
.SUBCKT AOI21XL A1 A0 VDD B0 5 VSS Y
** N=8 EP=7 IP=0 FDC=6
M0 8 A1 VSS VSS n18 L=1.8e-07 W=5.6e-07 $X=6200 $Y=10050 $D=6
M1 Y A0 8 VSS n18 L=1.8e-07 W=5.6e-07 $X=11800 $Y=10050 $D=6
M2 VSS B0 Y VSS n18 L=1.8e-07 W=4.2e-07 $X=19000 $Y=11450 $D=6
M3 VDD A1 5 VDD p18 L=1.8e-07 W=8.4e-07 $X=6200 $Y=28950 $D=10
M4 5 A0 VDD VDD p18 L=1.8e-07 W=8.4e-07 $X=12200 $Y=28950 $D=10
M5 Y B0 5 VDD p18 L=1.8e-07 W=8.4e-07 $X=18200 $Y=28950 $D=10
.ENDS
***************************************
.SUBCKT NAND2BXL AN VSS B 4 VDD Y
** N=7 EP=6 IP=0 FDC=6
M0 VSS AN 4 VSS n18 L=1.8e-07 W=3e-07 $X=6600 $Y=11550 $D=6
M1 7 B VSS VSS n18 L=1.8e-07 W=5.6e-07 $X=12600 $Y=8950 $D=6
M2 Y 4 7 VSS n18 L=1.8e-07 W=5.6e-07 $X=18200 $Y=8950 $D=6
M3 VDD AN 4 VDD p18 L=1.8e-07 W=4.2e-07 $X=6200 $Y=30700 $D=10
M4 Y B VDD VDD p18 L=1.8e-07 W=6.4e-07 $X=12200 $Y=30700 $D=10
M5 VDD 4 Y VDD p18 L=1.8e-07 W=6.4e-07 $X=19400 $Y=30700 $D=10
.ENDS
***************************************
.SUBCKT NOR2XL VDD B A Y VSS
** N=6 EP=5 IP=0 FDC=4
M0 Y B VSS VSS n18 L=1.8e-07 W=4e-07 $X=5000 $Y=11000 $D=6
M1 VSS A Y VSS n18 L=1.8e-07 W=4e-07 $X=13000 $Y=11000 $D=6
M2 6 B VDD VDD p18 L=1.8e-07 W=8.4e-07 $X=6200 $Y=28100 $D=10
M3 Y A 6 VDD p18 L=1.8e-07 W=8.4e-07 $X=11800 $Y=28100 $D=10
.ENDS
***************************************
.SUBCKT OAI2BB1XL A1N A0N B0 VSS 5 Y VDD
** N=9 EP=7 IP=0 FDC=8
M0 8 A1N 5 VSS n18 L=1.8e-07 W=3.6e-07 $X=6600 $Y=8950 $D=6
M1 VSS A0N 8 VSS n18 L=1.8e-07 W=3.6e-07 $X=12200 $Y=8950 $D=6
M2 9 B0 VSS VSS n18 L=1.8e-07 W=5.6e-07 $X=19400 $Y=12600 $D=6
M3 Y 5 9 VSS n18 L=1.8e-07 W=5.6e-07 $X=25000 $Y=12600 $D=6
M4 5 A1N VDD VDD p18 L=1.8e-07 W=4.2e-07 $X=4600 $Y=31500 $D=10
M5 VDD A0N 5 VDD p18 L=1.8e-07 W=4.2e-07 $X=12600 $Y=31500 $D=10
M6 Y B0 VDD VDD p18 L=1.8e-07 W=6.4e-07 $X=18650 $Y=32150 $D=10
M7 VDD 5 Y VDD p18 L=1.8e-07 W=6.4e-07 $X=25850 $Y=32150 $D=10
.ENDS
***************************************
.SUBCKT XNOR2XL B A VSS VDD Y
** N=9 EP=5 IP=0 FDC=12
M0 VSS A 6 VSS n18 L=1.8e-07 W=3e-07 $X=6600 $Y=10800 $D=6
M1 7 B VSS VSS n18 L=1.8e-07 W=3e-07 $X=13650 $Y=10800 $D=6
M2 9 A 7 VSS n18 L=1.8e-07 W=5.6e-07 $X=23900 $Y=10800 $D=6
M3 8 6 9 VSS n18 L=1.8e-07 W=5.6e-07 $X=31200 $Y=10800 $D=6
M4 VSS 7 8 VSS n18 L=1.8e-07 W=3e-07 $X=38800 $Y=12300 $D=6
M5 Y 9 VSS VSS n18 L=1.8e-07 W=4.2e-07 $X=44800 $Y=11100 $D=6
M6 VDD A 6 VDD p18 L=1.8e-07 W=4.2e-07 $X=6200 $Y=33600 $D=10
M7 7 B VDD VDD p18 L=1.8e-07 W=4.2e-07 $X=12900 $Y=33600 $D=10
M8 9 6 7 VDD p18 L=1.8e-07 W=8.4e-07 $X=23900 $Y=29400 $D=10
M9 8 A 9 VDD p18 L=1.8e-07 W=8.4e-07 $X=31200 $Y=29400 $D=10
M10 VDD 7 8 VDD p18 L=1.8e-07 W=4.2e-07 $X=38800 $Y=29400 $D=10
M11 Y 9 VDD VDD p18 L=1.8e-07 W=6.4e-07 $X=44800 $Y=29400 $D=10
.ENDS
***************************************
.SUBCKT OAI21X1 A1 A0 VSS B0 VDD Y
** N=8 EP=6 IP=0 FDC=6
M0 VSS A1 7 VSS n18 L=1.8e-07 W=8e-07 $X=6200 $Y=7700 $D=6
M1 7 A0 VSS VSS n18 L=1.8e-07 W=8e-07 $X=14200 $Y=7700 $D=6
M2 Y B0 7 VSS n18 L=1.8e-07 W=8e-07 $X=21400 $Y=8950 $D=6
M3 8 A1 VDD VDD p18 L=1.8e-07 W=1.2e-06 $X=6200 $Y=29200 $D=10
M4 Y A0 8 VDD p18 L=1.8e-07 W=1.2e-06 $X=12600 $Y=29200 $D=10
M5 VDD B0 Y VDD p18 L=1.8e-07 W=9e-07 $X=19800 $Y=32200 $D=10
.ENDS
***************************************
.SUBCKT XNOR2X1 B A VSS VDD Y
** N=9 EP=5 IP=0 FDC=12
M0 VSS A 6 VSS n18 L=1.8e-07 W=3e-07 $X=7150 $Y=10800 $D=6
M1 8 B VSS VSS n18 L=1.8e-07 W=1.2e-06 $X=13650 $Y=5700 $D=6
M2 9 A 8 VSS n18 L=1.8e-07 W=4.8e-07 $X=23900 $Y=11550 $D=6
M3 7 6 9 VSS n18 L=1.8e-07 W=4.8e-07 $X=31200 $Y=11550 $D=6
M4 VSS 8 7 VSS n18 L=1.8e-07 W=4.8e-07 $X=38800 $Y=11550 $D=6
M5 Y 9 VSS VSS n18 L=1.8e-07 W=6e-07 $X=44800 $Y=10350 $D=6
M6 VDD A 6 VDD p18 L=1.8e-07 W=4.2e-07 $X=6200 $Y=33600 $D=10
M7 8 B VDD VDD p18 L=1.82173e-07 W=1.67314e-06 $X=12900 $Y=28250 $D=10
M8 9 6 8 VDD p18 L=1.8e-07 W=7.2e-07 $X=23900 $Y=28300 $D=10
M9 7 A 9 VDD p18 L=1.8e-07 W=7.2e-07 $X=31200 $Y=28300 $D=10
M10 VDD 8 7 VDD p18 L=1.8e-07 W=7.2e-07 $X=38800 $Y=27000 $D=10
M11 Y 9 VDD VDD p18 L=1.8e-07 W=9e-07 $X=44800 $Y=28300 $D=10
.ENDS
***************************************
.SUBCKT AOI211XL A1 A0 VDD C0 VSS B0 Y
** N=10 EP=7 IP=0 FDC=8
M0 9 A1 VSS VSS n18 L=1.8e-07 W=5.6e-07 $X=6200 $Y=9150 $D=6
M1 Y A0 9 VSS n18 L=1.8e-07 W=5.6e-07 $X=11800 $Y=9150 $D=6
M2 VSS C0 Y VSS n18 L=1.8e-07 W=4.2e-07 $X=19000 $Y=10550 $D=6
M3 Y B0 VSS VSS n18 L=1.8e-07 W=4.2e-07 $X=25000 $Y=10550 $D=6
M4 VDD A1 8 VDD p18 L=1.8e-07 W=9.8e-07 $X=6200 $Y=28600 $D=10
M5 8 A0 VDD VDD p18 L=1.8e-07 W=9.8e-07 $X=12200 $Y=28600 $D=10
M6 10 C0 8 VDD p18 L=1.8e-07 W=9.8e-07 $X=19400 $Y=28600 $D=10
M7 Y B0 10 VDD p18 L=1.8e-07 W=9.8e-07 $X=25000 $Y=28600 $D=10
.ENDS
***************************************
.SUBCKT OR4XL A B C 4 D VSS VDD Y
** N=11 EP=8 IP=0 FDC=10
M0 4 A VSS VSS n18 L=1.8e-07 W=3e-07 $X=4200 $Y=8900 $D=6
M1 VSS B 4 VSS n18 L=1.8e-07 W=3e-07 $X=11400 $Y=15200 $D=6
M2 4 C VSS VSS n18 L=1.8e-07 W=3e-07 $X=17400 $Y=11400 $D=6
M3 VSS D 4 VSS n18 L=1.8e-07 W=3e-07 $X=25400 $Y=11400 $D=6
M4 Y 4 VSS VSS n18 L=1.8e-07 W=4.2e-07 $X=31400 $Y=10200 $D=6
M5 9 A 4 VDD p18 L=1.8e-07 W=7.6e-07 $X=6800 $Y=32450 $D=10
M6 10 B 9 VDD p18 L=1.8e-07 W=7.6e-07 $X=12400 $Y=32450 $D=10
M7 11 C 10 VDD p18 L=1.8e-07 W=7.6e-07 $X=18000 $Y=32450 $D=10
M8 VDD D 11 VDD p18 L=1.8e-07 W=7.6e-07 $X=23600 $Y=32450 $D=10
M9 Y 4 VDD VDD p18 L=1.8e-07 W=6.4e-07 $X=29600 $Y=32450 $D=10
.ENDS
***************************************
.SUBCKT XOR2X1 B A VSS VDD Y
** N=9 EP=5 IP=0 FDC=12
M0 VSS A 6 VSS n18 L=1.8e-07 W=3e-07 $X=7150 $Y=10800 $D=6
M1 8 B VSS VSS n18 L=1.8e-07 W=1.2e-06 $X=13650 $Y=5700 $D=6
M2 9 6 8 VSS n18 L=1.8e-07 W=4.8e-07 $X=23900 $Y=11400 $D=6
M3 7 A 9 VSS n18 L=1.8e-07 W=4.8e-07 $X=31600 $Y=11400 $D=6
M4 VSS 8 7 VSS n18 L=1.8e-07 W=4.8e-07 $X=38800 $Y=11400 $D=6
M5 Y 9 VSS VSS n18 L=1.8e-07 W=6e-07 $X=44800 $Y=10200 $D=6
M6 VDD A 6 VDD p18 L=1.8e-07 W=4.2e-07 $X=6200 $Y=33600 $D=10
M7 8 B VDD VDD p18 L=1.8e-07 W=1.64e-06 $X=12900 $Y=28300 $D=10
M8 9 A 8 VDD p18 L=1.8e-07 W=7.2e-07 $X=23900 $Y=28300 $D=10
M9 7 6 9 VDD p18 L=1.8e-07 W=7.2e-07 $X=31600 $Y=28300 $D=10
M10 VDD 8 7 VDD p18 L=1.8e-07 W=7.2e-07 $X=38800 $Y=28300 $D=10
M11 Y 9 VDD VDD p18 L=1.8e-07 W=9e-07 $X=44800 $Y=28300 $D=10
.ENDS
***************************************
.SUBCKT ICV_1 1 2 3 4 5 6 7 8 9 10 11 12 13 14 15
*.CALIBRE ICV_CELL 9
** N=16 EP=15 IP=18 FDC=68
X0 1 2 3 4 16 5 6 7 8 DFFSXL $T=0 0 0 0 $X=-4300 $Y=-4000
X1 9 10 11 12 13 14 6 15 8 DFFSXL $T=132000 0 0 0 $X=127700 $Y=-4000
.ENDS
***************************************
.SUBCKT NOR2BX1 AN VDD B Y VSS
** N=7 EP=5 IP=0 FDC=6
M0 VSS AN 6 VSS n18 L=1.8e-07 W=3e-07 $X=6600 $Y=13550 $D=6
M1 Y B VSS VSS n18 L=1.8e-07 W=6e-07 $X=12700 $Y=10550 $D=6
M2 VSS 6 Y VSS n18 L=1.8e-07 W=6e-07 $X=19900 $Y=10550 $D=6
M3 VDD AN 6 VDD p18 L=1.8e-07 W=4.2e-07 $X=6200 $Y=29650 $D=10
M4 7 B VDD VDD p18 L=1.8e-07 W=1.2e-06 $X=12800 $Y=29650 $D=10
M5 Y 6 7 VDD p18 L=1.8e-07 W=1.2e-06 $X=18400 $Y=29650 $D=10
.ENDS
***************************************
.SUBCKT AOI21X1 A1 A0 VDD B0 Y VSS
** N=8 EP=6 IP=0 FDC=6
M0 8 A1 VSS VSS n18 L=1.8e-07 W=8e-07 $X=6200 $Y=8950 $D=6
M1 Y A0 8 VSS n18 L=1.8e-07 W=8e-07 $X=11800 $Y=8950 $D=6
M2 VSS B0 Y VSS n18 L=1.8e-07 W=6e-07 $X=19000 $Y=10950 $D=6
M3 VDD A1 7 VDD p18 L=1.83022e-07 W=1.20314e-06 $X=5400 $Y=33700 $D=10
M4 7 A0 VDD VDD p18 L=1.83022e-07 W=1.20314e-06 $X=11800 $Y=28200 $D=10
M5 Y B0 7 VDD p18 L=1.83022e-07 W=1.20314e-06 $X=18200 $Y=33700 $D=10
.ENDS
***************************************
.SUBCKT OAI2BB1X1 A1N A0N B0 VSS Y VDD
** N=9 EP=6 IP=0 FDC=8
M0 8 A1N 7 VSS n18 L=1.8e-07 W=3.6e-07 $X=6600 $Y=8950 $D=6
M1 VSS A0N 8 VSS n18 L=1.8e-07 W=3.6e-07 $X=12200 $Y=8950 $D=6
M2 9 B0 VSS VSS n18 L=1.8e-07 W=8e-07 $X=19400 $Y=10200 $D=6
M3 Y 7 9 VSS n18 L=1.8e-07 W=8e-07 $X=25000 $Y=10200 $D=6
M4 7 A1N VDD VDD p18 L=1.8e-07 W=4e-07 $X=4600 $Y=31600 $D=10
M5 VDD A0N 7 VDD p18 L=1.8e-07 W=4e-07 $X=12600 $Y=31600 $D=10
M6 Y B0 VDD VDD p18 L=1.8e-07 W=9e-07 $X=18650 $Y=30850 $D=10
M7 VDD 7 Y VDD p18 L=1.8e-07 W=9e-07 $X=25850 $Y=30850 $D=10
.ENDS
***************************************
.SUBCKT AND2XL A B VDD VSS Y
** N=7 EP=5 IP=0 FDC=6
M0 7 A 6 VSS n18 L=1.8e-07 W=3.2e-07 $X=5700 $Y=15050 $D=6
M1 VSS B 7 VSS n18 L=1.8e-07 W=3.2e-07 $X=11300 $Y=15050 $D=6
M2 Y 6 VSS VSS n18 L=1.8e-07 W=4.2e-07 $X=17300 $Y=14050 $D=6
M3 VDD A 6 VDD p18 L=1.8e-07 W=4.2e-07 $X=4200 $Y=39900 $D=10
M4 VDD B 6 VDD p18 L=1.8e-07 W=4.2e-07 $X=9400 $Y=30600 $D=10
M5 Y 6 VDD VDD p18 L=1.8e-07 W=6.4e-07 $X=16500 $Y=30600 $D=10
.ENDS
***************************************
.SUBCKT OR2XL A B VSS VDD Y
** N=7 EP=5 IP=0 FDC=6
M0 6 A VSS VSS n18 L=1.8e-07 W=3e-07 $X=4100 $Y=10450 $D=6
M1 VSS B 6 VSS n18 L=1.8e-07 W=3e-07 $X=12100 $Y=15100 $D=6
M2 Y 6 VSS VSS n18 L=1.8e-07 W=4.2e-07 $X=18100 $Y=13900 $D=6
M3 7 A 6 VDD p18 L=1.8e-07 W=5.6e-07 $X=6400 $Y=33600 $D=10
M4 VDD B 7 VDD p18 L=1.8e-07 W=5.6e-07 $X=12000 $Y=33600 $D=10
M5 Y 6 VDD VDD p18 L=1.8e-07 W=6.4e-07 $X=18000 $Y=31500 $D=10
.ENDS
***************************************
.SUBCKT DFFSX1 CK D 3 SN QN VSS Q VDD
** N=24 EP=8 IP=0 FDC=34
M0 VSS CK 11 VSS n18 L=1.8e-07 W=4e-07 $X=6700 $Y=11600 $D=6
M1 15 D VSS VSS n18 L=1.8e-07 W=3e-07 $X=16850 $Y=8400 $D=6
M2 3 11 15 VSS n18 L=1.8e-07 W=3e-07 $X=22450 $Y=8400 $D=6
M3 16 10 3 VSS n18 L=1.8e-07 W=3e-07 $X=29200 $Y=15000 $D=6
M4 VSS 9 16 VSS n18 L=1.8e-07 W=3e-07 $X=34800 $Y=15000 $D=6
M5 17 SN VSS VSS n18 L=1.8e-07 W=3e-07 $X=40800 $Y=15000 $D=6
M6 9 3 17 VSS n18 L=1.8e-07 W=3e-07 $X=46400 $Y=15000 $D=6
M7 VSS 11 10 VSS n18 L=1.8e-07 W=3e-07 $X=55600 $Y=7000 $D=6
M8 18 9 VSS VSS n18 L=1.8e-07 W=4e-07 $X=61600 $Y=14100 $D=6
M9 12 10 18 VSS n18 L=1.8e-07 W=4e-07 $X=67200 $Y=14100 $D=6
M10 19 11 12 VSS n18 L=1.8e-07 W=3e-07 $X=73200 $Y=7350 $D=6
M11 VSS 13 19 VSS n18 L=1.8e-07 W=3e-07 $X=79000 $Y=7350 $D=6
M12 20 12 13 VSS n18 L=1.8e-07 W=5.8e-07 $X=90000 $Y=12500 $D=6
M13 VSS SN 20 VSS n18 L=1.8e-07 W=5.8e-07 $X=95600 $Y=12500 $D=6
M14 QN 13 VSS VSS n18 L=1.8e-07 W=5.6e-07 $X=103250 $Y=5800 $D=6
M15 14 13 VSS VSS n18 L=1.8e-07 W=3e-07 $X=103250 $Y=14900 $D=6
M16 Q 14 VSS VSS n18 L=1.8e-07 W=6e-07 $X=116250 $Y=11200 $D=6
M17 VDD CK 11 VDD p18 L=1.8e-07 W=6e-07 $X=6400 $Y=33200 $D=10
M18 21 D VDD VDD p18 L=1.8e-07 W=4.2e-07 $X=14200 $Y=28450 $D=10
M19 3 10 21 VDD p18 L=1.8e-07 W=4.2e-07 $X=19800 $Y=28450 $D=10
M20 22 11 3 VDD p18 L=1.8e-07 W=4.2e-07 $X=27400 $Y=31400 $D=10
M21 VDD 9 22 VDD p18 L=1.8e-07 W=4.2e-07 $X=33000 $Y=31400 $D=10
M22 9 SN VDD VDD p18 L=1.8e-07 W=3.2e-07 $X=39000 $Y=31400 $D=10
M23 VDD 3 9 VDD p18 L=1.8e-07 W=3.2e-07 $X=47000 $Y=31400 $D=10
M24 10 11 VDD VDD p18 L=1.8e-07 W=4.2e-07 $X=53000 $Y=30400 $D=10
M25 23 9 VDD VDD p18 L=1.8e-07 W=6e-07 $X=65600 $Y=32700 $D=10
M26 12 11 23 VDD p18 L=1.8e-07 W=6e-07 $X=71200 $Y=32700 $D=10
M27 24 10 12 VDD p18 L=1.8e-07 W=3e-07 $X=78800 $Y=33700 $D=10
M28 VDD 13 24 VDD p18 L=1.8e-07 W=3e-07 $X=84400 $Y=33700 $D=10
M29 13 12 VDD VDD p18 L=1.8e-07 W=6.6e-07 $X=90400 $Y=29200 $D=10
M30 VDD SN 13 VDD p18 L=1.8e-07 W=6.6e-07 $X=97600 $Y=29000 $D=10
M31 14 13 VDD VDD p18 L=1.8e-07 W=4.2e-07 $X=104800 $Y=29000 $D=10
M32 QN 13 VDD VDD p18 L=1.8e-07 W=8.6e-07 $X=104800 $Y=36000 $D=10
M33 Q 14 VDD VDD p18 L=1.8e-07 W=9e-07 $X=117400 $Y=28100 $D=10
.ENDS
***************************************
.SUBCKT AOI22XL B1 VDD B0 A0 A1 Y VSS
** N=10 EP=7 IP=0 FDC=8
M0 9 B1 VSS VSS n18 L=1.8e-07 W=5.6e-07 $X=6600 $Y=10200 $D=6
M1 Y B0 9 VSS n18 L=1.8e-07 W=5.6e-07 $X=12200 $Y=10200 $D=6
M2 10 A0 Y VSS n18 L=1.8e-07 W=5.6e-07 $X=19400 $Y=10200 $D=6
M3 VSS A1 10 VSS n18 L=1.8e-07 W=5.6e-07 $X=25000 $Y=10200 $D=6
M4 VDD B1 8 VDD p18 L=1.8e-07 W=8.4e-07 $X=6200 $Y=28900 $D=10
M5 8 B0 VDD VDD p18 L=1.8e-07 W=8.4e-07 $X=12200 $Y=28900 $D=10
M6 Y A0 8 VDD p18 L=1.8e-07 W=8.4e-07 $X=18200 $Y=28900 $D=10
M7 8 A1 Y VDD p18 L=1.8e-07 W=8.4e-07 $X=25400 $Y=28900 $D=10
.ENDS
***************************************
.SUBCKT AOI222X1 C0 C1 VDD B1 B0 A0 Y A1 VSS
** N=14 EP=9 IP=0 FDC=12
M0 12 C0 Y VSS n18 L=1.8e-07 W=8e-07 $X=6200 $Y=8950 $D=6
M1 VSS C1 12 VSS n18 L=1.8e-07 W=8e-07 $X=11800 $Y=8950 $D=6
M2 13 B1 VSS VSS n18 L=1.8e-07 W=8e-07 $X=21250 $Y=8950 $D=6
M3 Y B0 13 VSS n18 L=1.8e-07 W=8e-07 $X=26850 $Y=8950 $D=6
M4 14 A0 Y VSS n18 L=1.8e-07 W=8e-07 $X=34550 $Y=8950 $D=6
M5 VSS A1 14 VSS n18 L=1.8e-07 W=8e-07 $X=41250 $Y=8950 $D=6
M6 11 C0 VDD VDD p18 L=1.826e-07 W=1.39814e-06 $X=5400 $Y=31050 $D=10
M7 VDD C1 11 VDD p18 L=1.826e-07 W=1.39814e-06 $X=11800 $Y=36450 $D=10
M8 11 B1 10 VDD p18 L=1.826e-07 W=1.39814e-06 $X=25250 $Y=27800 $D=10
M9 10 B0 11 VDD p18 L=1.826e-07 W=1.39814e-06 $X=31650 $Y=33200 $D=10
M10 Y A0 10 VDD p18 L=1.826e-07 W=1.39814e-06 $X=38050 $Y=27800 $D=10
M11 10 A1 Y VDD p18 L=1.826e-07 W=1.39814e-06 $X=44450 $Y=33200 $D=10
.ENDS
***************************************
.SUBCKT AOI222XL C0 C1 VDD B1 B0 A0 A1 Y VSS
** N=14 EP=9 IP=0 FDC=12
M0 12 C0 Y VSS n18 L=1.8e-07 W=5.6e-07 $X=6200 $Y=9000 $D=6
M1 VSS C1 12 VSS n18 L=1.8e-07 W=5.6e-07 $X=11800 $Y=9000 $D=6
M2 13 B1 VSS VSS n18 L=1.8e-07 W=5.6e-07 $X=20650 $Y=9000 $D=6
M3 Y B0 13 VSS n18 L=1.8e-07 W=5.6e-07 $X=27350 $Y=9000 $D=6
M4 14 A0 Y VSS n18 L=1.8e-07 W=5.6e-07 $X=36250 $Y=9000 $D=6
M5 VSS A1 14 VSS n18 L=1.8e-07 W=5.6e-07 $X=41900 $Y=9000 $D=6
M6 10 C0 VDD VDD p18 L=1.8e-07 W=9.6e-07 $X=4600 $Y=29200 $D=10
M7 VDD C1 10 VDD p18 L=1.8e-07 W=9.6e-07 $X=11800 $Y=29200 $D=10
M8 10 B1 11 VDD p18 L=1.8e-07 W=9.6e-07 $X=23600 $Y=27400 $D=10
M9 11 B0 10 VDD p18 L=1.8e-07 W=9.6e-07 $X=30800 $Y=27400 $D=10
M10 Y A0 11 VDD p18 L=1.8e-07 W=9.6e-07 $X=36850 $Y=27400 $D=10
M11 11 A1 Y VDD p18 L=1.8e-07 W=9.6e-07 $X=44050 $Y=27400 $D=10
.ENDS
***************************************
.SUBCKT CLKBUFX3 A Y VSS VDD
** N=5 EP=4 IP=0 FDC=6
M0 VSS A 5 VSS n18 L=1.8e-07 W=3.4e-07 $X=6600 $Y=10650 $D=6
M1 Y 5 VSS VSS n18 L=1.8e-07 W=5.2e-07 $X=12600 $Y=10650 $D=6
M2 VSS 5 Y VSS n18 L=1.8e-07 W=5e-07 $X=19800 $Y=10850 $D=6
M3 VDD A 5 VDD p18 L=1.8e-07 W=9e-07 $X=6200 $Y=28850 $D=10
M4 Y 5 VDD VDD p18 L=1.8e-07 W=1.32e-06 $X=12200 $Y=26650 $D=10
M5 VDD 5 Y VDD p18 L=1.8e-07 W=1.32e-06 $X=19400 $Y=27000 $D=10
.ENDS
***************************************
.SUBCKT BUFXL A VSS VDD Y
** N=5 EP=4 IP=0 FDC=4
M0 VSS A 5 VSS n18 L=1.8e-07 W=3e-07 $X=6600 $Y=11900 $D=6
M1 Y 5 VSS VSS n18 L=1.8e-07 W=4.2e-07 $X=12600 $Y=10000 $D=6
M2 VDD A 5 VDD p18 L=1.8e-07 W=4.2e-07 $X=6200 $Y=27200 $D=10
M3 Y 5 VDD VDD p18 L=1.8e-07 W=6.4e-07 $X=12200 $Y=27200 $D=10
.ENDS
***************************************
.SUBCKT BUFX1 A VSS VDD Y
** N=5 EP=4 IP=0 FDC=4
M0 VSS A 5 VSS n18 L=1.8e-07 W=3e-07 $X=6600 $Y=11900 $D=6
M1 Y 5 VSS VSS n18 L=1.8e-07 W=6e-07 $X=12600 $Y=9100 $D=6
M2 VDD A 5 VDD p18 L=1.8e-07 W=4.2e-07 $X=6200 $Y=27200 $D=10
M3 Y 5 VDD VDD p18 L=1.8e-07 W=9e-07 $X=12200 $Y=27200 $D=10
.ENDS
***************************************
.SUBCKT NAND4XL D VSS C B Y A VDD
** N=10 EP=7 IP=0 FDC=8
M0 8 D VSS VSS n18 L=1.8e-07 W=7.2e-07 $X=6750 $Y=10550 $D=6
M1 9 C 8 VSS n18 L=1.8e-07 W=7.2e-07 $X=12350 $Y=10550 $D=6
M2 10 B 9 VSS n18 L=1.8e-07 W=7.2e-07 $X=17950 $Y=10550 $D=6
M3 Y A 10 VSS n18 L=1.8e-07 W=7.2e-07 $X=23550 $Y=10550 $D=6
M4 Y D VDD VDD p18 L=1.8e-07 W=6.4e-07 $X=5100 $Y=30550 $D=10
M5 VDD C Y VDD p18 L=1.8e-07 W=6.4e-07 $X=12300 $Y=30550 $D=10
M6 Y B VDD VDD p18 L=1.8e-07 W=6.4e-07 $X=18900 $Y=30550 $D=10
M7 VDD A Y VDD p18 L=1.8e-07 W=6.4e-07 $X=26100 $Y=30550 $D=10
.ENDS
***************************************
.SUBCKT AOI22X1 B1 B0 VDD A0 A1 Y VSS
** N=10 EP=7 IP=0 FDC=8
M0 9 B1 VSS VSS n18 L=1.8e-07 W=8e-07 $X=6200 $Y=8950 $D=6
M1 Y B0 9 VSS n18 L=1.8e-07 W=8e-07 $X=11800 $Y=8950 $D=6
M2 10 A0 Y VSS n18 L=1.8e-07 W=8e-07 $X=19000 $Y=7050 $D=6
M3 VSS A1 10 VSS n18 L=1.8e-07 W=8e-07 $X=24600 $Y=7050 $D=6
M4 VDD B1 8 VDD p18 L=1.8e-07 W=1.2e-06 $X=6200 $Y=28150 $D=10
M5 8 B0 VDD VDD p18 L=1.8e-07 W=1.2e-06 $X=12200 $Y=28150 $D=10
M6 Y A0 8 VDD p18 L=1.83022e-07 W=1.20314e-06 $X=18600 $Y=28950 $D=10
M7 8 A1 Y VDD p18 L=1.83022e-07 W=1.20314e-06 $X=25000 $Y=34450 $D=10
.ENDS
***************************************
.SUBCKT CLKINVX4 A Y VDD VSS
** N=4 EP=4 IP=0 FDC=4
M0 Y A VSS VSS n18 L=1.8e-07 W=6.8e-07 $X=8200 $Y=11400 $D=6
M1 VSS A Y VSS n18 L=1.8e-07 W=6.8e-07 $X=15400 $Y=11400 $D=6
M2 Y A VDD VDD p18 L=1.8e-07 W=1.77e-06 $X=8200 $Y=27000 $D=10
M3 VDD A Y VDD p18 L=1.8e-07 W=1.77e-06 $X=15400 $Y=27000 $D=10
.ENDS
***************************************
.SUBCKT INVX4 A Y VSS VDD
** N=4 EP=4 IP=0 FDC=4
M0 Y A VSS VSS n18 L=1.8e-07 W=1.2e-06 $X=6650 $Y=6200 $D=6
M1 VSS A Y VSS n18 L=1.8e-07 W=1.2e-06 $X=13850 $Y=6200 $D=6
M2 Y A VDD VDD p18 L=1.8e-07 W=1.74e-06 $X=6650 $Y=27300 $D=10
M3 VDD A Y VDD p18 L=1.8e-07 W=1.74e-06 $X=13850 $Y=27300 $D=10
.ENDS
***************************************
.SUBCKT CLKINVX8 A VSS Y VDD
** N=4 EP=4 IP=0 FDC=7
M0 Y A VSS VSS n18 L=1.85682e-07 W=9.59706e-07 $X=5800 $Y=11200 $D=6
M1 VSS A Y VSS n18 L=1.85682e-07 W=9.59706e-07 $X=13450 $Y=6500 $D=6
M2 Y A VSS VSS n18 L=1.85682e-07 W=9.59706e-07 $X=20250 $Y=11200 $D=6
M3 Y A VDD VDD p18 L=1.84048e-07 W=1.79627e-06 $X=5000 $Y=27200 $D=10
M4 VDD A Y VDD p18 L=1.84048e-07 W=1.79627e-06 $X=12200 $Y=36300 $D=10
M5 Y A VDD VDD p18 L=1.84048e-07 W=1.79627e-06 $X=19400 $Y=27200 $D=10
M6 VDD A Y VDD p18 L=1.84048e-07 W=1.79627e-06 $X=26600 $Y=36300 $D=10
.ENDS
***************************************
.SUBCKT CLKBUFX2 A VDD VSS Y
** N=5 EP=4 IP=0 FDC=4
M0 VSS A 5 VSS n18 L=1.8e-07 W=3e-07 $X=7600 $Y=12350 $D=6
M1 Y 5 VSS VSS n18 L=1.8e-07 W=6.4e-07 $X=13600 $Y=8950 $D=6
M2 VDD A 5 VDD p18 L=1.8e-07 W=7.8e-07 $X=7200 $Y=27100 $D=10
M3 Y 5 VDD VDD p18 L=1.8e-07 W=1.76e-06 $X=13200 $Y=27100 $D=10
.ENDS
***************************************
.SUBCKT AOI211X1 A1 VDD A0 C0 VSS B0 Y
** N=10 EP=7 IP=0 FDC=8
M0 9 A1 VSS VSS n18 L=1.8e-07 W=8e-07 $X=6200 $Y=6750 $D=6
M1 Y A0 9 VSS n18 L=1.8e-07 W=8e-07 $X=11800 $Y=6750 $D=6
M2 VSS C0 Y VSS n18 L=1.8e-07 W=6e-07 $X=19000 $Y=10550 $D=6
M3 Y B0 VSS VSS n18 L=1.8e-07 W=6e-07 $X=25000 $Y=10550 $D=6
M4 VDD A1 8 VDD p18 L=1.82563e-07 W=1.41814e-06 $X=5400 $Y=35100 $D=10
M5 8 A0 VDD VDD p18 L=1.82563e-07 W=1.41814e-06 $X=11800 $Y=27500 $D=10
M6 10 C0 8 VDD p18 L=1.8e-07 W=1.4e-06 $X=19000 $Y=27350 $D=10
M7 Y B0 10 VDD p18 L=1.8e-07 W=1.4e-06 $X=24600 $Y=27350 $D=10
.ENDS
***************************************
.SUBCKT NAND3XL C VSS B VDD A Y
** N=8 EP=6 IP=0 FDC=6
M0 7 C VSS VSS n18 L=1.8e-07 W=6.6e-07 $X=7200 $Y=8950 $D=6
M1 8 B 7 VSS n18 L=1.8e-07 W=6.6e-07 $X=12800 $Y=8950 $D=6
M2 Y A 8 VSS n18 L=1.8e-07 W=6.6e-07 $X=18400 $Y=8950 $D=6
M3 VDD C Y VDD p18 L=1.8e-07 W=6.4e-07 $X=4100 $Y=38800 $D=10
M4 VDD B Y VDD p18 L=1.8e-07 W=6.4e-07 $X=11500 $Y=27400 $D=10
M5 Y A VDD VDD p18 L=1.8e-07 W=6.4e-07 $X=18400 $Y=27400 $D=10
.ENDS
***************************************
.SUBCKT NAND2X1 B VSS A VDD Y
** N=6 EP=5 IP=0 FDC=4
M0 6 B VSS VSS n18 L=1.8e-07 W=7.8e-07 $X=6200 $Y=8950 $D=6
M1 Y A 6 VSS n18 L=1.8e-07 W=7.8e-07 $X=11800 $Y=8950 $D=6
M2 Y B VDD VDD p18 L=1.8e-07 W=9e-07 $X=5350 $Y=27150 $D=10
M3 VDD A Y VDD p18 L=1.8e-07 W=9e-07 $X=12600 $Y=27150 $D=10
.ENDS
***************************************
.SUBCKT NAND4X1 D VSS C B A Y VDD
** N=10 EP=7 IP=0 FDC=8
M0 8 D VSS VSS n18 L=1.8e-07 W=1.04e-06 $X=6750 $Y=5700 $D=6
M1 9 C 8 VSS n18 L=1.8e-07 W=1.04e-06 $X=12350 $Y=5700 $D=6
M2 10 B 9 VSS n18 L=1.8e-07 W=1.04e-06 $X=17950 $Y=5700 $D=6
M3 Y A 10 VSS n18 L=1.8e-07 W=1.04e-06 $X=23550 $Y=5700 $D=6
M4 Y D VDD VDD p18 L=1.84272e-07 W=9.57279e-07 $X=5100 $Y=30550 $D=10
M5 VDD C Y VDD p18 L=1.84272e-07 W=9.57279e-07 $X=11600 $Y=35350 $D=10
M6 Y B VDD VDD p18 L=1.84272e-07 W=9.57279e-07 $X=18700 $Y=30550 $D=10
M7 VDD A Y VDD p18 L=1.84272e-07 W=9.57279e-07 $X=25200 $Y=35350 $D=10
.ENDS
***************************************
.SUBCKT AND4XL A B C D VSS VDD Y
** N=11 EP=7 IP=0 FDC=10
M0 9 A 8 VSS n18 L=1.8e-07 W=4.8e-07 $X=6600 $Y=9150 $D=6
M1 10 B 9 VSS n18 L=1.8e-07 W=4.8e-07 $X=12200 $Y=9150 $D=6
M2 11 C 10 VSS n18 L=1.8e-07 W=4.8e-07 $X=17800 $Y=9150 $D=6
M3 VSS D 11 VSS n18 L=1.8e-07 W=4.8e-07 $X=23400 $Y=9150 $D=6
M4 Y 8 VSS VSS n18 L=1.8e-07 W=4.2e-07 $X=31400 $Y=9750 $D=6
M5 VDD A 8 VDD p18 L=1.8e-07 W=4e-07 $X=4800 $Y=39400 $D=10
M6 VDD B 8 VDD p18 L=1.8e-07 W=4e-07 $X=10000 $Y=30400 $D=10
M7 8 C VDD VDD p18 L=1.8e-07 W=4e-07 $X=16000 $Y=30400 $D=10
M8 VDD D 8 VDD p18 L=1.8e-07 W=4e-07 $X=24000 $Y=30400 $D=10
M9 Y 8 VDD VDD p18 L=1.8e-07 W=6.4e-07 $X=31200 $Y=30400 $D=10
.ENDS
***************************************
.SUBCKT OR4X1 A B C D VDD VSS Y
** N=11 EP=7 IP=0 FDC=10
M0 8 A VSS VSS n18 L=1.8e-07 W=3e-07 $X=4200 $Y=8900 $D=6
M1 VSS B 8 VSS n18 L=1.8e-07 W=3e-07 $X=11400 $Y=15400 $D=6
M2 8 C VSS VSS n18 L=1.8e-07 W=3e-07 $X=17400 $Y=11400 $D=6
M3 VSS D 8 VSS n18 L=1.8e-07 W=3e-07 $X=25400 $Y=11400 $D=6
M4 Y 8 VSS VSS n18 L=1.8e-07 W=6e-07 $X=31400 $Y=8400 $D=6
M5 9 A 8 VDD p18 L=1.8e-07 W=7.6e-07 $X=6800 $Y=32450 $D=10
M6 10 B 9 VDD p18 L=1.8e-07 W=7.6e-07 $X=12400 $Y=32450 $D=10
M7 11 C 10 VDD p18 L=1.8e-07 W=7.6e-07 $X=18000 $Y=32450 $D=10
M8 VDD D 11 VDD p18 L=1.8e-07 W=7.6e-07 $X=23600 $Y=32450 $D=10
M9 Y 8 VDD VDD p18 L=1.8e-07 W=9e-07 $X=29600 $Y=32450 $D=10
.ENDS
***************************************
.SUBCKT CLKBUFX4 A Y VSS VDD
** N=5 EP=4 IP=0 FDC=6
M0 VSS A 5 VSS n18 L=1.8e-07 W=4.4e-07 $X=6200 $Y=11900 $D=6
M1 Y 5 VSS VSS n18 L=1.8e-07 W=6.8e-07 $X=14200 $Y=10900 $D=6
M2 VSS 5 Y VSS n18 L=1.8e-07 W=6.8e-07 $X=21400 $Y=10900 $D=6
M3 VDD A 5 VDD p18 L=1.8e-07 W=1.16e-06 $X=6200 $Y=27000 $D=10
M4 Y 5 VDD VDD p18 L=1.8e-07 W=1.76e-06 $X=14200 $Y=27000 $D=10
M5 VDD 5 Y VDD p18 L=1.8e-07 W=1.76e-06 $X=21400 $Y=27000 $D=10
.ENDS
***************************************
.SUBCKT AOI221XL B1 B0 VDD A0 A1 VSS C0 Y
** N=12 EP=8 IP=0 FDC=10
M0 11 B1 VSS VSS n18 L=1.8e-07 W=5.6e-07 $X=6200 $Y=5700 $D=6
M1 Y B0 11 VSS n18 L=1.8e-07 W=5.6e-07 $X=11800 $Y=5700 $D=6
M2 12 A0 Y VSS n18 L=1.8e-07 W=5.6e-07 $X=19000 $Y=5700 $D=6
M3 VSS A1 12 VSS n18 L=1.8e-07 W=5.6e-07 $X=24600 $Y=5700 $D=6
M4 Y C0 VSS VSS n18 L=1.8e-07 W=4.2e-07 $X=32950 $Y=8950 $D=6
M5 10 B1 VDD VDD p18 L=1.8e-07 W=1e-06 $X=4600 $Y=30200 $D=10
M6 VDD B0 10 VDD p18 L=1.8e-07 W=1e-06 $X=11800 $Y=30200 $D=10
M7 10 A0 9 VDD p18 L=1.8e-07 W=1e-06 $X=22800 $Y=27300 $D=10
M8 9 A1 10 VDD p18 L=1.8e-07 W=1e-06 $X=30000 $Y=27300 $D=10
M9 Y C0 9 VDD p18 L=1.8e-07 W=1e-06 $X=36000 $Y=27300 $D=10
.ENDS
***************************************
.SUBCKT ICV_2 1 2 3 4 5 6 7 8 9 10 11 12 14 15 16 17 18 19 20 21
+ 22 23 24 25 26 27 28 29 31 32 33 34 37 39 40 41 42 43 49 50
+ 51 52 53 54 55 56 58 59 60 61 62 63 65 66 68 69 70 71 72 73
+ 74 75 76 77 78 82 83 84 85 86 87 88 89 90 92 93 95 96 97 98
+ 99 100 101 102 104 105 106 107 109 110 111 112 113 114 115 116 117 118 119 120
+ 121 122 123 124 125 127 128 129 130 132 133 134 137 138 139 142 144 145 147 148
+ 149 150 151 153 155 156 157 162 163 165 166 167 168 170 171 173 174 175 176 177
+ 178 179 180 181 182 183 186 187 188 189 190 191 192 193 194 195 196 197 198 199
+ 200 201 202 203 204 205 206 207 208 209 210 211 212 213 214 215 216 217 218 219
+ 220 221 222 223 224 225 226 227 228 229 230 231 232 233 234 235 236 237 238 239
+ 240 241 242 243 244 245 246 247 248 249 250 251 252 253 254 255 256 257 258 260
+ 261 262 263 264 265 266 267 268 269 270 271 272 273 274 275 276 277 278 279 280
+ 281 282 283 284 285 286 287 288 289 290 291 292 293 294 295
*.CALIBRE ICV_CELL 2
** N=1176 EP=255 IP=3507 FDC=6669
M0 221 439 755 221 n18 L=1.8e-07 W=3e-07 $X=1518350 $Y=3691150 $D=6
M1 443 69 221 221 n18 L=1.8e-07 W=4.2e-07 $X=1524350 $Y=3689950 $D=6
M2 221 202 443 221 n18 L=1.8e-07 W=4.2e-07 $X=1531600 $Y=3689950 $D=6
M3 443 756 221 221 n18 L=1.8e-07 W=4.2e-07 $X=1538700 $Y=3689950 $D=6
M4 221 755 443 221 n18 L=1.8e-07 W=4.2e-07 $X=1545900 $Y=3689950 $D=6
M5 756 684 221 221 n18 L=1.8e-07 W=3e-07 $X=1552200 $Y=3692650 $D=6
M6 3 757 221 221 n18 L=1.8e-07 W=1.2e-06 $X=2042200 $Y=3762300 $D=6
M7 221 757 3 221 n18 L=1.8e-07 W=1.2e-06 $X=2049400 $Y=3762300 $D=6
M8 1167 462 221 221 n18 L=1.8e-07 W=8e-07 $X=2056600 $Y=3764650 $D=6
M9 1168 689 1167 221 n18 L=1.8e-07 W=8e-07 $X=2062200 $Y=3764650 $D=6
M10 1169 102 1168 221 n18 L=1.8e-07 W=8e-07 $X=2067800 $Y=3764650 $D=6
M11 757 476 1169 221 n18 L=1.8e-07 W=8e-07 $X=2073400 $Y=3764650 $D=6
M12 1170 476 757 221 n18 L=1.8e-07 W=8e-07 $X=2080600 $Y=3763050 $D=6
M13 1171 102 1170 221 n18 L=1.8e-07 W=8e-07 $X=2086200 $Y=3763050 $D=6
M14 1172 689 1171 221 n18 L=1.8e-07 W=8e-07 $X=2091800 $Y=3763050 $D=6
M15 221 462 1172 221 n18 L=1.8e-07 W=8e-07 $X=2097400 $Y=3763050 $D=6
M16 221 776 775 221 n18 L=1.8e-07 W=4.2e-07 $X=3741800 $Y=3589900 $D=6
M17 774 285 221 221 n18 L=1.8e-07 W=3e-07 $X=3747800 $Y=3590100 $D=6
M18 662 774 775 221 n18 L=1.8e-07 W=5.6e-07 $X=3764450 $Y=3584350 $D=6
M19 776 285 662 221 n18 L=1.8e-07 W=5.6e-07 $X=3772050 $Y=3588100 $D=6
M20 221 286 776 221 n18 L=1.8e-07 W=4.2e-07 $X=3779650 $Y=3588950 $D=6
M21 1173 286 221 221 n18 L=1.8e-07 W=3.6e-07 $X=3785650 $Y=3591650 $D=6
M22 777 285 1173 221 n18 L=1.8e-07 W=3.6e-07 $X=3791250 $Y=3591650 $D=6
M23 665 777 221 221 n18 L=1.8e-07 W=4.2e-07 $X=3800200 $Y=3584300 $D=6
M24 104 439 755 104 p18 L=1.8e-07 W=4.2e-07 $X=1517600 $Y=3706850 $D=10
M25 1174 69 104 104 p18 L=1.8e-07 W=1.16e-06 $X=1525450 $Y=3706850 $D=10
M26 1175 202 1174 104 p18 L=1.8e-07 W=1.16e-06 $X=1531600 $Y=3706850 $D=10
M27 1176 756 1175 104 p18 L=1.8e-07 W=1.16e-06 $X=1537450 $Y=3706850 $D=10
M28 443 755 1176 104 p18 L=1.8e-07 W=1.16e-06 $X=1543450 $Y=3706850 $D=10
M29 104 684 756 104 p18 L=1.8e-07 W=4.2e-07 $X=1554150 $Y=3715150 $D=10
M30 3 757 104 104 p18 L=1.8e-07 W=1.77e-06 $X=2046950 $Y=3735300 $D=10
M31 104 757 3 104 p18 L=1.8e-07 W=1.77e-06 $X=2054200 $Y=3735300 $D=10
M32 757 689 104 104 p18 L=1.8e-07 W=1.29e-06 $X=2066250 $Y=3735300 $D=10
M33 104 102 757 104 p18 L=1.8e-07 W=1.29e-06 $X=2073750 $Y=3735300 $D=10
M34 757 476 104 104 p18 L=1.8e-07 W=1.29e-06 $X=2081800 $Y=3735300 $D=10
M35 104 462 757 104 p18 L=1.8e-07 W=1.29e-06 $X=2089000 $Y=3735300 $D=10
M36 104 776 775 104 p18 L=1.8e-07 W=6.4e-07 $X=3741800 $Y=3612900 $D=10
M37 774 285 104 104 p18 L=1.8e-07 W=4.2e-07 $X=3747800 $Y=3612900 $D=10
M38 662 285 775 104 p18 L=1.8e-07 W=8.4e-07 $X=3762000 $Y=3611450 $D=10
M39 776 774 662 104 p18 L=1.8e-07 W=8.4e-07 $X=3771250 $Y=3611450 $D=10
M40 104 286 776 104 p18 L=1.8e-07 W=6.4e-07 $X=3778450 $Y=3611450 $D=10
M41 777 286 104 104 p18 L=1.8e-07 W=4.2e-07 $X=3784450 $Y=3611450 $D=10
M42 104 285 777 104 p18 L=1.8e-07 W=4.2e-07 $X=3791650 $Y=3611450 $D=10
M43 665 777 104 104 p18 L=1.8e-07 W=6.4e-07 $X=3797750 $Y=3611450 $D=10
X44 393 104 221 24 INVXL $T=613800 3679200 0 0 $X=609500 $Y=3675200
X45 482 104 221 497 INVXL $T=2567400 4183200 1 0 $X=2563100 $Y=4127400
X46 334 104 221 335 INVXL $T=2686200 3679200 1 180 $X=2668700 $Y=3675200
X47 332 104 221 499 INVXL $T=2686200 3780000 1 180 $X=2668700 $Y=3776000
X48 336 104 221 489 INVXL $T=2706000 4183200 0 180 $X=2688500 $Y=4127400
X49 129 104 221 702 INVXL $T=2772000 3679200 0 0 $X=2767700 $Y=3675200
X50 516 104 221 521 INVXL $T=2791800 4082400 1 0 $X=2787500 $Y=4026600
X51 513 104 221 523 INVXL $T=2831400 3981600 0 0 $X=2827100 $Y=3977600
X52 537 104 221 538 INVXL $T=2970000 4082400 0 0 $X=2965700 $Y=4078400
X53 548 104 221 531 INVXL $T=3009600 4183200 1 180 $X=2992100 $Y=4179200
X54 535 104 221 715 INVXL $T=3009600 4082400 1 0 $X=3005300 $Y=4026600
X55 716 104 221 558 INVXL $T=3049200 4082400 1 0 $X=3044900 $Y=4026600
X56 527 104 221 550 INVXL $T=3062400 3981600 1 0 $X=3058100 $Y=3925800
X57 562 104 221 722 INVXL $T=3082200 3780000 0 0 $X=3077900 $Y=3776000
X58 147 104 221 576 INVXL $T=3108600 3679200 0 0 $X=3104300 $Y=3675200
X59 582 104 221 585 INVXL $T=3161400 3880800 0 0 $X=3157100 $Y=3876800
X60 726 104 221 589 INVXL $T=3201000 4183200 0 0 $X=3196700 $Y=4179200
X61 364 104 221 730 INVXL $T=3227400 4183200 0 180 $X=3209900 $Y=4127400
X62 557 104 221 598 INVXL $T=3240600 4284000 1 0 $X=3236300 $Y=4228200
X63 592 104 221 733 INVXL $T=3267000 4183200 0 0 $X=3262700 $Y=4179200
X64 597 104 221 768 INVXL $T=3286800 4183200 0 0 $X=3282500 $Y=4179200
X65 601 104 221 371 INVXL $T=3306600 4082400 0 0 $X=3302300 $Y=4078400
X66 734 104 221 618 INVXL $T=3319800 4183200 1 0 $X=3315500 $Y=4127400
X67 612 104 221 626 INVXL $T=3425400 3981600 1 0 $X=3421100 $Y=3925800
X68 624 104 221 629 INVXL $T=3458400 3981600 0 0 $X=3454100 $Y=3977600
X69 375 104 221 636 INVXL $T=3517800 3981600 1 0 $X=3513500 $Y=3925800
X70 619 104 221 634 INVXL $T=3531000 3981600 1 180 $X=3513500 $Y=3977600
X71 279 104 221 744 INVXL $T=3531000 3578400 0 0 $X=3526700 $Y=3574400
X72 641 104 221 749 INVXL $T=3590400 3880800 0 0 $X=3586100 $Y=3876800
X73 644 104 221 656 INVXL $T=3669600 3780000 1 0 $X=3665300 $Y=3724200
X74 633 104 221 750 INVXL $T=3689400 3880800 1 0 $X=3685100 $Y=3825000
X75 645 104 221 381 INVXL $T=3696000 3780000 1 0 $X=3691700 $Y=3724200
X76 667 104 221 668 INVXL $T=3854400 3679200 0 0 $X=3850100 $Y=3675200
X77 234 104 221 671 INVXL $T=3927000 3679200 1 0 $X=3922700 $Y=3623400
X78 295 104 221 168 INVXL $T=4026000 4082400 0 180 $X=4008500 $Y=4026600
X79 483 221 479 327 104 328 OAI21XL $T=2587200 4183200 1 0 $X=2582900 $Y=4127400
X80 330 221 478 694 104 496 OAI21XL $T=2620200 3780000 0 0 $X=2615900 $Y=3776000
X81 488 221 333 494 104 331 OAI21XL $T=2620200 3981600 1 0 $X=2615900 $Y=3925800
X82 490 221 491 759 104 498 OAI21XL $T=2633400 3679200 1 0 $X=2629100 $Y=3623400
X83 332 221 335 330 104 491 OAI21XL $T=2673000 3679200 1 180 $X=2642300 $Y=3675200
X84 481 221 329 488 104 504 OAI21XL $T=2646600 3981600 0 0 $X=2642300 $Y=3977600
X85 132 221 697 493 104 334 OAI21XL $T=2692800 3679200 0 180 $X=2662100 $Y=3623400
X86 760 221 336 761 104 548 OAI21XL $T=2686200 4082400 0 0 $X=2681900 $Y=4078400
X87 502 221 504 762 104 342 OAI21XL $T=2719200 3981600 1 0 $X=2714900 $Y=3925800
X88 338 221 337 506 104 700 OAI21XL $T=2745600 3780000 0 0 $X=2741300 $Y=3776000
X89 511 221 507 509 104 703 OAI21XL $T=2772000 3880800 0 0 $X=2767700 $Y=3876800
X90 505 221 702 338 104 520 OAI21XL $T=2778600 3780000 1 0 $X=2774300 $Y=3724200
X91 517 221 518 512 104 519 OAI21XL $T=2778600 4082400 0 0 $X=2774300 $Y=4078400
X92 510 221 524 511 104 709 OAI21XL $T=2811600 3880800 0 0 $X=2807300 $Y=3876800
X93 704 221 513 763 104 527 OAI21XL $T=2824800 3981600 1 0 $X=2820500 $Y=3925800
X94 345 221 528 764 104 347 OAI21XL $T=2890800 4183200 1 0 $X=2886500 $Y=4127400
X95 530 221 531 349 104 528 OAI21XL $T=2950200 4183200 0 180 $X=2919500 $Y=4127400
X96 349 221 529 713 104 537 OAI21XL $T=2930400 4082400 0 0 $X=2926100 $Y=4078400
X97 351 221 535 541 104 536 OAI21XL $T=3003000 4082400 0 180 $X=2972300 $Y=4026600
X98 539 221 540 543 104 556 OAI21XL $T=3029400 3981600 1 0 $X=3025100 $Y=3925800
X99 544 221 531 553 104 557 OAI21XL $T=3029400 4183200 0 0 $X=3025100 $Y=4179200
X100 546 221 550 539 104 718 OAI21XL $T=3036000 3880800 0 0 $X=3031700 $Y=3876800
X101 562 221 561 552 104 568 OAI21XL $T=3075600 3780000 1 0 $X=3071300 $Y=3724200
X102 765 221 560 574 104 359 OAI21XL $T=3121800 4082400 0 0 $X=3117500 $Y=4078400
X103 563 221 553 577 104 565 OAI21XL $T=3121800 4183200 0 0 $X=3117500 $Y=4179200
X104 356 221 570 721 104 727 OAI21XL $T=3128400 4082400 1 0 $X=3124100 $Y=4026600
X105 554 221 576 561 104 584 OAI21XL $T=3148200 3679200 0 0 $X=3143900 $Y=3675200
X106 361 221 578 725 104 586 OAI21XL $T=3154800 3880800 1 0 $X=3150500 $Y=3825000
X107 358 221 575 766 104 587 OAI21XL $T=3154800 4183200 1 0 $X=3150500 $Y=4127400
X108 572 221 584 767 104 590 OAI21XL $T=3201000 3679200 0 0 $X=3196700 $Y=3675200
X109 580 221 550 591 104 375 OAI21XL $T=3220800 3981600 0 0 $X=3216500 $Y=3977600
X110 581 221 364 593 104 597 OAI21XL $T=3220800 4082400 0 0 $X=3216500 $Y=4078400
X111 596 221 591 599 104 569 OAI21XL $T=3247200 3981600 1 0 $X=3242900 $Y=3925800
X112 601 221 365 600 104 731 OAI21XL $T=3293400 4082400 1 180 $X=3262700 $Y=4078400
X113 733 221 598 768 104 604 OAI21XL $T=3300000 4183200 0 0 $X=3295700 $Y=4179200
X114 630 221 606 605 104 615 OAI21XL $T=3379200 3880800 1 180 $X=3348500 $Y=3876800
X115 611 221 604 621 104 736 OAI21XL $T=3372600 4183200 0 0 $X=3368300 $Y=4179200
X116 619 221 623 610 104 616 OAI21XL $T=3432000 3981600 1 180 $X=3401300 $Y=3977600
X117 171 221 279 635 104 280 OAI21XL $T=3498000 3578400 0 0 $X=3493700 $Y=3574400
X118 641 221 649 643 104 748 OAI21XL $T=3590400 3880800 1 0 $X=3586100 $Y=3825000
X119 642 221 613 377 104 651 OAI21XL $T=3623400 3780000 1 0 $X=3619100 $Y=3724200
X120 653 221 654 655 104 379 OAI21XL $T=3630000 3880800 0 0 $X=3625700 $Y=3876800
X121 229 221 379 376 104 178 OAI21XL $T=3649800 3679200 0 0 $X=3645500 $Y=3675200
X122 633 221 657 649 104 654 OAI21XL $T=3682800 3880800 0 180 $X=3652100 $Y=3825000
X123 660 221 381 773 104 772 OAI21XL $T=3715800 3679200 0 180 $X=3685100 $Y=3623400
X124 661 221 288 663 104 667 OAI21XL $T=3788400 3679200 0 0 $X=3784100 $Y=3675200
X125 669 221 234 233 104 752 OAI21XL $T=3887400 3578400 0 0 $X=3883100 $Y=3574400
X126 666 221 668 669 104 672 OAI21XL $T=3913800 3679200 0 0 $X=3909500 $Y=3675200
X127 753 221 672 673 104 293 OAI21XL $T=3999600 3679200 1 0 $X=3995300 $Y=3623400
X128 163 221 104 224 CLKBUFXL $T=3346200 4183200 0 0 $X=3341900 $Y=4179200
X129 167 221 104 226 CLKBUFXL $T=3451800 4183200 0 0 $X=3447500 $Y=4179200
X130 176 221 104 230 CLKBUFXL $T=3643200 4082400 1 0 $X=3638900 $Y=4026600
X131 177 221 104 228 CLKBUFXL $T=3669600 3981600 1 0 $X=3665300 $Y=3925800
X132 179 221 104 231 CLKBUFXL $T=3762000 3981600 0 0 $X=3757700 $Y=3977600
X133 180 221 104 289 CLKBUFXL $T=3874200 3981600 1 180 $X=3843500 $Y=3977600
X134 291 221 104 236 CLKBUFXL $T=3933600 4082400 1 0 $X=3929300 $Y=4026600
X135 186 221 104 238 CLKBUFXL $T=3966600 3981600 0 0 $X=3962300 $Y=3977600
X136 248 221 104 397 398 NAND2XL $T=752400 3578400 0 0 $X=748100 $Y=3574400
X137 676 221 104 83 43 NAND2XL $T=1135200 3880800 1 0 $X=1130900 $Y=3825000
X138 411 221 104 255 297 NAND2XL $T=1201200 3578400 0 0 $X=1196900 $Y=3574400
X139 419 221 104 42 679 NAND2XL $T=1280400 4082400 0 180 $X=1256300 $Y=4026600
X140 681 221 104 42 420 NAND2XL $T=1339800 3880800 1 180 $X=1315700 $Y=3876800
X141 416 221 104 83 429 NAND2XL $T=1452000 3880800 0 0 $X=1447700 $Y=3876800
X142 314 221 104 42 61 NAND2XL $T=1524600 3880800 0 180 $X=1500500 $Y=3825000
X143 441 221 104 438 440 NAND2XL $T=1524600 3880800 1 180 $X=1500500 $Y=3876800
X144 315 221 104 42 684 NAND2XL $T=1584000 3780000 1 180 $X=1559900 $Y=3776000
X145 453 221 104 96 454 NAND2XL $T=1874400 3679200 1 0 $X=1870100 $Y=3623400
X146 455 221 104 96 321 NAND2XL $T=1900800 3780000 0 0 $X=1896500 $Y=3776000
X147 456 221 104 96 260 NAND2XL $T=1947000 3578400 0 0 $X=1942700 $Y=3574400
X148 686 221 104 96 462 NAND2XL $T=1999800 3880800 1 0 $X=1995500 $Y=3825000
X149 687 221 104 97 466 NAND2XL $T=2052600 3679200 0 0 $X=2048300 $Y=3675200
X150 688 221 104 97 468 NAND2XL $T=2065800 3679200 1 0 $X=2061500 $Y=3623400
X151 469 221 104 97 689 NAND2XL $T=2118600 3880800 1 180 $X=2094500 $Y=3876800
X152 690 221 104 97 263 NAND2XL $T=2171400 3780000 0 180 $X=2147300 $Y=3724200
X153 115 221 104 107 465 NAND2XL $T=2277000 3578400 1 180 $X=2252900 $Y=3574400
X154 148 221 104 267 327 NAND2XL $T=2547600 4183200 1 0 $X=2543300 $Y=4127400
X155 142 221 104 435 694 NAND2XL $T=2554200 3780000 0 0 $X=2549900 $Y=3776000
X156 350 221 104 307 483 NAND2XL $T=2567400 4082400 0 0 $X=2563100 $Y=4078400
X157 339 221 104 437 488 NAND2XL $T=2587200 3981600 0 0 $X=2582900 $Y=3977600
X158 125 221 104 484 330 NAND2XL $T=2593800 3679200 0 0 $X=2589500 $Y=3675200
X159 487 221 104 215 494 NAND2XL $T=2613600 3880800 1 180 $X=2589500 $Y=3876800
X160 490 221 104 491 759 NAND2XL $T=2626800 3679200 0 180 $X=2602700 $Y=3623400
X161 217 221 104 216 493 NAND2XL $T=2620200 3578400 0 0 $X=2615900 $Y=3574400
X162 330 221 104 499 500 NAND2XL $T=2646600 3780000 1 0 $X=2642300 $Y=3724200
X163 492 221 104 485 760 NAND2XL $T=2653200 4082400 0 0 $X=2648900 $Y=4078400
X164 483 221 104 497 501 NAND2XL $T=2673000 4183200 1 0 $X=2668700 $Y=4127400
X165 326 221 104 142 506 NAND2XL $T=2692800 3780000 0 0 $X=2688500 $Y=3776000
X166 502 221 104 504 762 NAND2XL $T=2692800 3981600 1 0 $X=2688500 $Y=3925800
X167 325 221 104 125 338 NAND2XL $T=2712600 3679200 0 0 $X=2708300 $Y=3675200
X168 121 221 104 487 509 NAND2XL $T=2752200 3880800 0 180 $X=2728100 $Y=3825000
X169 111 221 104 339 511 NAND2XL $T=2745600 3880800 0 0 $X=2741300 $Y=3876800
X170 127 221 104 350 517 NAND2XL $T=2745600 4082400 1 0 $X=2741300 $Y=4026600
X171 324 221 104 148 512 NAND2XL $T=2745600 4082400 0 0 $X=2741300 $Y=4078400
X172 514 221 104 515 704 NAND2XL $T=2772000 3981600 0 0 $X=2767700 $Y=3977600
X173 157 221 104 340 525 NAND2XL $T=2811600 3679200 1 180 $X=2787500 $Y=3675200
X174 157 221 104 498 269 NAND2XL $T=2818200 3578400 1 180 $X=2794100 $Y=3574400
X175 157 221 104 508 149 NAND2XL $T=2818200 3679200 0 0 $X=2813900 $Y=3675200
X176 157 221 104 342 705 NAND2XL $T=2857800 3780000 1 180 $X=2833700 $Y=3776000
X177 157 221 104 343 138 NAND2XL $T=2871000 3981600 1 0 $X=2866700 $Y=3925800
X178 517 221 104 521 710 NAND2XL $T=2871000 4082400 1 0 $X=2866700 $Y=4026600
X179 345 221 104 528 764 NAND2XL $T=2871000 4183200 1 0 $X=2866700 $Y=4127400
X180 157 221 104 344 711 NAND2XL $T=2877600 3780000 0 0 $X=2873300 $Y=3776000
X181 157 221 104 347 712 NAND2XL $T=2890800 3981600 1 0 $X=2886500 $Y=3925800
X182 157 221 104 348 346 NAND2XL $T=2937000 3981600 0 180 $X=2912900 $Y=3925800
X183 533 221 104 311 713 NAND2XL $T=2937000 3981600 1 180 $X=2912900 $Y=3977600
X184 475 221 104 532 539 NAND2XL $T=2950200 3880800 0 0 $X=2945900 $Y=3876800
X185 532 221 104 417 349 NAND2XL $T=2950200 4082400 1 0 $X=2945900 $Y=4026600
X186 341 221 104 533 543 NAND2XL $T=2963400 3981600 1 0 $X=2959100 $Y=3925800
X187 213 221 104 139 145 NAND2XL $T=2996400 3578400 0 0 $X=2992100 $Y=3574400
X188 353 221 104 312 541 NAND2XL $T=2996400 3981600 0 0 $X=2992100 $Y=3977600
X189 551 221 104 542 544 NAND2XL $T=2996400 4183200 1 0 $X=2992100 $Y=4127400
X190 128 221 104 549 552 NAND2XL $T=3022800 3780000 1 0 $X=3018500 $Y=3724200
X191 541 221 104 715 356 NAND2XL $T=3022800 3981600 0 0 $X=3018500 $Y=3977600
X192 218 221 104 559 561 NAND2XL $T=3055800 3679200 0 0 $X=3051500 $Y=3675200
X193 351 221 104 558 765 NAND2XL $T=3062400 4082400 0 0 $X=3058100 $Y=4078400
X194 355 221 104 105 351 NAND2XL $T=3095400 3981600 1 180 $X=3071300 $Y=3977600
X195 356 221 104 570 721 NAND2XL $T=3095400 3981600 0 0 $X=3091100 $Y=3977600
X196 765 221 104 560 574 NAND2XL $T=3095400 4082400 0 0 $X=3091100 $Y=4078400
X197 471 221 104 353 725 NAND2XL $T=3102000 3780000 0 0 $X=3097700 $Y=3776000
X198 552 221 104 722 572 NAND2XL $T=3128400 3780000 0 180 $X=3104300 $Y=3724200
X199 571 221 104 355 361 NAND2XL $T=3128400 3880800 0 0 $X=3124100 $Y=3876800
X200 358 221 104 575 766 NAND2XL $T=3148200 4183200 0 180 $X=3124100 $Y=4127400
X201 583 221 104 566 580 NAND2XL $T=3168000 3981600 1 180 $X=3143900 $Y=3977600
X202 588 221 104 153 581 NAND2XL $T=3181200 4082400 0 180 $X=3157100 $Y=4026600
X203 157 221 104 359 360 NAND2XL $T=3168000 3981600 0 0 $X=3163700 $Y=3977600
X204 572 221 104 584 767 NAND2XL $T=3174600 3679200 0 0 $X=3170300 $Y=3675200
X205 157 221 104 727 362 NAND2XL $T=3187800 3981600 0 0 $X=3183500 $Y=3977600
X206 593 221 104 730 358 NAND2XL $T=3207600 4082400 1 180 $X=3183500 $Y=4078400
X207 157 221 104 587 363 NAND2XL $T=3207600 4082400 1 0 $X=3203300 $Y=4026600
X208 581 221 104 589 594 NAND2XL $T=3207600 4284000 1 0 $X=3203300 $Y=4228200
X209 595 221 104 592 563 NAND2XL $T=3253800 4183200 1 180 $X=3229700 $Y=4179200
X210 361 221 104 585 732 NAND2XL $T=3253800 3880800 0 0 $X=3249500 $Y=3876800
X211 367 221 104 9 593 NAND2XL $T=3273600 4082400 0 180 $X=3249500 $Y=4026600
X212 366 221 104 162 600 NAND2XL $T=3293400 3981600 1 180 $X=3269300 $Y=3977600
X213 369 221 104 298 601 NAND2XL $T=3313200 3981600 1 180 $X=3289100 $Y=3977600
X214 222 221 104 366 605 NAND2XL $T=3313200 3880800 1 0 $X=3308900 $Y=3825000
X215 209 221 104 367 610 NAND2XL $T=3319800 3981600 0 0 $X=3315500 $Y=3977600
X216 611 221 104 604 621 NAND2XL $T=3326400 4183200 0 0 $X=3322100 $Y=4179200
X217 157 221 104 370 368 NAND2XL $T=3333000 4082400 1 0 $X=3328700 $Y=4026600
X218 601 221 104 618 611 NAND2XL $T=3339600 4183200 1 0 $X=3335300 $Y=4127400
X219 616 221 104 627 596 NAND2XL $T=3366000 3981600 0 180 $X=3341900 $Y=3925800
X220 109 221 104 369 630 NAND2XL $T=3379200 3880800 0 180 $X=3355100 $Y=3825000
X221 157 221 104 735 301 NAND2XL $T=3379200 4082400 0 180 $X=3355100 $Y=4026600
X222 166 221 104 588 619 NAND2XL $T=3372600 3981600 0 0 $X=3368300 $Y=3977600
X223 157 221 104 736 372 NAND2XL $T=3379200 4082400 1 0 $X=3374900 $Y=4026600
X224 220 221 104 602 377 NAND2XL $T=3385800 3679200 0 0 $X=3381500 $Y=3675200
X225 115 221 104 374 171 NAND2XL $T=3471600 3578400 0 0 $X=3467300 $Y=3574400
X226 112 221 104 617 649 NAND2XL $T=3498000 3880800 1 0 $X=3493700 $Y=3825000
X227 630 221 104 626 742 NAND2XL $T=3498000 3880800 0 0 $X=3493700 $Y=3876800
X228 619 221 104 629 745 NAND2XL $T=3531000 3981600 0 0 $X=3526700 $Y=3977600
X229 123 221 104 573 642 NAND2XL $T=3537600 3679200 0 0 $X=3533300 $Y=3675200
X230 635 221 104 744 281 NAND2XL $T=3544200 3578400 0 0 $X=3539900 $Y=3574400
X231 227 221 104 639 635 NAND2XL $T=3550800 3679200 1 0 $X=3546500 $Y=3623400
X232 170 221 104 640 643 NAND2XL $T=3557400 3880800 1 0 $X=3553100 $Y=3825000
X233 643 221 104 749 653 NAND2XL $T=3603600 3880800 0 0 $X=3599300 $Y=3876800
X234 380 221 104 652 648 NAND2XL $T=3649800 3780000 1 180 $X=3625700 $Y=3776000
X235 653 221 104 654 655 NAND2XL $T=3663000 3880800 0 0 $X=3658700 $Y=3876800
X236 649 221 104 750 659 NAND2XL $T=3702600 3880800 1 0 $X=3698300 $Y=3825000
X237 660 221 104 381 773 NAND2XL $T=3742200 3679200 0 180 $X=3718100 $Y=3623400
X238 642 221 104 656 660 NAND2XL $T=3755400 3780000 0 180 $X=3731300 $Y=3724200
X239 287 221 104 662 663 NAND2XL $T=3775200 3679200 1 0 $X=3770900 $Y=3623400
X240 665 221 104 232 669 NAND2XL $T=3847800 3578400 0 0 $X=3843500 $Y=3574400
X241 233 221 104 671 753 NAND2XL $T=3940200 3679200 1 0 $X=3935900 $Y=3623400
X242 753 221 104 672 673 NAND2XL $T=3966600 3679200 1 0 $X=3962300 $Y=3623400
X243 495 329 221 104 344 XOR2XL $T=2679600 3981600 0 0 $X=2675300 $Y=3977600
X244 132 503 221 104 133 XOR2XL $T=2712600 3578400 0 0 $X=2708300 $Y=3574400
X245 534 531 221 104 348 XOR2XL $T=2976600 4183200 1 180 $X=2919500 $Y=4179200
X246 714 550 221 104 549 XOR2XL $T=3016200 3780000 0 0 $X=3011900 $Y=3776000
X247 357 576 221 104 156 XOR2XL $T=3161400 3679200 0 180 $X=3104300 $Y=3623400
X248 594 598 221 104 370 XOR2XL $T=3267000 4284000 1 0 $X=3262700 $Y=4228200
X249 288 664 221 104 181 XOR2XL $T=3801600 3679200 1 0 $X=3797300 $Y=3623400
X250 668 670 221 104 237 XOR2XL $T=3953400 3679200 0 0 $X=3949100 $Y=3675200
X251 11 60 779 104 780 240 221 781 104 DFFSXL $T=46200 3578400 0 0 $X=41900 $Y=3574400
X252 11 15 782 104 783 385 221 784 104 DFFSXL $T=224400 3780000 1 0 $X=220100 $Y=3724200
X253 11 33 785 104 786 386 221 787 104 DFFSXL $T=244200 3880800 1 0 $X=239900 $Y=3825000
X254 11 72 788 104 789 387 221 790 104 DFFSXL $T=257400 3880800 0 0 $X=253100 $Y=3876800
X255 14 33 791 104 792 303 221 793 104 DFFSXL $T=389400 3780000 0 0 $X=385100 $Y=3776000
X256 14 72 794 104 795 388 221 796 104 DFFSXL $T=396000 3880800 0 0 $X=391700 $Y=3876800
X257 14 15 797 104 798 390 221 799 104 DFFSXL $T=415800 3679200 1 0 $X=411500 $Y=3623400
X258 18 87 800 104 801 245 221 802 104 DFFSXL $T=541200 3679200 1 0 $X=536900 $Y=3623400
X259 23 197 803 305 804 396 221 805 104 DFFSXL $T=666600 3780000 1 0 $X=662300 $Y=3724200
X260 25 72 806 305 807 394 221 808 104 DFFSXL $T=673200 3880800 0 0 $X=668900 $Y=3876800
X261 25 197 809 305 810 392 221 811 104 DFFSXL $T=673200 3981600 1 0 $X=668900 $Y=3925800
X262 23 33 812 104 813 395 221 814 104 DFFSXL $T=686400 3679200 1 0 $X=682100 $Y=3623400
X263 25 28 815 305 816 391 221 817 104 DFFSXL $T=798600 3880800 1 0 $X=794300 $Y=3825000
X264 29 110 818 305 819 400 221 820 104 DFFSXL $T=825000 3679200 1 0 $X=820700 $Y=3623400
X265 29 197 821 305 822 250 221 823 104 DFFSXL $T=825000 3679200 0 0 $X=820700 $Y=3675200
X266 10 199 824 305 825 675 221 826 104 DFFSXL $T=930600 3780000 0 0 $X=926300 $Y=3776000
X267 10 49 827 305 828 304 221 829 104 DFFSXL $T=930600 3880800 0 0 $X=926300 $Y=3876800
X268 29 199 830 305 831 402 221 832 104 DFFSXL $T=943800 3578400 0 0 $X=939500 $Y=3574400
X269 37 87 833 305 834 676 221 835 104 DFFSXL $T=957000 3780000 1 0 $X=952700 $Y=3724200
X270 37 21 836 305 837 412 221 838 104 DFFSXL $T=1069200 3880800 0 0 $X=1064900 $Y=3876800
X271 37 55 839 305 840 415 221 841 104 DFFSXL $T=1082400 3780000 1 0 $X=1078100 $Y=3724200
X272 37 40 842 305 843 414 221 844 104 DFFSXL $T=1089000 3981600 1 0 $X=1084700 $Y=3925800
X273 10 122 845 305 846 409 221 847 104 DFFSXL $T=1102200 4183200 1 0 $X=1097900 $Y=4127400
X274 37 110 848 104 849 405 221 850 104 DFFSXL $T=1207800 3679200 1 0 $X=1203500 $Y=3623400
X275 37 197 851 305 852 58 221 853 104 DFFSXL $T=1221000 3780000 1 0 $X=1216700 $Y=3724200
X276 54 122 122 305 854 419 221 855 104 DFFSXL $T=1234200 4082400 0 0 $X=1229900 $Y=4078400
X277 10 60 856 305 857 310 221 858 104 DFFSXL $T=1247400 4183200 0 0 $X=1243100 $Y=4179200
X278 54 49 859 305 860 681 221 861 104 DFFSXL $T=1267200 3981600 1 0 $X=1262900 $Y=3925800
X279 54 55 862 305 863 425 221 864 104 DFFSXL $T=1280400 3880800 1 0 $X=1276100 $Y=3825000
X280 54 197 865 104 866 53 221 867 104 DFFSXL $T=1287000 3578400 0 0 $X=1282700 $Y=3574400
X281 54 60 868 305 869 428 221 870 104 DFFSXL $T=1300200 3981600 0 0 $X=1295900 $Y=3977600
X282 54 15 871 305 872 308 221 873 104 DFFSXL $T=1300200 4082400 1 0 $X=1295900 $Y=4026600
X283 37 28 874 82 875 74 221 876 104 DFFSXL $T=1425600 3780000 0 0 $X=1421300 $Y=3776000
X284 54 88 877 305 878 315 221 879 104 DFFSXL $T=1438800 4082400 1 0 $X=1434500 $Y=4026600
X285 54 114 114 82 880 314 221 881 104 DFFSXL $T=1485000 3981600 0 0 $X=1480700 $Y=3977600
X286 10 33 882 305 883 317 221 884 104 DFFSXL $T=1504800 4183200 0 0 $X=1500500 $Y=4179200
X287 54 40 885 82 886 432 221 887 104 DFFSXL $T=1518000 3981600 1 0 $X=1513700 $Y=3925800
X288 54 72 888 82 889 445 221 890 104 DFFSXL $T=1537800 3880800 1 0 $X=1533500 $Y=3825000
X289 54 87 891 82 892 84 221 893 104 DFFSXL $T=1557600 3780000 1 0 $X=1553300 $Y=3724200
X290 37 114 894 82 895 450 221 896 104 DFFSXL $T=1656600 4183200 1 0 $X=1652300 $Y=4127400
X291 37 119 897 82 898 86 221 899 104 DFFSXL $T=1669800 3780000 0 0 $X=1665500 $Y=3776000
X292 37 88 900 82 901 449 221 902 104 DFFSXL $T=1683000 3880800 0 0 $X=1678700 $Y=3876800
X293 37 60 903 82 904 451 221 905 104 DFFSXL $T=1683000 3981600 0 0 $X=1678700 $Y=3977600
X294 93 110 906 82 907 453 221 908 104 DFFSXL $T=1788600 3780000 1 0 $X=1784300 $Y=3724200
X295 93 88 909 82 910 457 221 911 104 DFFSXL $T=1795200 3880800 1 0 $X=1790900 $Y=3825000
X296 208 110 912 82 913 688 221 914 104 DFFSXL $T=1927200 3679200 0 0 $X=1922900 $Y=3675200
X297 208 55 915 82 916 687 221 917 104 DFFSXL $T=1927200 3780000 0 0 $X=1922900 $Y=3776000
X298 208 88 918 82 919 460 221 920 104 DFFSXL $T=1927200 3981600 0 0 $X=1922900 $Y=3977600
X299 208 49 921 82 922 320 221 923 104 DFFSXL $T=1940400 3981600 1 0 $X=1936100 $Y=3925800
X300 208 119 924 104 925 469 221 926 104 DFFSXL $T=2065800 3981600 1 0 $X=2061500 $Y=3925800
X301 100 49 927 104 928 471 221 929 104 DFFSXL $T=2072400 3880800 1 0 $X=2068100 $Y=3825000
X302 99 110 110 104 930 265 221 931 104 DFFSXL $T=2105400 3679200 1 0 $X=2101100 $Y=3623400
X303 100 55 55 104 932 209 221 933 104 DFFSXL $T=2105400 3780000 0 0 $X=2101100 $Y=3776000
X304 99 28 934 104 935 106 221 936 104 DFFSXL $T=2131800 3578400 0 0 $X=2127500 $Y=3574400
X305 99 122 937 104 938 692 221 939 104 DFFSXL $T=2197800 3880800 0 0 $X=2193500 $Y=3876800
X306 100 72 940 104 941 341 221 942 104 DFFSXL $T=2237400 3780000 1 0 $X=2233100 $Y=3724200
X307 99 88 943 104 944 322 221 945 104 DFFSXL $T=2244000 4082400 0 0 $X=2239700 $Y=4078400
X308 99 15 946 104 947 693 221 948 104 DFFSXL $T=2257200 4183200 0 0 $X=2252900 $Y=4179200
X309 100 122 949 104 950 475 221 951 104 DFFSXL $T=2336400 3880800 0 0 $X=2332100 $Y=3876800
X310 100 114 952 104 953 324 221 954 104 DFFSXL $T=2336400 3981600 1 0 $X=2332100 $Y=3925800
X311 100 119 955 104 956 571 221 957 104 DFFSXL $T=2402400 4183200 1 0 $X=2398100 $Y=4127400
X312 100 88 958 104 959 325 221 960 104 DFFSXL $T=2409000 4082400 1 0 $X=2404700 $Y=4026600
X313 100 15 961 104 962 326 221 963 104 DFFSXL $T=2409000 4082400 0 0 $X=2404700 $Y=4078400
X314 120 15 964 104 965 480 221 966 104 DFFSXL $T=2461800 3679200 0 0 $X=2457500 $Y=3675200
X315 120 49 967 104 968 464 221 969 104 DFFSXL $T=2461800 3780000 1 0 $X=2457500 $Y=3724200
X316 120 122 970 219 971 268 221 972 104 DFFSXL $T=2488200 3578400 0 0 $X=2483900 $Y=3574400
X317 100 60 973 104 974 111 221 975 104 DFFSXL $T=2488200 3981600 1 0 $X=2483900 $Y=3925800
X318 100 33 976 104 977 124 221 978 104 DFFSXL $T=2514600 3880800 1 0 $X=2510300 $Y=3825000
X319 137 705 979 219 980 487 221 272 104 DFFSXL $T=2824800 3578400 0 0 $X=2820500 $Y=3574400
X320 137 346 981 219 982 532 221 352 104 DFFSXL $T=2890800 3880800 1 0 $X=2886500 $Y=3825000
X321 137 712 983 219 984 533 221 545 104 DFFSXL $T=2897400 3679200 0 0 $X=2893100 $Y=3675200
X322 137 363 985 104 986 367 221 608 104 DFFSXL $T=3220800 3679200 1 0 $X=3216500 $Y=3623400
X323 137 301 987 104 988 366 221 769 104 DFFSXL $T=3227400 3578400 0 0 $X=3223100 $Y=3574400
X324 183 292 989 104 990 294 221 991 104 DFFSXL $T=3927000 3578400 0 0 $X=3922700 $Y=3574400
X325 461 221 90 104 INVX2 $T=1993200 3679200 0 180 $X=1969100 $Y=3623400
X326 235 221 182 104 INVX2 $T=3913800 4082400 0 180 $X=3889700 $Y=4026600
X327 428 42 104 433 992 221 683 AOI21XL $T=1432200 3981600 0 0 $X=1427900 $Y=3977600
X328 425 42 104 309 993 221 423 AOI21XL $T=1471800 3880800 0 180 $X=1441100 $Y=3825000
X329 328 492 104 331 994 221 761 AOI21XL $T=2620200 4082400 0 0 $X=2615900 $Y=4078400
X330 485 489 104 328 995 221 329 AOI21XL $T=2659800 4183200 0 180 $X=2629100 $Y=4127400
X331 334 695 104 496 996 221 336 AOI21XL $T=2679600 3880800 1 0 $X=2675300 $Y=3825000
X332 500 335 104 698 997 221 508 AOI21XL $T=2706000 3780000 1 0 $X=2701700 $Y=3724200
X333 129 699 104 700 998 221 513 AOI21XL $T=2765400 3880800 1 0 $X=2761100 $Y=3825000
X334 519 514 104 703 999 221 763 AOI21XL $T=2785200 3981600 1 0 $X=2780900 $Y=3925800
X335 515 523 104 519 1000 221 524 AOI21XL $T=2805000 3981600 0 0 $X=2800700 $Y=3977600
X336 537 551 104 536 1001 221 553 AOI21XL $T=3009600 4082400 0 0 $X=3005300 $Y=4078400
X337 527 564 104 569 1002 221 150 AOI21XL $T=3082200 3981600 1 0 $X=3077900 $Y=3925800
X338 724 147 104 568 1003 221 645 AOI21XL $T=3174600 3780000 1 0 $X=3170300 $Y=3724200
X339 556 583 104 586 1004 221 591 AOI21XL $T=3174600 3981600 1 0 $X=3170300 $Y=3925800
X340 597 595 104 731 1005 221 577 AOI21XL $T=3240600 4183200 1 0 $X=3236300 $Y=4127400
X341 616 616 104 615 1006 221 599 AOI21XL $T=3366000 3981600 1 0 $X=3361700 $Y=3925800
X342 618 604 104 371 1007 221 620 AOI21XL $T=3366000 4183200 1 0 $X=3361700 $Y=4127400
X343 629 375 104 634 1008 221 740 AOI21XL $T=3511200 3981600 1 180 $X=3480500 $Y=3977600
X344 745 636 104 746 1009 221 640 AOI21XL $T=3557400 3981600 1 0 $X=3553100 $Y=3925800
X345 651 652 104 748 1010 221 747 AOI21XL $T=3623400 3780000 1 180 $X=3592700 $Y=3776000
X346 380 381 104 651 1011 221 657 AOI21XL $T=3656400 3780000 0 0 $X=3652100 $Y=3776000
X347 659 657 104 658 1012 221 647 AOI21XL $T=3722400 3780000 1 180 $X=3691700 $Y=3776000
X348 667 778 104 752 1013 221 290 AOI21XL $T=3894000 3679200 1 0 $X=3889700 $Y=3623400
X349 26 221 679 1014 104 306 NAND2BXL $T=1227600 3981600 0 0 $X=1223300 $Y=3977600
X350 478 221 694 1015 104 490 NAND2BXL $T=2587200 3780000 1 0 $X=2582900 $Y=3724200
X351 481 221 488 1016 104 495 NAND2BXL $T=2600400 4082400 1 0 $X=2596100 $Y=4026600
X352 333 221 494 1017 104 502 NAND2BXL $T=2659800 3981600 1 0 $X=2655500 $Y=3925800
X353 697 221 493 1018 104 503 NAND2BXL $T=2679600 3578400 0 0 $X=2675300 $Y=3574400
X354 505 221 338 338 104 701 NAND2BXL $T=2739000 3679200 1 0 $X=2734700 $Y=3623400
X355 337 221 506 1019 104 522 NAND2BXL $T=2785200 3780000 0 0 $X=2780900 $Y=3776000
X356 518 221 512 1020 104 706 NAND2BXL $T=2791800 4183200 1 0 $X=2787500 $Y=4127400
X357 507 221 509 1021 104 707 NAND2BXL $T=2798400 3880800 1 0 $X=2794100 $Y=3825000
X358 510 221 511 1022 104 526 NAND2BXL $T=2844600 3880800 0 0 $X=2840300 $Y=3876800
X359 529 221 713 1023 104 345 NAND2BXL $T=2917200 4082400 1 180 $X=2886500 $Y=4078400
X360 530 221 349 1024 104 534 NAND2BXL $T=2956800 4183200 1 0 $X=2952500 $Y=4127400
X361 540 221 543 1025 104 547 NAND2BXL $T=2996400 3981600 1 0 $X=2992100 $Y=3925800
X362 546 221 539 1026 104 714 NAND2BXL $T=3049200 3880800 0 180 $X=3018500 $Y=3825000
X363 550 221 566 1027 104 723 NAND2BXL $T=3115200 3981600 0 0 $X=3110900 $Y=3977600
X364 554 221 561 1028 104 357 NAND2BXL $T=3154800 3780000 0 180 $X=3124100 $Y=3724200
X365 556 221 723 1029 104 579 NAND2BXL $T=3128400 3981600 1 0 $X=3124100 $Y=3925800
X366 365 221 600 1030 104 607 NAND2BXL $T=3319800 4082400 0 0 $X=3315500 $Y=4078400
X367 606 221 605 1031 104 738 NAND2BXL $T=3399000 3880800 0 0 $X=3394700 $Y=3876800
X368 623 221 610 1032 104 628 NAND2BXL $T=3418800 4082400 1 0 $X=3414500 $Y=4026600
X369 616 221 627 1033 104 632 NAND2BXL $T=3445200 3981600 1 0 $X=3440900 $Y=3925800
X370 636 221 627 1034 104 627 NAND2BXL $T=3511200 3981600 0 180 $X=3480500 $Y=3925800
X371 613 221 377 1035 104 650 NAND2BXL $T=3590400 3679200 0 0 $X=3586100 $Y=3675200
X372 661 221 663 1036 104 664 NAND2BXL $T=3748800 3679200 0 0 $X=3744500 $Y=3675200
X373 666 221 669 1037 104 670 NAND2BXL $T=3880800 3679200 0 0 $X=3876500 $Y=3675200
X374 104 142 435 478 221 NOR2XL $T=2534400 3780000 1 180 $X=2510300 $Y=3776000
X375 104 148 267 479 221 NOR2XL $T=2560800 4082400 1 180 $X=2536700 $Y=4078400
X376 104 339 437 481 221 NOR2XL $T=2574000 3981600 1 180 $X=2549900 $Y=3977600
X377 104 350 307 482 221 NOR2XL $T=2580600 4082400 0 180 $X=2556500 $Y=4026600
X378 104 479 482 485 221 NOR2XL $T=2587200 4082400 0 0 $X=2582900 $Y=4078400
X379 104 125 484 332 221 NOR2XL $T=2620200 3780000 1 0 $X=2615900 $Y=3724200
X380 104 487 215 333 221 NOR2XL $T=2626800 3880800 0 0 $X=2622500 $Y=3876800
X381 104 217 216 697 221 NOR2XL $T=2640000 3578400 0 0 $X=2635700 $Y=3574400
X382 104 478 332 695 221 NOR2XL $T=2653200 3780000 0 0 $X=2648900 $Y=3776000
X383 104 333 481 492 221 NOR2XL $T=2673000 4082400 0 180 $X=2648900 $Y=4026600
X384 104 500 335 698 221 NOR2XL $T=2679600 3780000 1 0 $X=2675300 $Y=3724200
X385 104 325 125 505 221 NOR2XL $T=2686200 3679200 0 0 $X=2681900 $Y=3675200
X386 104 121 487 507 221 NOR2XL $T=2712600 3880800 1 0 $X=2708300 $Y=3825000
X387 104 326 142 337 221 NOR2XL $T=2719200 3780000 0 0 $X=2714900 $Y=3776000
X388 104 324 148 518 221 NOR2XL $T=2719200 4183200 1 0 $X=2714900 $Y=4127400
X389 104 111 339 510 221 NOR2XL $T=2725800 3880800 0 0 $X=2721500 $Y=3876800
X390 104 337 505 699 221 NOR2XL $T=2745600 3780000 1 0 $X=2741300 $Y=3724200
X391 104 127 350 516 221 NOR2XL $T=2745600 3981600 0 0 $X=2741300 $Y=3977600
X392 104 507 510 514 221 NOR2XL $T=2758800 3981600 1 0 $X=2754500 $Y=3925800
X393 104 518 516 515 221 NOR2XL $T=2765400 4082400 1 0 $X=2761100 $Y=4026600
X394 104 532 417 530 221 NOR2XL $T=2943600 4082400 0 180 $X=2919500 $Y=4026600
X395 104 341 533 540 221 NOR2XL $T=2943600 3981600 1 0 $X=2939300 $Y=3925800
X396 104 533 311 529 221 NOR2XL $T=2963400 3981600 1 180 $X=2939300 $Y=3977600
X397 104 353 312 535 221 NOR2XL $T=2989800 3981600 1 180 $X=2965700 $Y=3977600
X398 104 529 530 542 221 NOR2XL $T=2983200 4082400 0 0 $X=2978900 $Y=4078400
X399 104 475 532 546 221 NOR2XL $T=2989800 3880800 0 0 $X=2985500 $Y=3876800
X400 104 223 271 719 221 NOR2XL $T=3036000 3578400 1 180 $X=3011900 $Y=3574400
X401 104 218 559 554 221 NOR2XL $T=3029400 3679200 0 0 $X=3025100 $Y=3675200
X402 104 535 716 551 221 NOR2XL $T=3029400 4082400 1 0 $X=3025100 $Y=4026600
X403 104 223 559 555 221 NOR2XL $T=3036000 3578400 0 0 $X=3031700 $Y=3574400
X404 104 128 549 562 221 NOR2XL $T=3049200 3780000 1 0 $X=3044900 $Y=3724200
X405 104 355 105 716 221 NOR2XL $T=3069000 3981600 1 180 $X=3044900 $Y=3977600
X406 104 544 563 717 221 NOR2XL $T=3062400 4183200 0 0 $X=3058100 $Y=4179200
X407 104 540 546 566 221 NOR2XL $T=3075600 3880800 0 0 $X=3071300 $Y=3876800
X408 104 223 549 720 221 NOR2XL $T=3102000 3679200 1 180 $X=3077900 $Y=3675200
X409 104 571 355 582 221 NOR2XL $T=3102000 3880800 0 0 $X=3097700 $Y=3876800
X410 104 471 353 578 221 NOR2XL $T=3128400 3880800 1 0 $X=3124100 $Y=3825000
X411 104 562 554 724 221 NOR2XL $T=3141600 3780000 0 0 $X=3137300 $Y=3776000
X412 104 578 582 583 221 NOR2XL $T=3194400 3880800 1 180 $X=3170300 $Y=3876800
X413 104 588 153 726 221 NOR2XL $T=3187800 4082400 1 0 $X=3183500 $Y=4026600
X414 104 364 726 592 221 NOR2XL $T=3194400 4183200 1 0 $X=3190100 $Y=4127400
X415 104 596 580 564 221 NOR2XL $T=3227400 3981600 0 180 $X=3203300 $Y=3925800
X416 104 367 9 364 221 NOR2XL $T=3253800 4082400 0 180 $X=3229700 $Y=4026600
X417 104 365 734 595 221 NOR2XL $T=3300000 4183200 0 180 $X=3275900 $Y=4127400
X418 104 223 573 603 221 NOR2XL $T=3286800 3679200 0 0 $X=3282500 $Y=3675200
X419 104 366 162 365 221 NOR2XL $T=3306600 3981600 0 180 $X=3282500 $Y=3925800
X420 104 369 298 734 221 NOR2XL $T=3306600 4082400 0 180 $X=3282500 $Y=4026600
X421 104 209 367 623 221 NOR2XL $T=3306600 3981600 1 0 $X=3302300 $Y=3925800
X422 104 222 366 606 221 NOR2XL $T=3313200 3880800 0 0 $X=3308900 $Y=3876800
X423 104 606 612 616 221 NOR2XL $T=3326400 3981600 1 0 $X=3322100 $Y=3925800
X424 104 220 602 613 221 NOR2XL $T=3333000 3679200 0 0 $X=3328700 $Y=3675200
X425 104 109 369 612 221 NOR2XL $T=3333000 3880800 1 0 $X=3328700 $Y=3825000
X426 104 223 165 614 221 NOR2XL $T=3352800 3679200 1 0 $X=3348500 $Y=3623400
X427 104 223 602 622 221 NOR2XL $T=3379200 3679200 1 0 $X=3374900 $Y=3623400
X428 104 166 588 624 221 NOR2XL $T=3405600 3981600 1 0 $X=3401300 $Y=3925800
X429 104 223 374 739 221 NOR2XL $T=3418800 3679200 0 0 $X=3414500 $Y=3675200
X430 104 623 624 627 221 NOR2XL $T=3438600 3981600 0 0 $X=3434300 $Y=3977600
X431 104 115 374 277 221 NOR2XL $T=3445200 3578400 0 0 $X=3440900 $Y=3574400
X432 104 223 617 741 221 NOR2XL $T=3451800 3679200 0 0 $X=3447500 $Y=3675200
X433 104 112 617 633 221 NOR2XL $T=3471600 3880800 1 0 $X=3467300 $Y=3825000
X434 104 227 639 279 221 NOR2XL $T=3550800 3679200 0 180 $X=3526700 $Y=3623400
X435 104 170 640 641 221 NOR2XL $T=3531000 3880800 1 0 $X=3526700 $Y=3825000
X436 104 745 636 746 221 NOR2XL $T=3531000 3981600 1 0 $X=3526700 $Y=3925800
X437 104 223 639 637 221 NOR2XL $T=3537600 3780000 1 0 $X=3533300 $Y=3724200
X438 104 223 640 743 221 NOR2XL $T=3557400 3780000 1 180 $X=3533300 $Y=3776000
X439 104 123 573 644 221 NOR2XL $T=3564000 3679200 0 0 $X=3559700 $Y=3675200
X440 104 229 772 631 221 NOR2XL $T=3636600 3679200 0 180 $X=3612500 $Y=3623400
X441 104 641 633 652 221 NOR2XL $T=3623400 3880800 1 0 $X=3619100 $Y=3825000
X442 104 613 644 380 221 NOR2XL $T=3649800 3780000 1 0 $X=3645500 $Y=3724200
X443 104 659 657 658 221 NOR2XL $T=3748800 3780000 1 180 $X=3724700 $Y=3776000
X444 104 287 662 661 221 NOR2XL $T=3768600 3679200 0 180 $X=3744500 $Y=3623400
X445 104 665 232 666 221 NOR2XL $T=3821400 3578400 0 0 $X=3817100 $Y=3574400
X446 104 666 234 778 221 NOR2XL $T=3867600 3679200 1 0 $X=3863300 $Y=3623400
X447 246 395 389 221 1038 247 104 OAI2BB1XL $T=666600 3578400 0 0 $X=662300 $Y=3574400
X448 77 400 677 221 1039 408 104 OAI2BB1XL $T=1069200 3679200 0 0 $X=1064900 $Y=3675200
X449 42 413 678 221 1040 254 104 OAI2BB1XL $T=1161600 3578400 0 0 $X=1157300 $Y=3574400
X450 83 410 410 221 1041 418 104 OAI2BB1XL $T=1267200 3880800 0 180 $X=1229900 $Y=3825000
X451 42 308 426 221 1042 427 104 OAI2BB1XL $T=1425600 3780000 1 180 $X=1388300 $Y=3776000
X452 42 432 431 221 1043 422 104 OAI2BB1XL $T=1438800 3880800 1 180 $X=1401500 $Y=3876800
X453 42 68 682 221 1044 309 104 OAI2BB1XL $T=1465200 3780000 0 180 $X=1427900 $Y=3724200
X454 83 316 444 221 1045 75 104 OAI2BB1XL $T=1577400 3679200 0 180 $X=1540100 $Y=3623400
X455 42 78 477 221 1046 313 104 OAI2BB1XL $T=1617000 3679200 1 180 $X=1579700 $Y=3675200
X456 83 450 448 221 1047 73 104 OAI2BB1XL $T=1676400 3880800 1 0 $X=1672100 $Y=3825000
X457 42 89 443 221 1048 484 104 OAI2BB1XL $T=1702800 3679200 1 0 $X=1698500 $Y=3623400
X458 489 497 483 221 1049 696 104 OAI2BB1XL $T=2620200 4183200 0 0 $X=2615900 $Y=4179200
X459 523 521 517 221 1050 708 104 OAI2BB1XL $T=2818200 4082400 1 0 $X=2813900 $Y=4026600
X460 560 558 351 221 1051 570 104 OAI2BB1XL $T=3069000 4082400 1 0 $X=3064700 $Y=4026600
X461 557 589 581 221 1052 575 104 OAI2BB1XL $T=3187800 4183200 1 180 $X=3150500 $Y=4179200
X462 579 585 361 221 1053 729 104 OAI2BB1XL $T=3240600 3880800 1 180 $X=3203300 $Y=3876800
X463 632 626 630 221 1054 737 104 OAI2BB1XL $T=3484800 3880800 1 180 $X=3447500 $Y=3876800
X464 381 656 642 221 1055 751 104 OAI2BB1XL $T=3696000 3679200 0 0 $X=3691700 $Y=3675200
X465 501 489 221 104 340 XNOR2XL $T=2725800 4183200 0 0 $X=2721500 $Y=4179200
X466 522 520 221 104 270 XNOR2XL $T=2811600 3780000 1 0 $X=2807300 $Y=3724200
X467 707 709 221 104 559 XNOR2XL $T=2831400 3880800 1 0 $X=2827100 $Y=3825000
X468 751 650 221 104 646 XNOR2XL $T=3715800 3578400 1 180 $X=3658700 $Y=3574400
X469 229 590 221 567 104 276 OAI21X1 $T=3201000 3578400 1 180 $X=3163700 $Y=3574400
X470 648 645 221 747 104 282 OAI21X1 $T=3603600 3780000 0 180 $X=3566300 $Y=3724200
X471 229 646 221 625 104 174 OAI21X1 $T=3610200 3578400 1 180 $X=3572900 $Y=3574400
X472 229 647 221 638 104 175 OAI21X1 $T=3610200 3679200 0 180 $X=3572900 $Y=3623400
X473 229 283 221 378 104 284 OAI21X1 $T=3630000 3578400 0 0 $X=3625700 $Y=3574400
X474 706 708 221 104 139 XNOR2X1 $T=2824800 4082400 0 0 $X=2820500 $Y=4078400
X475 710 523 221 104 134 XNOR2X1 $T=2910600 3981600 1 180 $X=2853500 $Y=3977600
X476 547 718 221 104 573 XNOR2X1 $T=3062400 3880800 1 0 $X=3058100 $Y=3825000
X477 732 579 221 104 602 XNOR2X1 $T=3253800 3880800 1 0 $X=3249500 $Y=3825000
X478 738 737 221 104 165 XNOR2X1 $T=3451800 3880800 0 180 $X=3394700 $Y=3825000
X479 742 632 221 104 639 XNOR2X1 $T=3524400 3880800 0 0 $X=3520100 $Y=3876800
X480 354 221 104 155 221 719 274 AOI211XL $T=3069000 3578400 0 0 $X=3064700 $Y=3574400
X481 352 221 104 155 221 720 567 AOI211XL $T=3069000 3679200 1 0 $X=3064700 $Y=3623400
X482 272 221 104 155 221 555 275 AOI211XL $T=3135000 3578400 1 180 $X=3097700 $Y=3574400
X483 769 221 104 155 221 614 225 AOI211XL $T=3366000 3578400 0 0 $X=3361700 $Y=3574400
X484 373 221 104 155 221 622 625 AOI211XL $T=3399000 3578400 0 0 $X=3394700 $Y=3574400
X485 608 221 104 155 221 739 278 AOI211XL $T=3438600 3679200 1 0 $X=3434300 $Y=3623400
X486 609 221 104 155 221 741 638 AOI211XL $T=3491400 3679200 0 0 $X=3487100 $Y=3675200
X487 770 221 104 155 221 637 378 AOI211XL $T=3491400 3780000 1 0 $X=3487100 $Y=3724200
X488 771 221 104 155 221 743 376 AOI211XL $T=3498000 3780000 0 0 $X=3493700 $Y=3776000
X489 754 296 52 1056 422 221 104 307 OR4XL $T=1386000 3679200 1 180 $X=1342100 $Y=3675200
X490 442 427 5 1057 424 221 104 435 OR4XL $T=1511400 3780000 0 180 $X=1467500 $Y=3724200
X491 631 603 155 155 155 221 104 173 OR4XL $T=3484800 3679200 1 0 $X=3480500 $Y=3623400
X492 486 696 221 104 343 XOR2X1 $T=2659800 4183200 0 0 $X=2655500 $Y=4179200
X493 701 702 221 104 130 XOR2X1 $T=2772000 3679200 1 0 $X=2767700 $Y=3623400
X494 526 524 221 104 271 XOR2X1 $T=2884200 3880800 0 0 $X=2879900 $Y=3876800
X495 728 729 221 104 617 XOR2X1 $T=3194400 3880800 1 0 $X=3190100 $Y=3825000
X496 607 620 221 104 735 XOR2X1 $T=3412200 4082400 1 180 $X=3355100 $Y=4078400
X497 628 740 221 104 374 XOR2X1 $T=3504600 4082400 0 180 $X=3447500 $Y=4026600
X498 11 122 1058 104 382 221 1059 104 14 110 1060 104 1061 241 1062 ICV_1 $T=66000 3679200 1 0 $X=61700 $Y=3623400
X499 11 87 1063 104 383 221 1064 104 14 87 1065 104 1066 384 1067 ICV_1 $T=151800 3679200 0 0 $X=147500 $Y=3675200
X500 18 110 1068 104 244 221 1069 104 14 16 1070 104 1071 31 1072 ICV_1 $T=396000 3578400 0 0 $X=391700 $Y=3574400
X501 14 122 1073 104 302 221 1074 104 18 197 1075 104 1076 674 1077 ICV_1 $T=402600 3780000 1 0 $X=398300 $Y=3724200
X502 23 21 1078 305 196 221 1079 104 25 122 1080 305 1081 399 1082 ICV_1 $T=666600 3780000 0 0 $X=662300 $Y=3776000
X503 10 15 1083 305 401 221 1084 104 10 87 1085 305 1086 198 1087 ICV_1 $T=825000 3981600 1 0 $X=820700 $Y=3925800
X504 10 21 1088 305 404 221 1089 104 37 15 1090 305 1091 416 1092 ICV_1 $T=970200 3981600 0 0 $X=965900 $Y=3977600
X505 10 40 1093 305 406 221 1094 104 37 122 1095 305 1096 410 1097 ICV_1 $T=970200 4082400 0 0 $X=965900 $Y=4078400
X506 37 199 1098 305 403 221 1099 104 54 110 1100 305 1101 407 1102 ICV_1 $T=1056000 3780000 0 0 $X=1051700 $Y=3776000
X507 10 88 1103 305 318 221 1104 104 10 114 1105 305 1106 319 1107 ICV_1 $T=1386000 4183200 1 0 $X=1381700 $Y=4127400
X508 54 21 1108 82 413 221 1109 104 54 33 1110 82 1111 203 1112 ICV_1 $T=1412400 3578400 0 0 $X=1408100 $Y=3574400
X509 10 72 1113 82 446 221 1114 104 37 33 1115 82 1116 316 1117 ICV_1 $T=1570800 4082400 0 0 $X=1566500 $Y=4078400
X510 29 40 1118 82 430 221 1119 104 93 40 1120 82 1121 456 1122 ICV_1 $T=1669800 3679200 0 0 $X=1665500 $Y=3675200
X511 29 15 1123 82 434 221 1124 104 93 15 1125 82 1126 685 1127 ICV_1 $T=1676400 3578400 0 0 $X=1672100 $Y=3574400
X512 37 72 1128 82 447 221 1129 104 93 55 1130 82 1131 455 1132 ICV_1 $T=1676400 3981600 1 0 $X=1672100 $Y=3925800
X513 93 119 1133 82 686 221 1134 104 208 15 1135 82 1136 458 1137 ICV_1 $T=1808400 3880800 0 0 $X=1804100 $Y=3876800
X514 208 60 1138 104 690 221 1139 104 99 119 1140 104 1141 472 1142 ICV_1 $T=2065800 3981600 0 0 $X=2061500 $Y=3977600
X515 99 55 1143 104 264 221 1144 104 99 72 1145 104 1146 473 1147 ICV_1 $T=2072400 3679200 0 0 $X=2068100 $Y=3675200
X516 99 49 49 104 470 221 1148 104 99 33 1149 104 1150 113 1151 ICV_1 $T=2105400 4082400 1 0 $X=2101100 $Y=4026600
X517 100 87 1152 104 116 221 1153 104 100 21 1154 104 1155 121 1156 ICV_1 $T=2257200 3880800 1 0 $X=2252900 $Y=3825000
X518 137 362 1157 104 353 221 609 104 137 372 1158 104 1159 369 770 ICV_1 $T=3220800 3780000 1 0 $X=3216500 $Y=3724200
X519 137 360 1160 104 355 221 373 104 137 368 1161 104 1162 588 771 ICV_1 $T=3220800 3780000 0 0 $X=3216500 $Y=3776000
X520 327 104 479 486 221 NOR2BX1 $T=2580600 4183200 0 0 $X=2576300 $Y=4179200
X521 725 104 578 728 221 NOR2BX1 $T=3174600 3780000 0 0 $X=3170300 $Y=3776000
X522 717 548 104 565 151 221 AOI21X1 $T=3069000 4183200 1 0 $X=3064700 $Y=4127400
X523 542 548 538 221 560 104 OAI2BB1X1 $T=3029400 4183200 1 0 $X=3025100 $Y=4127400
X524 42 66 104 221 754 AND2XL $T=1419000 3679200 1 180 $X=1388300 $Y=3675200
X525 83 451 104 221 433 AND2XL $T=1683000 4082400 0 180 $X=1652300 $Y=4026600
X526 221 545 104 221 155 AND2XL $T=3029400 3679200 1 0 $X=3025100 $Y=3623400
X527 139 213 221 104 273 OR2XL $T=2956800 3578400 0 0 $X=2952500 $Y=3574400
X528 29 16 1163 305 249 221 1164 104 DFFSX1 $T=811800 3578400 0 0 $X=807500 $Y=3574400
X529 137 711 1165 219 339 221 354 104 DFFSX1 $T=2890800 3780000 1 0 $X=2886500 $Y=3724200
X530 137 525 1166 219 350 221 144 104 DFFSX1 $T=2897400 3679200 1 0 $X=2893100 $Y=3623400
X531 383 104 193 20 384 242 221 AOI22XL $T=297000 3578400 0 0 $X=292700 $Y=3574400
X532 382 104 193 20 302 243 221 AOI22XL $T=343200 3679200 1 0 $X=338900 $Y=3623400
X533 386 104 193 20 303 389 221 AOI22XL $T=468600 3679200 0 0 $X=464300 $Y=3675200
X534 396 104 246 194 674 393 221 AOI22XL $T=686400 3679200 1 180 $X=649100 $Y=3675200
X535 252 104 71 39 405 677 221 AOI22XL $T=1069200 3679200 1 0 $X=1064900 $Y=3623400
X536 204 104 77 71 317 444 221 AOI22XL $T=1617000 3679200 0 180 $X=1579700 $Y=3623400
X537 205 104 77 71 319 448 221 AOI22XL $T=1623600 3780000 0 0 $X=1619300 $Y=3776000
X538 685 104 96 97 458 459 221 AOI22XL $T=1933800 3780000 1 0 $X=1929500 $Y=3724200
X539 693 104 211 210 326 467 221 AOI22XL $T=2376000 3780000 0 0 $X=2371700 $Y=3776000
X540 480 104 261 107 214 323 221 AOI22XL $T=2475000 3679200 0 180 $X=2437700 $Y=3623400
X541 77 402 104 675 71 39 251 403 221 AOI222X1 $T=1009800 3679200 0 0 $X=1005500 $Y=3675200
X542 42 201 104 77 77 71 71 310 221 AOI222X1 $T=1531200 3679200 0 180 $X=1474100 $Y=3623400
X543 473 211 104 341 210 123 477 107 221 AOI222X1 $T=2395800 3780000 1 0 $X=2391500 $Y=3724200
X544 472 211 104 571 210 107 476 220 221 AOI222X1 $T=2409000 3780000 0 0 $X=2404700 $Y=3776000
X545 77 200 104 41 42 71 409 410 221 AOI222XL $T=1161600 3679200 0 180 $X=1104500 $Y=3623400
X546 77 59 104 404 71 39 412 678 221 AOI222XL $T=1221000 3679200 1 180 $X=1163900 $Y=3675200
X547 77 63 104 304 71 39 256 680 221 AOI222XL $T=1386000 3679200 0 180 $X=1328900 $Y=3623400
X548 71 257 104 415 39 77 258 682 221 AOI222XL $T=1392600 3679200 1 0 $X=1388300 $Y=3623400
X549 83 414 104 430 77 71 406 431 221 AOI222XL $T=1399200 3981600 1 0 $X=1394900 $Y=3925800
X550 42 70 104 434 77 71 401 426 221 AOI222XL $T=1485000 3679200 1 180 $X=1427900 $Y=3675200
X551 77 76 104 446 71 83 447 441 221 AOI222XL $T=1570800 3880800 0 0 $X=1566500 $Y=3876800
X552 83 449 104 206 85 71 318 439 221 AOI222XL $T=1676400 3679200 0 180 $X=1619300 $Y=3623400
X553 261 464 104 207 96 97 320 320 221 AOI222XL $T=2039400 3578400 1 180 $X=1982300 $Y=3574400
X554 210 471 104 211 470 112 107 758 221 AOI222XL $T=2323200 3679200 1 0 $X=2318900 $Y=3623400
X555 692 211 104 475 210 107 128 691 221 AOI222XL $T=2343000 3679200 0 0 $X=2338700 $Y=3675200
X556 322 211 104 325 117 117 118 474 221 AOI222XL $T=2376000 3679200 1 0 $X=2371700 $Y=3623400
X557 211 212 104 324 117 117 213 266 221 AOI222XL $T=2409000 3578400 0 0 $X=2404700 $Y=3574400
X558 297 298 221 104 CLKBUFX3 $T=1471800 3880800 1 0 $X=1467500 $Y=3825000
X559 300 4 221 104 CLKBUFX3 $T=1834800 3679200 1 0 $X=1830500 $Y=3623400
X560 320 95 221 104 CLKBUFX3 $T=1973400 3679200 0 180 $X=1942700 $Y=3623400
X561 474 8 221 104 CLKBUFX3 $T=2349600 3578400 1 180 $X=2318900 $Y=3574400
X562 691 221 104 397 BUFXL $T=2310000 3578400 1 180 $X=2279300 $Y=3574400
X563 391 221 104 239 BUFX1 $T=561000 4082400 0 180 $X=530300 $Y=4026600
X564 392 221 104 192 BUFX1 $T=600600 4082400 0 180 $X=569900 $Y=4026600
X565 758 221 104 452 BUFX1 $T=2303400 3679200 0 180 $X=2272700 $Y=3623400
X566 465 221 321 466 461 98 104 NAND4XL $T=2026200 3679200 1 0 $X=2021900 $Y=3623400
X567 467 221 323 459 442 463 104 NAND4XL $T=2065800 3880800 0 180 $X=2028500 $Y=3825000
X568 454 221 101 262 300 468 104 NAND4XL $T=2105400 3578400 1 180 $X=2068100 $Y=3574400
X569 387 193 104 20 388 438 221 AOI22X1 $T=521400 3880800 1 0 $X=517100 $Y=3825000
X570 385 193 104 20 390 463 221 AOI22X1 $T=528000 3780000 0 0 $X=523700 $Y=3776000
X571 457 96 104 97 460 299 221 AOI22X1 $T=2032800 3780000 0 180 $X=1995500 $Y=3724200
X572 92 104 104 221 CLKINVX4 $T=1907400 3679200 1 0 $X=1903100 $Y=3623400
X573 92 82 221 104 INVX4 $T=1788600 3679200 0 180 $X=1757900 $Y=3623400
X574 92 221 305 104 CLKINVX8 $T=1742400 3780000 0 180 $X=1698500 $Y=3724200
X575 394 104 221 12 CLKBUFX2 $T=620400 3880800 0 180 $X=589700 $Y=3825000
X576 22 104 221 296 CLKBUFX2 $T=686400 3679200 0 0 $X=682100 $Y=3675200
X577 399 104 221 187 CLKBUFX2 $T=778800 3679200 1 180 $X=748100 $Y=3675200
X578 51 104 221 189 CLKBUFX2 $T=871200 3880800 1 180 $X=840500 $Y=3876800
X579 65 104 221 191 CLKBUFX2 $T=871200 4082400 0 180 $X=840500 $Y=4026600
X580 34 104 221 190 CLKBUFX2 $T=996600 3679200 0 180 $X=965900 $Y=3623400
X581 56 104 221 188 CLKBUFX2 $T=1300200 3880800 1 180 $X=1269500 $Y=3876800
X582 299 104 221 6 CLKBUFX2 $T=1531200 3780000 1 0 $X=1526900 $Y=3724200
X583 445 104 42 440 221 313 436 AOI211X1 $T=1557600 3880800 1 180 $X=1520300 $Y=3876800
X584 429 221 1 104 27 424 NAND3XL $T=1419000 3780000 0 180 $X=1388300 $Y=3724200
X585 683 221 19 104 71 437 NAND3XL $T=1465200 3981600 1 0 $X=1460900 $Y=3925800
X586 2 221 436 104 7 311 NAND3XL $T=1504800 3880800 1 180 $X=1474100 $Y=3876800
X587 423 221 9 104 9 NAND2X1 $T=1359600 3880800 0 0 $X=1355300 $Y=3876800
X588 452 221 32 421 62 312 104 NAND4X1 $T=1333200 3780000 0 0 $X=1328900 $Y=3776000
X589 50 17 420 680 221 104 421 AND4XL $T=1280400 3679200 0 0 $X=1276100 $Y=3675200
X590 418 398 195 306 104 221 417 OR4X1 $T=1260600 3880800 1 180 $X=1216700 $Y=3876800
X591 39 83 221 104 CLKBUFX4 $T=1194600 3880800 1 0 $X=1190300 $Y=3825000
X592 407 42 104 42 253 221 408 411 AOI221XL $T=1108800 3578400 0 0 $X=1104500 $Y=3574400
.ENDS
***************************************
.SUBCKT NOR2BXL AN VDD B Y VSS
** N=7 EP=5 IP=0 FDC=6
M0 VSS AN 6 VSS n18 L=1.8e-07 W=3e-07 $X=6600 $Y=13200 $D=6
M1 Y B VSS VSS n18 L=1.8e-07 W=4.2e-07 $X=12700 $Y=10900 $D=6
M2 VSS 6 Y VSS n18 L=1.8e-07 W=4.2e-07 $X=19900 $Y=10900 $D=6
M3 VDD AN 6 VDD p18 L=1.8e-07 W=4.2e-07 $X=6200 $Y=29300 $D=10
M4 7 B VDD VDD p18 L=1.8e-07 W=8.4e-07 $X=12800 $Y=29300 $D=10
M5 Y 6 7 VDD p18 L=1.8e-07 W=8.4e-07 $X=18400 $Y=29300 $D=10
.ENDS
***************************************
.SUBCKT ADDFX1 B A CI CO VSS VDD S
** N=15 EP=7 IP=0 FDC=30
M0 VSS B 10 VSS n18 L=1.8e-07 W=1.2e-06 $X=6200 $Y=6200 $D=6
M1 8 10 VSS VSS n18 L=1.8e-07 W=8.4e-07 $X=14250 $Y=9800 $D=6
M2 13 9 8 VSS n18 L=1.8e-07 W=6.4e-07 $X=21450 $Y=11800 $D=6
M3 9 8 13 VSS n18 L=1.8e-07 W=4.2e-07 $X=31300 $Y=14000 $D=6
M4 VSS A 9 VSS n18 L=1.8e-07 W=6e-07 $X=38550 $Y=12200 $D=6
M5 9 A VSS VSS n18 L=1.8e-07 W=6e-07 $X=44550 $Y=13600 $D=6
M6 14 10 9 VSS n18 L=1.8e-07 W=4.2e-07 $X=52500 $Y=13700 $D=6
M7 10 9 14 VSS n18 L=1.8e-07 W=6.4e-07 $X=60400 $Y=11500 $D=6
M8 12 14 10 VSS n18 L=1.8e-07 W=4.2e-07 $X=72850 $Y=15450 $D=6
M9 11 13 12 VSS n18 L=1.8e-07 W=4.2e-07 $X=80050 $Y=15450 $D=6
M10 VSS CI 11 VSS n18 L=1.8e-07 W=4.2e-07 $X=87650 $Y=10800 $D=6
M11 15 CI 13 VSS n18 L=1.8e-07 W=4.2e-07 $X=101150 $Y=13050 $D=6
M12 14 11 15 VSS n18 L=1.8e-07 W=4.2e-07 $X=108350 $Y=13050 $D=6
M13 VSS 12 CO VSS n18 L=1.8e-07 W=6e-07 $X=121100 $Y=12200 $D=6
M14 S 15 VSS VSS n18 L=1.8e-07 W=6e-07 $X=129500 $Y=12200 $D=6
M15 VDD B 10 VDD p18 L=1.82027e-07 W=1.79314e-06 $X=5400 $Y=33800 $D=10
M16 8 10 VDD VDD p18 L=1.8e-07 W=1.26e-06 $X=12250 $Y=27100 $D=10
M17 14 9 8 VDD p18 L=1.8e-07 W=9.6e-07 $X=20450 $Y=27200 $D=10
M18 9 8 14 VDD p18 L=1.8e-07 W=6.4e-07 $X=30900 $Y=28200 $D=10
M19 VDD A 9 VDD p18 L=1.8e-07 W=9e-07 $X=40550 $Y=29000 $D=10
M20 9 A VDD VDD p18 L=1.8e-07 W=9e-07 $X=47350 $Y=29000 $D=10
M21 13 10 9 VDD p18 L=1.8e-07 W=6.4e-07 $X=54550 $Y=29200 $D=10
M22 10 9 13 VDD p18 L=1.8e-07 W=9.6e-07 $X=61750 $Y=31000 $D=10
M23 12 13 10 VDD p18 L=1.8e-07 W=6.4e-07 $X=68950 $Y=32650 $D=10
M24 11 14 12 VDD p18 L=1.8e-07 W=6.4e-07 $X=76150 $Y=32650 $D=10
M25 VDD CI 11 VDD p18 L=1.8e-07 W=6.4e-07 $X=84750 $Y=33800 $D=10
M26 15 11 13 VDD p18 L=1.8e-07 W=6.4e-07 $X=98350 $Y=30800 $D=10
M27 14 CI 15 VDD p18 L=1.8e-07 W=6.4e-07 $X=105550 $Y=30800 $D=10
M28 VDD 12 CO VDD p18 L=1.8e-07 W=9e-07 $X=120950 $Y=27550 $D=10
M29 S 15 VDD VDD p18 L=1.8e-07 W=9e-07 $X=129500 $Y=27550 $D=10
.ENDS
***************************************
.SUBCKT CMPR32X1 B A C 4 CO 6 VSS VDD S
** N=15 EP=9 IP=0 FDC=30
M0 VSS B 12 VSS n18 L=1.8e-07 W=1.2e-06 $X=6200 $Y=6200 $D=6
M1 10 12 VSS VSS n18 L=1.8e-07 W=8.4e-07 $X=14250 $Y=9800 $D=6
M2 15 11 10 VSS n18 L=1.8e-07 W=6.4e-07 $X=21450 $Y=11800 $D=6
M3 11 10 15 VSS n18 L=1.8e-07 W=4.2e-07 $X=31300 $Y=14000 $D=6
M4 VSS A 11 VSS n18 L=1.8e-07 W=6e-07 $X=38550 $Y=12200 $D=6
M5 11 A VSS VSS n18 L=1.8e-07 W=6e-07 $X=44550 $Y=13600 $D=6
M6 4 12 11 VSS n18 L=1.8e-07 W=4.2e-07 $X=52500 $Y=13700 $D=6
M7 12 11 4 VSS n18 L=1.8e-07 W=6.4e-07 $X=60400 $Y=11500 $D=6
M8 14 4 12 VSS n18 L=1.8e-07 W=4.2e-07 $X=72850 $Y=15450 $D=6
M9 13 15 14 VSS n18 L=1.8e-07 W=4.2e-07 $X=80050 $Y=15450 $D=6
M10 VSS C 13 VSS n18 L=1.8e-07 W=4.2e-07 $X=87650 $Y=10800 $D=6
M11 6 C 15 VSS n18 L=1.8e-07 W=4.2e-07 $X=101150 $Y=13050 $D=6
M12 4 13 6 VSS n18 L=1.8e-07 W=4.2e-07 $X=108350 $Y=13050 $D=6
M13 VSS 14 CO VSS n18 L=1.8e-07 W=6e-07 $X=121100 $Y=12200 $D=6
M14 S 6 VSS VSS n18 L=1.8e-07 W=6e-07 $X=129500 $Y=12200 $D=6
M15 VDD B 12 VDD p18 L=1.82027e-07 W=1.79314e-06 $X=5400 $Y=33800 $D=10
M16 10 12 VDD VDD p18 L=1.8e-07 W=1.26e-06 $X=12250 $Y=27100 $D=10
M17 4 11 10 VDD p18 L=1.8e-07 W=9.6e-07 $X=20450 $Y=27200 $D=10
M18 11 10 4 VDD p18 L=1.8e-07 W=6.4e-07 $X=30900 $Y=28200 $D=10
M19 VDD A 11 VDD p18 L=1.8e-07 W=9e-07 $X=40550 $Y=29000 $D=10
M20 11 A VDD VDD p18 L=1.8e-07 W=9e-07 $X=47350 $Y=29000 $D=10
M21 15 12 11 VDD p18 L=1.8e-07 W=6.4e-07 $X=54550 $Y=29200 $D=10
M22 12 11 15 VDD p18 L=1.8e-07 W=9.6e-07 $X=61750 $Y=31000 $D=10
M23 14 15 12 VDD p18 L=1.8e-07 W=6.4e-07 $X=68950 $Y=32650 $D=10
M24 13 4 14 VDD p18 L=1.8e-07 W=6.4e-07 $X=76150 $Y=32650 $D=10
M25 VDD C 13 VDD p18 L=1.8e-07 W=6.4e-07 $X=84750 $Y=33800 $D=10
M26 6 13 15 VDD p18 L=1.8e-07 W=6.4e-07 $X=98350 $Y=30800 $D=10
M27 4 C 6 VDD p18 L=1.8e-07 W=6.4e-07 $X=105550 $Y=30800 $D=10
M28 VDD 14 CO VDD p18 L=1.8e-07 W=9e-07 $X=120950 $Y=27550 $D=10
M29 S 6 VDD VDD p18 L=1.8e-07 W=9e-07 $X=129500 $Y=27550 $D=10
.ENDS
***************************************
.SUBCKT AND2X4 A B VSS VDD Y
** N=7 EP=5 IP=0 FDC=8
M0 7 A 6 VSS n18 L=1.85215e-07 W=1.30713e-06 $X=4700 $Y=5750 $D=6
M1 VSS B 7 VSS n18 L=1.90638e-07 W=1.30299e-06 $X=10600 $Y=5750 $D=6
M2 Y 6 VSS VSS n18 L=1.85791e-07 W=1.17713e-06 $X=17800 $Y=12250 $D=6
M3 VSS 6 Y VSS n18 L=1.85791e-07 W=1.17713e-06 $X=24900 $Y=7050 $D=6
M4 6 A VDD VDD p18 L=1.8e-07 W=1.2e-06 $X=4600 $Y=27750 $D=10
M5 VDD B 6 VDD p18 L=1.8e-07 W=1.2e-06 $X=11800 $Y=27750 $D=10
M6 Y 6 VDD VDD p18 L=1.83772e-07 W=1.80713e-06 $X=17800 $Y=27250 $D=10
M7 VDD 6 Y VDD p18 L=1.83772e-07 W=1.80713e-06 $X=24900 $Y=35000 $D=10
.ENDS
***************************************
.SUBCKT OAI211XL A1 A0 VSS C0 VDD B0 Y
** N=10 EP=7 IP=0 FDC=8
M0 VSS A1 8 VSS n18 L=1.8e-07 W=6.6e-07 $X=6200 $Y=7600 $D=6
M1 8 A0 VSS VSS n18 L=1.8e-07 W=6.6e-07 $X=14200 $Y=7600 $D=6
M2 9 C0 8 VSS n18 L=1.8e-07 W=6.6e-07 $X=21400 $Y=7600 $D=6
M3 Y B0 9 VSS n18 L=1.8e-07 W=6.6e-07 $X=27400 $Y=10400 $D=6
M4 10 A1 VDD VDD p18 L=1.8e-07 W=8.4e-07 $X=6200 $Y=31000 $D=10
M5 Y A0 10 VDD p18 L=1.8e-07 W=8.4e-07 $X=12600 $Y=31000 $D=10
M6 VDD C0 Y VDD p18 L=1.8e-07 W=6.4e-07 $X=19800 $Y=33000 $D=10
M7 Y B0 VDD VDD p18 L=1.8e-07 W=6.4e-07 $X=27800 $Y=33000 $D=10
.ENDS
***************************************
.SUBCKT CLKINVX3 A VDD Y VSS
** N=4 EP=4 IP=0 FDC=4
M0 Y A VSS VSS n18 L=1.8e-07 W=5.1e-07 $X=4600 $Y=13100 $D=6
M1 VSS A Y VSS n18 L=1.8e-07 W=5.1e-07 $X=11800 $Y=13100 $D=6
M2 Y A VDD VDD p18 L=1.8e-07 W=1.23e-06 $X=4600 $Y=27000 $D=10
M3 VDD A Y VDD p18 L=1.8e-07 W=1.47e-06 $X=11800 $Y=27000 $D=10
.ENDS
***************************************
.SUBCKT BUFX12 A Y VSS VDD
** N=5 EP=4 IP=0 FDC=18
M0 VSS A 5 VSS n18 L=1.8e-07 W=4.2e-07 $X=6200 $Y=13100 $D=6
M1 5 A VSS VSS n18 L=1.83022e-07 W=1.20314e-06 $X=12600 $Y=10700 $D=6
M2 VSS A 5 VSS n18 L=1.83022e-07 W=1.20314e-06 $X=19000 $Y=5700 $D=6
M3 Y 5 VSS VSS n18 L=1.83022e-07 W=1.20314e-06 $X=25400 $Y=12200 $D=6
M4 VSS 5 Y VSS n18 L=1.83022e-07 W=1.20314e-06 $X=31800 $Y=5700 $D=6
M5 Y 5 VSS VSS n18 L=1.83022e-07 W=1.20314e-06 $X=38200 $Y=12200 $D=6
M6 VSS 5 Y VSS n18 L=1.83022e-07 W=1.20314e-06 $X=44600 $Y=5700 $D=6
M7 Y 5 VSS VSS n18 L=1.83022e-07 W=1.20314e-06 $X=51000 $Y=12200 $D=6
M8 VSS 5 Y VSS n18 L=1.83022e-07 W=1.20314e-06 $X=57400 $Y=5700 $D=6
M9 VDD A 5 VDD p18 L=1.82563e-07 W=1.41814e-06 $X=5400 $Y=32500 $D=10
M10 5 A VDD VDD p18 L=1.82563e-07 W=1.41814e-06 $X=11800 $Y=27000 $D=10
M11 VDD A 5 VDD p18 L=1.82563e-07 W=1.41814e-06 $X=18200 $Y=32500 $D=10
M12 Y 5 VDD VDD p18 L=1.82016e-07 W=1.80314e-06 $X=24600 $Y=27000 $D=10
M13 VDD 5 Y VDD p18 L=1.82016e-07 W=1.80314e-06 $X=31000 $Y=34600 $D=10
M14 Y 5 VDD VDD p18 L=1.82016e-07 W=1.80314e-06 $X=37400 $Y=27000 $D=10
M15 VDD 5 Y VDD p18 L=1.82016e-07 W=1.80314e-06 $X=43800 $Y=34600 $D=10
M16 Y 5 VDD VDD p18 L=1.82016e-07 W=1.80314e-06 $X=51200 $Y=27000 $D=10
M17 VDD 5 Y VDD p18 L=1.82016e-07 W=1.80314e-06 $X=57600 $Y=34600 $D=10
.ENDS
***************************************
.SUBCKT AND2X2 A VDD B VSS Y
** N=7 EP=5 IP=0 FDC=6
M0 7 A 6 VSS n18 L=1.8e-07 W=6.2e-07 $X=6200 $Y=12100 $D=6
M1 VSS B 7 VSS n18 L=1.8e-07 W=6.2e-07 $X=12000 $Y=12100 $D=6
M2 Y 6 VSS VSS n18 L=1.8e-07 W=1.2e-06 $X=18000 $Y=6300 $D=6
M3 6 A VDD VDD p18 L=1.8e-07 W=7e-07 $X=4800 $Y=27000 $D=10
M4 VDD B 6 VDD p18 L=1.8e-07 W=7e-07 $X=12000 $Y=27000 $D=10
M5 Y 6 VDD VDD p18 L=1.8e-07 W=1.7e-06 $X=18000 $Y=27000 $D=10
.ENDS
***************************************
.SUBCKT NOR3XL C VDD B VSS A Y
** N=8 EP=6 IP=0 FDC=6
M0 Y C VSS VSS n18 L=1.8e-07 W=4.2e-07 $X=4600 $Y=11450 $D=6
M1 VSS B Y VSS n18 L=1.8e-07 W=4.2e-07 $X=11800 $Y=11450 $D=6
M2 Y A VSS VSS n18 L=1.8e-07 W=4.2e-07 $X=18400 $Y=11450 $D=6
M3 7 C VDD VDD p18 L=1.8e-07 W=9.8e-07 $X=6200 $Y=29050 $D=10
M4 8 B 7 VDD p18 L=1.8e-07 W=9.8e-07 $X=12350 $Y=29050 $D=10
M5 Y A 8 VDD p18 L=1.8e-07 W=9.8e-07 $X=18200 $Y=29050 $D=10
.ENDS
***************************************
.SUBCKT NOR3X2 A VSS B C Y VDD
** N=10 EP=6 IP=0 FDC=9
M0 Y C VSS VSS n18 L=1.8e-07 W=1.2e-06 $X=6200 $Y=5700 $D=6
M1 VSS B Y VSS n18 L=1.8e-07 W=1.2e-06 $X=13400 $Y=5700 $D=6
M2 Y A VSS VSS n18 L=1.8e-07 W=1.2e-06 $X=20600 $Y=5700 $D=6
M3 7 C VDD VDD p18 L=1.8e-07 W=1.4e-06 $X=6200 $Y=30700 $D=10
M4 8 B 7 VDD p18 L=1.8e-07 W=1.4e-06 $X=12350 $Y=30700 $D=10
M5 Y A 8 VDD p18 L=1.8e-07 W=1.4e-06 $X=18200 $Y=30700 $D=10
M6 9 A Y VDD p18 L=1.8e-07 W=1.4e-06 $X=25400 $Y=27450 $D=10
M7 10 B 9 VDD p18 L=1.8e-07 W=1.4e-06 $X=31000 $Y=27450 $D=10
M8 VDD C 10 VDD p18 L=1.8e-07 W=1.4e-06 $X=36600 $Y=27450 $D=10
.ENDS
***************************************
.SUBCKT NAND3BXL AN VSS C B VDD Y
** N=9 EP=6 IP=0 FDC=8
M0 VSS AN 7 VSS n18 L=1.8e-07 W=3e-07 $X=6600 $Y=10550 $D=6
M1 8 C VSS VSS n18 L=1.8e-07 W=6.6e-07 $X=13200 $Y=5700 $D=6
M2 9 B 8 VSS n18 L=1.8e-07 W=6.6e-07 $X=18800 $Y=5700 $D=6
M3 Y 7 9 VSS n18 L=1.8e-07 W=6.6e-07 $X=24400 $Y=5700 $D=6
M4 VDD AN 7 VDD p18 L=1.8e-07 W=4.2e-07 $X=6200 $Y=31700 $D=10
M5 Y C VDD VDD p18 L=1.8e-07 W=6.4e-07 $X=12200 $Y=30600 $D=10
M6 VDD B Y VDD p18 L=1.8e-07 W=6.4e-07 $X=19400 $Y=30600 $D=10
M7 Y 7 VDD VDD p18 L=1.8e-07 W=6.4e-07 $X=25400 $Y=30600 $D=10
.ENDS
***************************************
.SUBCKT NOR4BX1 AN VDD D C B Y VSS
** N=11 EP=7 IP=0 FDC=10
M0 VSS AN 8 VSS n18 L=1.8e-07 W=3.6e-07 $X=6600 $Y=10550 $D=6
M1 Y D VSS VSS n18 L=1.8e-07 W=6e-07 $X=12600 $Y=10550 $D=6
M2 VSS C Y VSS n18 L=1.8e-07 W=6e-07 $X=19800 $Y=10200 $D=6
M3 Y B VSS VSS n18 L=1.8e-07 W=6e-07 $X=25800 $Y=10200 $D=6
M4 VSS 8 Y VSS n18 L=1.8e-07 W=6e-07 $X=33000 $Y=10200 $D=6
M5 VDD AN 8 VDD p18 L=1.8e-07 W=5.4e-07 $X=6200 $Y=29300 $D=10
M6 9 D VDD VDD p18 L=1.8e-07 W=1.54e-06 $X=13200 $Y=29300 $D=10
M7 10 C 9 VDD p18 L=1.8e-07 W=1.54e-06 $X=18800 $Y=29300 $D=10
M8 11 B 10 VDD p18 L=1.8e-07 W=1.54e-06 $X=24600 $Y=29300 $D=10
M9 Y 8 11 VDD p18 L=1.8e-07 W=1.54e-06 $X=30200 $Y=29300 $D=10
.ENDS
***************************************
.SUBCKT ICV_3 3 4 5 6 7 8 9 10 11 12 13 14 15 16 17 18 19 20 21 22
+ 23 24 25 26 27 28 29 31 32 34 35 36 37 38 39 40 41 42 43 44
+ 45 46 47 48 50 51 52 53 54 56 57 58 60 61 62 63 64 65 66 67
+ 68 69 70 71 74 75 76 77 78 80 83 84 85 87 88 89 90 91 92 93
+ 97 98 100 101 103 105 106 107 108 109 110 111 112 114 115 116 118 119 120 122
+ 124 125 127 128 129 130 131 132 133 134 135 136 137 141 143 144 145 146 147 148
+ 151 152 153 154 155 156 157 158 159 160 161 162 163 164 165 167 168 169 170 172
+ 173 174 175 176 177 178 179 180 181 182 183 184 185 186 187 188 189 190 192 193
+ 194 195 196 197 198 199 201 202 203 206 207 208 210 211 213 214 216 217 218 220
+ 221 222 223 224 228 230 234 235 237 238 242 243 245 246 247 248 250 252 253 255
+ 257 263 267 268 270 273 275 276 277 279 281 282 283 284 286 287 288 289 291 292
+ 293 294 295 296 297 298 299 300 301 302 303 304 305 306 307 308 309 310 311 312
+ 313 314 315 316 317 318 319 320 321 322 323 324 325 326 327 328 329 331 332 333
+ 334 335 336 337 338 339 340 341 342 343 344 345 346 347 348 349 350 351 352 353
+ 355 356 357 358 359 360 361 362 363 364 365 366 367 368 369 370 371 372 373 374
+ 375 376 377 378 379 380 381 382 383 384 385 387 388 389 391 392 393 394 396 397
+ 398 399 400 401 402 403 404 405 406 407 408 409 410 411 412 413 414 415 416 417
+ 418 419 420 421 422 423 425 426 427 428 429 430 431 432 433 434 435 436
*.CALIBRE ICV_CELL 2
** N=1267 EP=358 IP=3198 FDC=7296
M0 36 795 189 189 n18 L=1.8e-07 W=1.18e-06 $X=490400 $Y=3460100 $D=6
M1 189 32 36 189 n18 L=1.8e-07 W=1.18e-06 $X=497600 $Y=3460100 $D=6
M2 36 731 189 189 n18 L=1.8e-07 W=1.18e-06 $X=505600 $Y=3460100 $D=6
M3 189 502 36 189 n18 L=1.8e-07 W=1.18e-06 $X=512800 $Y=3460100 $D=6
M4 795 35 189 189 n18 L=1.8e-07 W=7.2e-07 $X=520000 $Y=3464700 $D=6
M5 1259 373 799 189 n18 L=1.8e-07 W=8.2e-07 $X=865100 $Y=3084600 $D=6
M6 1260 524 1259 189 n18 L=1.8e-07 W=8.2e-07 $X=870700 $Y=3084600 $D=6
M7 1261 43 1260 189 n18 L=1.8e-07 W=8.2e-07 $X=876300 $Y=3084600 $D=6
M8 189 527 1261 189 n18 L=1.8e-07 W=8.2e-07 $X=881900 $Y=3084600 $D=6
M9 567 799 189 189 n18 L=1.8e-07 W=1.2e-06 $X=889300 $Y=3080800 $D=6
M10 1262 502 14 14 p18 L=1.8e-07 W=1.64e-06 $X=469600 $Y=3432900 $D=10
M11 1263 731 1262 14 p18 L=1.8e-07 W=1.64e-06 $X=475200 $Y=3432900 $D=10
M12 1264 32 1263 14 p18 L=1.8e-07 W=1.64e-06 $X=480800 $Y=3432900 $D=10
M13 36 795 1264 14 p18 L=1.8e-07 W=1.64e-06 $X=486400 $Y=3432900 $D=10
M14 1265 795 36 14 p18 L=1.8e-07 W=1.64e-06 $X=493600 $Y=3432900 $D=10
M15 1266 32 1265 14 p18 L=1.8e-07 W=1.64e-06 $X=499200 $Y=3432900 $D=10
M16 1267 731 1266 14 p18 L=1.8e-07 W=1.64e-06 $X=506300 $Y=3432900 $D=10
M17 14 502 1267 14 p18 L=1.8e-07 W=1.64e-06 $X=512800 $Y=3432900 $D=10
M18 795 35 14 14 p18 L=1.8e-07 W=1.08e-06 $X=520000 $Y=3438500 $D=10
M19 799 373 14 14 p18 L=1.8e-07 W=7.2e-07 $X=862700 $Y=3105900 $D=10
M20 14 524 799 14 p18 L=1.8e-07 W=7.2e-07 $X=869900 $Y=3105900 $D=10
M21 799 43 14 14 p18 L=1.8e-07 W=7.2e-07 $X=875900 $Y=3105900 $D=10
M22 14 527 799 14 p18 L=1.8e-07 W=7.2e-07 $X=883150 $Y=3105900 $D=10
M23 567 799 14 14 p18 L=1.8e-07 W=1.74e-06 $X=889450 $Y=3101700 $D=10
X24 444 14 189 522 INVXL $T=798600 3477600 1 0 $X=794300 $Y=3421800
X25 405 14 189 602 INVXL $T=2587200 3477600 0 180 $X=2569700 $Y=3421800
X26 609 14 189 758 INVXL $T=2811600 3276000 0 0 $X=2807300 $Y=3272000
X27 606 14 189 465 INVXL $T=2864400 3376800 0 0 $X=2860100 $Y=3372800
X28 617 14 189 760 INVXL $T=2890800 3376800 1 0 $X=2886500 $Y=3321000
X29 218 14 189 633 INVXL $T=3049200 3578400 1 0 $X=3044900 $Y=3522600
X30 629 14 189 632 INVXL $T=3055800 3074400 0 0 $X=3051500 $Y=3070400
X31 620 14 189 635 INVXL $T=3069000 3477600 1 0 $X=3064700 $Y=3421800
X32 223 14 189 636 INVXL $T=3082200 3276000 1 0 $X=3077900 $Y=3220200
X33 340 14 189 776 INVXL $T=3267000 3175200 1 0 $X=3262700 $Y=3119400
X34 238 14 189 343 INVXL $T=3300000 3074400 0 0 $X=3295700 $Y=3070400
X35 656 14 189 415 INVXL $T=3445200 3074400 1 180 $X=3427700 $Y=3070400
X36 660 14 189 665 INVXL $T=3438600 3477600 0 0 $X=3434300 $Y=3473600
X37 257 14 189 475 INVXL $T=3583800 3477600 1 0 $X=3579500 $Y=3421800
X38 680 14 189 681 INVXL $T=3715800 3376800 0 0 $X=3711500 $Y=3372800
X39 433 14 189 359 INVXL $T=4072200 3074400 0 0 $X=4067900 $Y=3070400
X40 702 14 189 714 INVXL $T=4151400 3477600 1 0 $X=4147100 $Y=3421800
X41 279 14 189 708 INVXL $T=4210800 3477600 1 180 $X=4193300 $Y=3473600
X42 281 14 189 362 INVXL $T=4290000 3074400 1 180 $X=4272500 $Y=3070400
X43 460 189 458 603 14 198 OAI21XL $T=2745600 3578400 1 0 $X=2741300 $Y=3522600
X44 607 189 12 460 14 606 OAI21XL $T=2811600 3477600 1 180 $X=2780900 $Y=3473600
X45 608 189 613 461 14 464 OAI21XL $T=2844600 3376800 1 0 $X=2840300 $Y=3321000
X46 616 189 463 611 14 462 OAI21XL $T=2871000 3276000 1 0 $X=2866700 $Y=3220200
X47 465 189 456 616 14 626 OAI21XL $T=2956800 3276000 0 0 $X=2952500 $Y=3272000
X48 621 189 464 761 14 624 OAI21XL $T=3003000 3376800 0 180 $X=2972300 $Y=3321000
X49 337 189 640 641 14 642 OAI21XL $T=3174600 3376800 0 180 $X=3143900 $Y=3321000
X50 337 189 622 637 14 645 OAI21XL $T=3194400 3276000 1 180 $X=3163700 $Y=3272000
X51 337 189 624 644 14 649 OAI21XL $T=3187800 3376800 1 0 $X=3183500 $Y=3321000
X52 337 189 230 335 14 472 OAI21XL $T=3187800 3578400 1 0 $X=3183500 $Y=3522600
X53 337 189 623 804 14 653 OAI21XL $T=3214200 3276000 1 0 $X=3209900 $Y=3220200
X54 341 189 340 473 14 412 OAI21XL $T=3267000 3074400 0 0 $X=3262700 $Y=3070400
X55 337 189 646 648 14 654 OAI21XL $T=3306600 3578400 1 0 $X=3302300 $Y=3522600
X56 337 189 659 651 14 245 OAI21XL $T=3379200 3074400 0 0 $X=3374900 $Y=3070400
X57 250 189 664 247 14 666 OAI21XL $T=3432000 3376800 0 0 $X=3427700 $Y=3372800
X58 668 189 475 664 14 656 OAI21XL $T=3484800 3477600 0 180 $X=3454100 $Y=3421800
X59 255 189 475 252 14 676 OAI21XL $T=3577200 3578400 1 0 $X=3572900 $Y=3522600
X60 348 189 676 781 14 350 OAI21XL $T=3630000 3578400 0 180 $X=3599300 $Y=3522600
X61 719 189 716 713 14 722 OAI21XL $T=4177800 3477600 1 0 $X=4173500 $Y=3421800
X62 717 189 362 360 14 435 OAI21XL $T=4217400 3074400 1 180 $X=4186700 $Y=3070400
X63 805 189 279 790 14 281 OAI21XL $T=4250400 3477600 0 180 $X=4219700 $Y=3421800
X64 721 189 483 712 14 724 OAI21XL $T=4250400 3376800 1 0 $X=4246100 $Y=3321000
X65 481 189 482 483 14 723 OAI21XL $T=4283400 3276000 1 180 $X=4252700 $Y=3272000
X66 794 189 14 25 499 NAND2XL $T=422400 3477600 1 0 $X=418100 $Y=3421800
X67 796 189 14 41 735 NAND2XL $T=574200 3276000 0 0 $X=569900 $Y=3272000
X68 368 189 14 38 513 NAND2XL $T=745800 3477600 1 180 $X=721700 $Y=3473600
X69 521 189 14 7 798 NAND2XL $T=844800 3276000 0 0 $X=840500 $Y=3272000
X70 380 189 14 38 531 NAND2XL $T=983400 3276000 0 180 $X=959300 $Y=3220200
X71 528 189 14 38 561 NAND2XL $T=970200 3175200 1 0 $X=965900 $Y=3119400
X72 92 189 14 90 538 NAND2XL $T=1148400 3376800 1 180 $X=1124300 $Y=3372800
X73 542 189 14 90 537 NAND2XL $T=1194600 3477600 0 0 $X=1190300 $Y=3473600
X74 543 189 14 90 546 NAND2XL $T=1221000 3276000 1 0 $X=1216700 $Y=3220200
X75 109 189 14 90 110 NAND2XL $T=1254000 3477600 1 180 $X=1229900 $Y=3473600
X76 742 189 14 90 548 NAND2XL $T=1273800 3376800 0 180 $X=1249700 $Y=3321000
X77 306 189 14 90 745 NAND2XL $T=1353000 3175200 1 180 $X=1328900 $Y=3171200
X78 114 189 14 90 385 NAND2XL $T=1346400 3276000 1 0 $X=1342100 $Y=3220200
X79 555 189 14 90 550 NAND2XL $T=1366200 3376800 1 180 $X=1342100 $Y=3372800
X80 124 189 14 90 556 NAND2XL $T=1465200 3477600 0 0 $X=1460900 $Y=3473600
X81 388 189 14 90 557 NAND2XL $T=1551000 3276000 0 180 $X=1526900 $Y=3220200
X82 564 189 14 90 748 NAND2XL $T=1584000 3477600 0 180 $X=1559900 $Y=3421800
X83 747 189 14 558 148 NAND2XL $T=1570800 3376800 1 0 $X=1566500 $Y=3321000
X84 143 189 14 90 447 NAND2XL $T=1617000 3578400 0 180 $X=1592900 $Y=3522600
X85 131 189 14 561 565 NAND2XL $T=1603800 3175200 1 0 $X=1599500 $Y=3119400
X86 749 189 14 158 575 NAND2XL $T=1874400 3175200 0 180 $X=1850300 $Y=3119400
X87 572 189 14 152 576 NAND2XL $T=1999800 3477600 1 180 $X=1975700 $Y=3473600
X88 750 189 14 152 583 NAND2XL $T=1999800 3175200 0 0 $X=1995500 $Y=3171200
X89 752 189 14 158 751 NAND2XL $T=2039400 3477600 1 180 $X=2015300 $Y=3473600
X90 157 189 14 161 579 NAND2XL $T=2065800 3175200 1 180 $X=2041700 $Y=3171200
X91 586 189 14 158 587 NAND2XL $T=2112000 3376800 1 180 $X=2087900 $Y=3372800
X92 397 189 14 161 581 NAND2XL $T=2184600 3175200 0 180 $X=2160500 $Y=3119400
X93 596 189 14 161 441 NAND2XL $T=2369400 3175200 1 180 $X=2345300 $Y=3171200
X94 549 189 14 756 597 NAND2XL $T=2382600 3477600 0 0 $X=2378300 $Y=3473600
X95 601 189 14 161 160 NAND2XL $T=2435400 3477600 1 180 $X=2411300 $Y=3473600
X96 598 189 14 161 452 NAND2XL $T=2442000 3276000 1 180 $X=2417900 $Y=3272000
X97 600 189 14 161 163 NAND2XL $T=2442000 3578400 0 180 $X=2417900 $Y=3522600
X98 599 189 14 161 591 NAND2XL $T=2448600 3376800 0 180 $X=2424500 $Y=3321000
X99 190 189 14 328 603 NAND2XL $T=2699400 3578400 1 0 $X=2695100 $Y=3522600
X100 197 189 14 329 461 NAND2XL $T=2758800 3376800 0 0 $X=2754500 $Y=3372800
X101 597 189 14 607 201 NAND2XL $T=2772000 3578400 1 0 $X=2767700 $Y=3522600
X102 183 189 14 199 609 NAND2XL $T=2791800 3276000 0 0 $X=2787500 $Y=3272000
X103 607 189 14 12 460 NAND2XL $T=2811600 3578400 0 180 $X=2787500 $Y=3522600
X104 325 189 14 459 611 NAND2XL $T=2798400 3276000 1 0 $X=2794100 $Y=3220200
X105 214 189 14 202 614 NAND2XL $T=2844600 3477600 1 180 $X=2820500 $Y=3473600
X106 609 189 14 605 615 NAND2XL $T=2844600 3276000 1 0 $X=2840300 $Y=3220200
X107 457 189 14 203 617 NAND2XL $T=2871000 3376800 1 0 $X=2866700 $Y=3321000
X108 617 189 14 612 621 NAND2XL $T=2923800 3376800 1 0 $X=2919500 $Y=3321000
X109 465 189 14 456 616 NAND2XL $T=2950200 3276000 1 180 $X=2926100 $Y=3272000
X110 621 189 14 464 761 NAND2XL $T=2950200 3376800 1 0 $X=2945900 $Y=3321000
X111 454 189 14 618 627 NAND2XL $T=2970000 3175200 1 0 $X=2965700 $Y=3119400
X112 618 189 14 539 410 NAND2XL $T=2996400 3074400 1 180 $X=2972300 $Y=3070400
X113 627 189 14 467 625 NAND2XL $T=3003000 3175200 1 180 $X=2978900 $Y=3171200
X114 466 189 14 331 628 NAND2XL $T=2996400 3477600 0 0 $X=2992100 $Y=3473600
X115 401 189 14 332 629 NAND2XL $T=3003000 3074400 0 0 $X=2998700 $Y=3070400
X116 467 189 14 630 801 NAND2XL $T=3009600 3175200 0 0 $X=3005300 $Y=3171200
X117 628 189 14 468 638 NAND2XL $T=3009600 3477600 1 0 $X=3005300 $Y=3421800
X118 468 189 14 333 802 NAND2XL $T=3016200 3477600 0 0 $X=3011900 $Y=3473600
X119 467 189 14 632 764 NAND2XL $T=3042600 3175200 1 0 $X=3038300 $Y=3119400
X120 468 189 14 633 766 NAND2XL $T=3062400 3578400 1 0 $X=3058100 $Y=3522600
X121 629 189 14 630 773 NAND2XL $T=3102000 3175200 1 0 $X=3097700 $Y=3119400
X122 218 189 14 333 771 NAND2XL $T=3102000 3578400 1 0 $X=3097700 $Y=3522600
X123 336 189 14 643 473 NAND2XL $T=3141600 3175200 1 0 $X=3137300 $Y=3119400
X124 194 189 14 339 341 NAND2XL $T=3253800 3074400 1 180 $X=3229700 $Y=3070400
X125 473 189 14 776 777 NAND2XL $T=3300000 3175200 1 0 $X=3295700 $Y=3119400
X126 455 189 14 243 660 NAND2XL $T=3379200 3477600 0 0 $X=3374900 $Y=3473600
X127 660 189 14 661 780 NAND2XL $T=3412200 3477600 0 0 $X=3407900 $Y=3473600
X128 661 189 14 669 668 NAND2XL $T=3517800 3477600 1 0 $X=3513500 $Y=3421800
X129 348 189 14 676 781 NAND2XL $T=3603600 3477600 0 0 $X=3599300 $Y=3473600
X130 477 189 14 476 680 NAND2XL $T=3748800 3376800 1 180 $X=3724700 $Y=3372800
X131 680 189 14 478 684 NAND2XL $T=3748800 3376800 0 0 $X=3744500 $Y=3372800
X132 356 189 14 268 784 NAND2XL $T=3867600 3578400 0 180 $X=3843500 $Y=3522600
X133 356 189 14 783 691 NAND2XL $T=3874200 3376800 0 0 $X=3869900 $Y=3372800
X134 480 189 14 688 423 NAND2XL $T=3894000 3578400 1 0 $X=3889700 $Y=3522600
X135 358 189 14 357 428 NAND2XL $T=3946800 3074400 0 0 $X=3942500 $Y=3070400
X136 356 189 14 426 785 NAND2XL $T=3966600 3376800 0 180 $X=3942500 $Y=3321000
X137 356 189 14 430 425 NAND2XL $T=4026000 3578400 0 180 $X=4001900 $Y=3522600
X138 356 189 14 701 697 NAND2XL $T=4039200 3477600 0 0 $X=4034900 $Y=3473600
X139 431 189 14 359 432 NAND2XL $T=4052400 3074400 0 0 $X=4048100 $Y=3070400
X140 694 189 14 692 360 NAND2XL $T=4078800 3175200 1 0 $X=4074500 $Y=3119400
X141 687 189 14 693 719 NAND2XL $T=4078800 3477600 1 0 $X=4074500 $Y=3421800
X142 689 189 14 277 361 NAND2XL $T=4098600 3074400 0 0 $X=4094300 $Y=3070400
X143 356 189 14 707 699 NAND2XL $T=4118400 3276000 0 180 $X=4094300 $Y=3220200
X144 719 189 14 709 703 NAND2XL $T=4125000 3477600 0 180 $X=4100900 $Y=3421800
X145 714 189 14 708 709 NAND2XL $T=4151400 3477600 1 180 $X=4127300 $Y=3473600
X146 356 189 14 711 275 NAND2XL $T=4158000 3175200 0 180 $X=4133900 $Y=3119400
X147 706 189 14 696 712 NAND2XL $T=4164600 3276000 0 180 $X=4140500 $Y=3220200
X148 690 189 14 718 713 NAND2XL $T=4158000 3376800 0 0 $X=4153700 $Y=3372800
X149 719 189 14 714 710 NAND2XL $T=4177800 3477600 1 180 $X=4153700 $Y=3473600
X150 356 189 14 788 698 NAND2XL $T=4164600 3175200 1 0 $X=4160300 $Y=3119400
X151 715 189 14 704 483 NAND2XL $T=4204200 3276000 1 0 $X=4199900 $Y=3220200
X152 484 189 14 720 805 NAND2XL $T=4276800 3477600 0 180 $X=4252700 $Y=3421800
X153 460 604 189 14 459 XOR2XL $T=2785200 3376800 0 0 $X=2780900 $Y=3372800
X154 613 610 189 14 640 XOR2XL $T=2917200 3276000 1 180 $X=2860100 $Y=3272000
X155 616 619 189 14 622 XOR2XL $T=3036000 3276000 0 180 $X=2978900 $Y=3220200
X156 673 475 189 14 474 XOR2XL $T=3590400 3477600 1 180 $X=3533300 $Y=3473600
X157 725 362 189 14 788 XOR2XL $T=4250400 3175200 0 180 $X=4193300 $Y=3119400
X158 791 482 189 14 711 XOR2XL $T=4290000 3175200 1 180 $X=4232900 $Y=3171200
X159 13 17 806 14 807 487 189 808 14 DFFSXL $T=6600 3376800 0 0 $X=2300 $Y=3372800
X160 13 180 809 14 810 442 189 811 14 DFFSXL $T=13200 3276000 0 0 $X=8900 $Y=3272000
X161 13 40 812 14 813 726 189 814 14 DFFSXL $T=26400 3477600 1 0 $X=22100 $Y=3421800
X162 13 47 815 14 816 792 189 817 14 DFFSXL $T=33000 3074400 0 0 $X=28700 $Y=3070400
X163 13 50 818 14 819 486 189 820 14 DFFSXL $T=33000 3477600 0 0 $X=28700 $Y=3473600
X164 15 180 821 14 822 18 189 823 14 DFFSXL $T=66000 3175200 0 0 $X=61700 $Y=3171200
X165 22 40 824 14 825 727 189 826 14 DFFSXL $T=138600 3376800 1 0 $X=134300 $Y=3321000
X166 15 50 827 14 828 728 189 829 14 DFFSXL $T=158400 3477600 0 0 $X=154100 $Y=3473600
X167 15 5 830 14 831 729 189 832 14 DFFSXL $T=178200 3578400 1 0 $X=173900 $Y=3522600
X168 22 85 833 14 834 730 189 835 14 DFFSXL $T=264000 3175200 0 0 $X=259700 $Y=3171200
X169 22 47 836 14 837 495 189 838 14 DFFSXL $T=264000 3276000 1 0 $X=259700 $Y=3220200
X170 22 21 839 14 840 793 189 841 14 DFFSXL $T=264000 3376800 1 0 $X=259700 $Y=3321000
X171 22 17 842 14 843 445 189 844 14 DFFSXL $T=277200 3376800 0 0 $X=272900 $Y=3372800
X172 22 50 845 14 846 794 189 847 14 DFFSXL $T=297000 3477600 1 0 $X=292700 $Y=3421800
X173 22 5 848 14 849 500 189 850 14 DFFSXL $T=369600 3578400 1 0 $X=365300 $Y=3522600
X174 26 185 851 14 852 503 189 853 14 DFFSXL $T=402600 3175200 0 0 $X=398300 $Y=3171200
X175 26 17 854 14 855 732 189 856 14 DFFSXL $T=402600 3276000 0 0 $X=398300 $Y=3272000
X176 26 27 857 14 858 504 189 859 14 DFFSXL $T=402600 3376800 0 0 $X=398300 $Y=3372800
X177 22 28 860 14 861 733 189 862 14 DFFSXL $T=462000 3175200 1 0 $X=457700 $Y=3119400
X178 15 40 863 14 864 737 189 865 14 DFFSXL $T=528000 3477600 0 0 $X=523700 $Y=3473600
X179 20 28 866 14 867 507 189 868 14 DFFSXL $T=600600 3175200 1 0 $X=596300 $Y=3119400
X180 20 40 869 14 870 511 189 871 14 DFFSXL $T=627000 3376800 1 0 $X=622700 $Y=3321000
X181 20 62 872 297 873 516 189 874 14 DFFSXL $T=640200 3175200 0 0 $X=635900 $Y=3171200
X182 26 21 875 14 876 509 189 877 14 DFFSXL $T=679800 3578400 1 0 $X=675500 $Y=3522600
X183 26 62 878 297 879 528 189 880 14 DFFSXL $T=765600 3175200 0 0 $X=761300 $Y=3171200
X184 26 88 881 297 882 375 189 883 14 DFFSXL $T=772200 3175200 1 0 $X=767900 $Y=3119400
X185 63 50 884 297 885 519 189 886 14 DFFSXL $T=891000 3175200 0 0 $X=886700 $Y=3171200
X186 70 21 887 14 888 377 189 889 14 DFFSXL $T=904200 3477600 0 0 $X=899900 $Y=3473600
X187 70 88 890 14 891 535 189 892 14 DFFSXL $T=917400 3276000 0 0 $X=913100 $Y=3272000
X188 302 88 893 14 894 543 189 895 14 DFFSXL $T=1049400 3276000 1 0 $X=1045100 $Y=3220200
X189 302 27 896 14 897 303 189 898 14 DFFSXL $T=1049400 3477600 0 0 $X=1045100 $Y=3473600
X190 63 47 899 14 900 552 189 901 14 DFFSXL $T=1214400 3276000 0 0 $X=1210100 $Y=3272000
X191 70 97 902 14 903 119 189 904 14 DFFSXL $T=1227600 3074400 0 0 $X=1223300 $Y=3070400
X192 107 88 905 14 906 554 189 907 14 DFFSXL $T=1267200 3175200 1 0 $X=1262900 $Y=3119400
X193 63 97 908 14 909 106 189 910 14 DFFSXL $T=1273800 3477600 1 0 $X=1269500 $Y=3421800
X194 63 111 911 14 912 78 189 913 14 DFFSXL $T=1287000 3376800 1 0 $X=1282700 $Y=3321000
X195 63 27 914 14 915 122 189 916 14 DFFSXL $T=1287000 3477600 0 0 $X=1282700 $Y=3473600
X196 75 111 917 14 918 127 189 919 14 DFFSXL $T=1366200 3276000 0 0 $X=1361900 $Y=3272000
X197 302 145 920 14 921 555 189 922 14 DFFSXL $T=1386000 3276000 1 0 $X=1381700 $Y=3220200
X198 70 47 923 14 924 116 189 925 14 DFFSXL $T=1392600 3175200 1 0 $X=1388300 $Y=3119400
X199 302 111 926 14 927 125 189 928 14 DFFSXL $T=1405800 3175200 0 0 $X=1401500 $Y=3171200
X200 70 111 929 14 930 308 189 931 14 DFFSXL $T=1405800 3376800 0 0 $X=1401500 $Y=3372800
X201 63 185 932 315 933 112 189 934 14 DFFSXL $T=1405800 3578400 1 0 $X=1401500 $Y=3522600
X202 70 128 935 14 936 134 189 937 14 DFFSXL $T=1412400 3477600 1 0 $X=1408100 $Y=3421800
X203 75 185 938 14 939 559 189 940 14 DFFSXL $T=1445400 3376800 1 0 $X=1441100 $Y=3321000
X204 302 50 941 14 942 146 189 943 14 DFFSXL $T=1531200 3175200 0 0 $X=1526900 $Y=3171200
X205 10 62 944 14 945 568 189 946 14 DFFSXL $T=1650000 3175200 1 0 $X=1645700 $Y=3119400
X206 10 17 947 315 948 563 189 949 14 DFFSXL $T=1650000 3376800 0 0 $X=1645700 $Y=3372800
X207 10 185 950 315 951 564 189 952 14 DFFSXL $T=1663200 3578400 1 0 $X=1658900 $Y=3522600
X208 70 180 953 14 954 312 189 955 14 DFFSXL $T=1676400 3376800 1 0 $X=1672100 $Y=3321000
X209 147 47 956 14 957 571 189 958 14 DFFSXL $T=1775400 3376800 0 0 $X=1771100 $Y=3372800
X210 151 88 959 14 960 749 189 961 14 DFFSXL $T=1782000 3175200 0 0 $X=1777700 $Y=3171200
X211 147 145 962 14 963 574 189 964 14 DFFSXL $T=1795200 3477600 1 0 $X=1790900 $Y=3421800
X212 151 180 965 14 966 450 189 967 14 DFFSXL $T=1801800 3376800 1 0 $X=1797500 $Y=3321000
X213 147 62 968 14 969 154 189 970 14 DFFSXL $T=1887600 3074400 0 0 $X=1883300 $Y=3070400
X214 151 47 971 14 972 580 189 973 14 DFFSXL $T=1900800 3376800 0 0 $X=1896500 $Y=3372800
X215 151 165 974 14 975 317 189 976 14 DFFSXL $T=2006400 3276000 0 0 $X=2002100 $Y=3272000
X216 162 88 977 14 978 588 189 979 14 DFFSXL $T=2013000 3175200 1 0 $X=2008700 $Y=3119400
X217 186 111 980 14 981 753 189 982 14 DFFSXL $T=2059200 3074400 0 0 $X=2054900 $Y=3070400
X218 164 40 983 14 984 454 189 985 14 DFFSXL $T=2131800 3276000 0 0 $X=2127500 $Y=3272000
X219 162 47 986 14 987 594 189 988 14 DFFSXL $T=2131800 3477600 1 0 $X=2127500 $Y=3421800
X220 164 165 989 14 990 401 189 991 14 DFFSXL $T=2145000 3175200 0 0 $X=2140700 $Y=3171200
X221 162 40 992 14 993 754 189 994 14 DFFSXL $T=2145000 3276000 1 0 $X=2140700 $Y=3220200
X222 189 111 995 14 996 181 189 997 14 DFFSXL $T=2283600 3276000 0 0 $X=2279300 $Y=3272000
X223 162 180 180 184 998 403 189 999 14 DFFSXL $T=2356200 3477600 1 0 $X=2351900 $Y=3421800
X224 189 145 1000 14 1001 456 189 1002 14 DFFSXL $T=2369400 3276000 1 0 $X=2365100 $Y=3220200
X225 189 85 1003 14 1004 457 189 1005 14 DFFSXL $T=2376000 3175200 1 0 $X=2371700 $Y=3119400
X226 186 47 1006 184 1007 585 189 1008 14 DFFSXL $T=2488200 3578400 1 0 $X=2483900 $Y=3522600
X227 186 74 1009 184 1010 599 189 1011 14 DFFSXL $T=2494800 3376800 0 0 $X=2490500 $Y=3372800
X228 186 185 1012 184 1013 600 189 1014 14 DFFSXL $T=2494800 3477600 0 0 $X=2490500 $Y=3473600
X229 186 5 1015 14 1016 598 189 1017 14 DFFSXL $T=2501400 3175200 0 0 $X=2497100 $Y=3171200
X230 189 185 1018 184 1019 406 189 1020 14 DFFSXL $T=2620200 3477600 0 0 $X=2615900 $Y=3473600
X231 189 27 1021 184 1022 192 189 1023 14 DFFSXL $T=2626800 3175200 0 0 $X=2622500 $Y=3171200
X232 189 602 1024 184 1025 196 189 1026 14 DFFSXL $T=2626800 3477600 1 0 $X=2622500 $Y=3421800
X233 189 50 1027 184 1028 183 189 1029 14 DFFSXL $T=2633400 3276000 1 0 $X=2629100 $Y=3220200
X234 189 180 1030 184 1031 210 189 1032 14 DFFSXL $T=2752200 3175200 0 0 $X=2747900 $Y=3171200
X235 189 5 1033 184 1034 466 189 1035 14 DFFSXL $T=2758800 3175200 1 0 $X=2754500 $Y=3119400
X236 206 614 614 184 1036 328 189 470 14 DFFSXL $T=2857800 3477600 1 0 $X=2853500 $Y=3421800
X237 206 759 759 184 1037 607 189 469 14 DFFSXL $T=2857800 3477600 0 0 $X=2853500 $Y=3473600
X238 206 411 1038 342 1039 618 189 775 14 DFFSXL $T=3088800 3074400 0 0 $X=3084500 $Y=3070400
X239 234 645 1040 14 1041 344 189 1042 14 DFFSXL $T=3207600 3376800 0 0 $X=3203300 $Y=3372800
X240 234 634 1043 14 1044 476 189 1045 14 DFFSXL $T=3326400 3477600 1 0 $X=3322100 $Y=3421800
X241 234 642 1046 14 1047 479 189 1048 14 DFFSXL $T=3339600 3376800 1 0 $X=3335300 $Y=3321000
X242 246 338 1049 342 1050 671 189 1051 14 DFFSXL $T=3412200 3175200 1 0 $X=3407900 $Y=3119400
X243 246 649 1052 14 1053 675 189 1054 14 DFFSXL $T=3465000 3276000 0 0 $X=3460700 $Y=3272000
X244 246 634 1055 14 1056 685 189 1057 14 DFFSXL $T=3471600 3376800 0 0 $X=3467300 $Y=3372800
X245 234 472 1058 14 1059 674 189 1060 14 DFFSXL $T=3498000 3175200 0 0 $X=3493700 $Y=3171200
X246 234 349 1061 342 1062 417 189 1063 14 DFFSXL $T=3550800 3074400 0 0 $X=3546500 $Y=3070400
X247 246 642 1064 14 1065 678 189 1066 14 DFFSXL $T=3597000 3477600 1 0 $X=3592700 $Y=3421800
X248 246 654 1067 14 1068 679 189 1069 14 DFFSXL $T=3603600 3376800 1 0 $X=3599300 $Y=3321000
X249 246 658 1070 342 1071 683 189 1072 14 DFFSXL $T=3663000 3175200 0 0 $X=3658700 $Y=3171200
X250 246 472 1073 14 1074 782 189 1075 14 DFFSXL $T=3676200 3276000 1 0 $X=3671900 $Y=3220200
X251 246 645 1076 14 1077 418 189 1078 14 DFFSXL $T=3682800 3276000 0 0 $X=3678500 $Y=3272000
X252 270 691 1079 14 1080 477 189 1081 14 DFFSXL $T=3913800 3477600 1 0 $X=3909500 $Y=3421800
X253 270 784 1082 14 1083 352 189 1084 14 DFFSXL $T=3913800 3477600 0 0 $X=3909500 $Y=3473600
X254 270 697 1085 14 1086 686 189 1087 14 DFFSXL $T=3920400 3376800 0 0 $X=3916100 $Y=3372800
X255 270 698 1088 14 1089 353 189 1090 14 DFFSXL $T=3940200 3175200 0 0 $X=3935900 $Y=3171200
X256 270 785 1091 342 1092 682 189 1093 14 DFFSXL $T=3946800 3175200 1 0 $X=3942500 $Y=3119400
X257 270 699 1094 14 1095 351 189 1096 14 DFFSXL $T=3946800 3276000 1 0 $X=3942500 $Y=3220200
X258 605 462 14 758 1097 189 613 AOI21XL $T=2857800 3276000 1 180 $X=2827100 $Y=3272000
X259 612 464 14 760 1098 189 620 AOI21XL $T=2904000 3376800 0 0 $X=2899700 $Y=3372800
X260 630 636 14 632 1099 189 768 AOI21XL $T=3069000 3175200 1 0 $X=3064700 $Y=3119400
X261 333 635 14 633 1100 189 769 AOI21XL $T=3088800 3477600 0 0 $X=3084500 $Y=3473600
X262 638 769 14 639 1101 189 803 AOI21XL $T=3121800 3477600 1 0 $X=3117500 $Y=3421800
X263 343 656 14 413 1102 189 778 AOI21XL $T=3366000 3074400 1 180 $X=3335300 $Y=3070400
X264 777 778 14 779 1103 189 659 AOI21XL $T=3339600 3175200 1 0 $X=3335300 $Y=3119400
X265 661 253 14 665 1104 189 664 AOI21XL $T=3484800 3477600 1 180 $X=3454100 $Y=3473600
X266 669 257 14 253 1105 189 662 AOI21XL $T=3498000 3477600 0 0 $X=3493700 $Y=3473600
X267 685 478 14 681 1106 189 420 AOI21XL $T=3775200 3376800 0 0 $X=3770900 $Y=3372800
X268 356 700 14 273 1107 189 695 AOI21XL $T=3993000 3376800 1 0 $X=3988700 $Y=3321000
X269 705 703 14 786 1108 189 700 AOI21XL $T=4098600 3376800 1 180 $X=4067900 $Y=3372800
X270 720 708 14 722 1109 189 482 AOI21XL $T=4210800 3477600 0 0 $X=4206500 $Y=3473600
X271 722 484 14 724 1110 189 790 AOI21XL $T=4250400 3376800 1 180 $X=4219700 $Y=3372800
X272 458 189 603 1111 14 604 NAND2BXL $T=2752200 3477600 0 0 $X=2747900 $Y=3473600
X273 608 189 461 1112 14 610 NAND2BXL $T=2791800 3376800 1 0 $X=2787500 $Y=3321000
X274 463 189 611 1113 14 619 NAND2BXL $T=2910600 3276000 1 0 $X=2906300 $Y=3220200
X275 255 189 252 1114 14 673 NAND2BXL $T=3537600 3578400 1 0 $X=3533300 $Y=3522600
X276 282 189 361 1115 14 434 NAND2BXL $T=4158000 3074400 0 0 $X=4153700 $Y=3070400
X277 721 189 712 1116 14 789 NAND2BXL $T=4204200 3376800 1 0 $X=4199900 $Y=3321000
X278 717 189 360 1117 14 725 NAND2BXL $T=4263600 3175200 1 0 $X=4259300 $Y=3119400
X279 481 189 483 1118 14 791 NAND2BXL $T=4263600 3276000 1 0 $X=4259300 $Y=3220200
X280 14 190 328 458 189 NOR2XL $T=2666400 3578400 1 0 $X=2662100 $Y=3522600
X281 14 197 329 608 189 NOR2XL $T=2725800 3376800 0 0 $X=2721500 $Y=3372800
X282 14 325 459 463 189 NOR2XL $T=2765400 3276000 1 0 $X=2761100 $Y=3220200
X283 14 618 539 409 189 NOR2XL $T=2976600 3074400 1 180 $X=2952500 $Y=3070400
X284 14 465 235 762 189 NOR2XL $T=2989800 3276000 0 0 $X=2985500 $Y=3272000
X285 14 235 459 765 189 NOR2XL $T=3022800 3376800 1 0 $X=3018500 $Y=3321000
X286 14 235 216 631 189 NOR2XL $T=3022800 3578400 1 0 $X=3018500 $Y=3522600
X287 14 235 329 770 189 NOR2XL $T=3062400 3376800 1 0 $X=3058100 $Y=3321000
X288 14 638 769 639 189 NOR2XL $T=3088800 3477600 1 0 $X=3084500 $Y=3421800
X289 14 235 203 772 189 NOR2XL $T=3095400 3276000 1 0 $X=3091100 $Y=3220200
X290 14 235 199 774 189 NOR2XL $T=3135000 3276000 1 0 $X=3130700 $Y=3220200
X291 14 336 643 340 189 NOR2XL $T=3181200 3175200 1 0 $X=3176900 $Y=3119400
X292 14 235 643 650 189 NOR2XL $T=3207600 3175200 0 0 $X=3203300 $Y=3171200
X293 14 777 778 779 189 NOR2XL $T=3313200 3074400 0 0 $X=3308900 $Y=3070400
X294 14 250 668 670 189 NOR2XL $T=3498000 3477600 1 0 $X=3493700 $Y=3421800
X295 14 255 345 669 189 NOR2XL $T=3511200 3578400 1 0 $X=3506900 $Y=3522600
X296 14 480 688 422 189 NOR2XL $T=3874200 3578400 1 0 $X=3869900 $Y=3522600
X297 14 358 357 427 189 NOR2XL $T=3913800 3074400 0 0 $X=3909500 $Y=3070400
X298 14 687 693 702 189 NOR2XL $T=4052400 3477600 1 0 $X=4048100 $Y=3421800
X299 14 694 692 717 189 NOR2XL $T=4105200 3175200 1 0 $X=4100900 $Y=3119400
X300 14 705 703 786 189 NOR2XL $T=4125000 3376800 1 180 $X=4100900 $Y=3372800
X301 14 689 277 282 189 NOR2XL $T=4125000 3074400 0 0 $X=4120700 $Y=3070400
X302 14 706 696 721 189 NOR2XL $T=4171200 3276000 1 0 $X=4166900 $Y=3220200
X303 14 690 718 716 189 NOR2XL $T=4177800 3376800 0 0 $X=4173500 $Y=3372800
X304 14 702 716 720 189 NOR2XL $T=4177800 3477600 0 0 $X=4173500 $Y=3473600
X305 14 715 704 481 189 NOR2XL $T=4237200 3276000 1 0 $X=4232900 $Y=3220200
X306 14 282 717 436 189 NOR2XL $T=4257000 3074400 0 0 $X=4252700 $Y=3070400
X307 14 721 481 484 189 NOR2XL $T=4270200 3376800 0 0 $X=4265900 $Y=3372800
X308 25 500 496 189 1119 731 14 OAI2BB1XL $T=448800 3477600 0 0 $X=444500 $Y=3473600
X309 25 34 494 189 1120 505 14 OAI2BB1XL $T=495000 3477600 0 0 $X=490700 $Y=3473600
X310 38 508 492 189 1121 510 14 OAI2BB1XL $T=613800 3276000 0 0 $X=609500 $Y=3272000
X311 38 509 29 189 1122 52 14 OAI2BB1XL $T=666600 3477600 0 0 $X=662300 $Y=3473600
X312 38 520 370 189 1123 738 14 OAI2BB1XL $T=798600 3477600 1 180 $X=761300 $Y=3473600
X313 23 487 76 189 1124 740 14 OAI2BB1XL $T=811800 3276000 1 0 $X=807500 $Y=3220200
X314 25 445 80 189 1125 525 14 OAI2BB1XL $T=871200 3276000 0 0 $X=866900 $Y=3272000
X315 90 563 562 189 1126 560 14 OAI2BB1XL $T=1597200 3376800 1 180 $X=1559900 $Y=3372800
X316 211 626 763 189 1127 634 14 OAI2BB1XL $T=3042600 3276000 1 0 $X=3038300 $Y=3220200
X317 462 615 189 14 623 XNOR2XL $T=2923800 3175200 0 0 $X=2919500 $Y=3171200
X318 771 635 189 14 646 XNOR2XL $T=3121800 3477600 0 0 $X=3117500 $Y=3473600
X319 685 684 189 14 783 XNOR2XL $T=3808200 3376800 0 0 $X=3803900 $Y=3372800
X320 710 708 189 14 701 XNOR2XL $T=4125000 3477600 1 180 $X=4067900 $Y=3473600
X321 789 723 189 14 707 XNOR2XL $T=4243800 3276000 1 180 $X=4186700 $Y=3272000
X322 337 803 189 334 14 242 OAI21X1 $T=3161400 3477600 1 0 $X=3157100 $Y=3421800
X323 337 657 189 414 14 658 OAI21X1 $T=3339600 3578400 1 0 $X=3335300 $Y=3522600
X324 337 474 189 416 14 248 OAI21X1 $T=3491400 3578400 0 180 $X=3454100 $Y=3522600
X325 773 636 189 14 339 XNOR2X1 $T=3148200 3175200 0 0 $X=3143900 $Y=3171200
X326 69 289 14 740 189 525 67 AOI211XL $T=884400 3276000 0 180 $X=847100 $Y=3220200
X327 389 90 14 133 189 130 746 AOI211XL $T=1577400 3578400 0 180 $X=1540100 $Y=3522600
X328 469 189 14 762 189 224 763 AOI211XL $T=3022800 3276000 0 0 $X=3018500 $Y=3272000
X329 470 189 14 765 189 224 637 AOI211XL $T=3062400 3276000 0 0 $X=3058100 $Y=3272000
X330 767 189 14 224 189 770 641 AOI211XL $T=3095400 3376800 1 0 $X=3091100 $Y=3321000
X331 217 189 14 224 189 772 644 AOI211XL $T=3115200 3276000 0 0 $X=3110900 $Y=3272000
X332 647 189 14 224 189 631 648 AOI211XL $T=3181200 3578400 0 180 $X=3143900 $Y=3522600
X333 471 189 14 224 189 774 804 AOI211XL $T=3201000 3276000 0 180 $X=3163700 $Y=3220200
X334 775 189 14 224 189 650 651 AOI211XL $T=3220800 3175200 1 0 $X=3216500 $Y=3119400
X335 625 768 189 14 643 XOR2X1 $T=3088800 3175200 0 0 $X=3084500 $Y=3171200
X336 780 662 189 14 657 XOR2X1 $T=3445200 3578400 0 180 $X=3388100 $Y=3522600
X337 13 111 1128 14 485 189 1129 14 15 111 1130 14 1131 489 1132 ICV_1 $T=0 3276000 1 0 $X=-4300 $Y=3220200
X338 20 17 1133 14 493 189 1134 14 22 185 1135 14 1136 498 1137 ICV_1 $T=198000 3175200 1 0 $X=193700 $Y=3119400
X339 26 111 1138 14 508 189 1139 14 20 111 1140 297 1141 739 1142 ICV_1 $T=521400 3276000 1 0 $X=517100 $Y=3220200
X340 26 50 1143 297 520 189 1144 14 63 5 1145 14 1146 526 1147 ICV_1 $T=686400 3376800 0 0 $X=682100 $Y=3372800
X341 75 27 1148 14 379 189 1149 14 302 5 1150 14 1151 381 1152 ICV_1 $T=924000 3477600 1 0 $X=919700 $Y=3421800
X342 75 88 1153 297 536 189 1154 14 302 17 1155 14 1156 545 1157 ICV_1 $T=930600 3376800 1 0 $X=926300 $Y=3321000
X343 302 47 1158 297 541 189 1159 14 63 88 1160 14 1161 530 1162 ICV_1 $T=1009800 3175200 1 0 $X=1005500 $Y=3119400
X344 70 145 1163 14 87 189 1164 14 63 28 1165 14 1166 440 1167 ICV_1 $T=1016400 3175200 0 0 $X=1012100 $Y=3171200
X345 10 40 1168 14 542 189 1169 14 10 88 1170 14 1171 742 1172 ICV_1 $T=1036200 3578400 1 0 $X=1031900 $Y=3522600
X346 302 128 1173 14 136 189 1174 14 70 62 1175 14 1176 566 1177 ICV_1 $T=1518000 3074400 0 0 $X=1513700 $Y=3070400
X347 70 5 1178 14 89 189 1179 14 70 74 1180 14 1181 392 1182 ICV_1 $T=1544400 3477600 0 0 $X=1540100 $Y=3473600
X348 70 50 1183 14 311 189 1184 14 151 145 1185 14 1186 573 1187 ICV_1 $T=1663200 3276000 0 0 $X=1658900 $Y=3272000
X349 147 5 1188 315 572 189 1189 14 151 85 1190 315 1191 752 1192 ICV_1 $T=1788600 3578400 1 0 $X=1784300 $Y=3522600
X350 147 74 1193 14 750 189 1194 14 162 5 1195 14 1196 589 1197 ICV_1 $T=1881000 3276000 1 0 $X=1876700 $Y=3220200
X351 151 74 1198 14 586 189 1199 14 164 62 1200 14 1201 173 1202 ICV_1 $T=2019600 3376800 1 0 $X=2015300 $Y=3321000
X352 162 85 1203 14 593 189 1204 14 162 145 1205 14 1206 755 1207 ICV_1 $T=2125200 3477600 0 0 $X=2120900 $Y=3473600
X353 189 62 1208 14 455 189 1209 14 189 88 1210 14 1211 595 1212 ICV_1 $T=2184600 3074400 0 0 $X=2180300 $Y=3070400
X354 186 50 1213 14 596 189 1214 14 189 165 1215 14 1216 194 1217 ICV_1 $T=2501400 3175200 1 0 $X=2497100 $Y=3119400
X355 186 180 1218 184 313 189 1219 14 189 28 1220 184 1221 197 1222 ICV_1 $T=2501400 3276000 0 0 $X=2497100 $Y=3272000
X356 186 27 1223 184 601 189 1224 14 189 47 1225 184 1226 195 1227 ICV_1 $T=2501400 3376800 1 0 $X=2497100 $Y=3321000
X357 234 649 1228 342 652 189 1229 14 234 653 1230 14 1231 663 1232 ICV_1 $T=3201000 3276000 0 0 $X=3196700 $Y=3272000
X358 234 338 1233 342 655 189 1234 14 234 654 654 342 1235 667 1236 ICV_1 $T=3227400 3175200 0 0 $X=3223100 $Y=3171200
X359 246 653 1237 342 672 189 1238 14 234 658 1239 342 1240 677 1241 ICV_1 $T=3418800 3276000 1 0 $X=3414500 $Y=3220200
X360 515 14 65 558 189 NOR2BX1 $T=792000 3376800 1 0 $X=787700 $Y=3321000
X361 545 90 14 560 747 189 AOI21X1 $T=1537800 3376800 0 0 $X=1533500 $Y=3372800
X362 257 670 14 666 347 189 AOI21X1 $T=3570600 3477600 0 180 $X=3539900 $Y=3421800
X363 90 541 14 189 741 AND2XL $T=1168200 3376800 0 0 $X=1163900 $Y=3372800
X364 199 183 189 14 605 OR2XL $T=2765400 3376800 1 0 $X=2761100 $Y=3321000
X365 203 457 189 14 612 OR2XL $T=2844600 3376800 0 180 $X=2813900 $Y=3321000
X366 618 454 189 14 467 OR2XL $T=2930400 3175200 1 0 $X=2926100 $Y=3119400
X367 331 466 189 14 468 OR2XL $T=2983200 3578400 1 0 $X=2978900 $Y=3522600
X368 332 401 189 14 630 OR2XL $T=3003000 3175200 1 0 $X=2998700 $Y=3119400
X369 243 455 189 14 661 OR2XL $T=3339600 3477600 0 0 $X=3335300 $Y=3473600
X370 476 477 189 14 478 OR2XL $T=3709200 3477600 0 0 $X=3704900 $Y=3473600
X371 206 208 1242 184 213 189 767 14 DFFSX1 $T=2943600 3376800 0 0 $X=2939300 $Y=3372800
X372 206 222 1243 184 193 189 471 14 DFFSX1 $T=3075600 3376800 0 0 $X=3071300 $Y=3372800
X373 206 207 1244 14 221 189 647 14 DFFSX1 $T=3187800 3477600 0 0 $X=3183500 $Y=3473600
X374 270 695 1245 14 787 189 1246 14 DFFSX1 $T=3907200 3276000 0 0 $X=3902900 $Y=3272000
X375 726 14 23 25 727 491 189 AOI22XL $T=178200 3376800 0 0 $X=173900 $Y=3372800
X376 485 14 23 289 489 492 189 AOI22XL $T=184800 3276000 0 0 $X=180500 $Y=3272000
X377 728 14 289 23 486 497 189 AOI22XL $T=250800 3477600 0 180 $X=213500 $Y=3421800
X378 364 14 23 289 365 494 189 AOI22XL $T=310200 3578400 1 0 $X=305900 $Y=3522600
X379 729 14 289 23 288 496 189 AOI22XL $T=343200 3477600 0 0 $X=338900 $Y=3473600
X380 24 14 64 25 730 443 189 AOI22XL $T=369600 3276000 0 0 $X=365300 $Y=3272000
X381 793 14 25 64 31 501 189 AOI22XL $T=435600 3376800 1 0 $X=431300 $Y=3321000
X382 493 14 64 38 732 515 189 AOI22XL $T=495000 3376800 1 0 $X=490700 $Y=3321000
X383 498 14 25 38 503 796 189 AOI22XL $T=534600 3276000 0 0 $X=530300 $Y=3272000
X384 291 14 64 38 504 734 189 AOI22XL $T=534600 3376800 1 0 $X=530300 $Y=3321000
X385 737 14 289 64 511 736 189 AOI22XL $T=653400 3376800 1 180 $X=616100 $Y=3372800
X386 495 14 25 64 296 797 189 AOI22XL $T=673200 3276000 0 0 $X=668900 $Y=3272000
X387 739 14 64 25 371 521 189 AOI22XL $T=778800 3276000 0 0 $X=774500 $Y=3272000
X388 516 14 64 25 298 524 189 AOI22XL $T=818400 3074400 0 0 $X=814100 $Y=3070400
X389 396 14 152 158 450 448 189 AOI22XL $T=1953600 3175200 0 180 $X=1916300 $Y=3119400
X390 89 300 14 115 84 132 383 108 189 AOI222X1 $T=1155000 3276000 0 0 $X=1150700 $Y=3272000
X391 754 168 14 454 182 170 399 336 189 AOI222X1 $T=2270400 3175200 1 0 $X=2266100 $Y=3119400
X392 25 295 14 51 64 132 374 529 189 AOI222XL $T=844800 3477600 0 0 $X=840500 $Y=3473600
X393 89 535 14 536 132 84 554 540 189 AOI222XL $T=1056000 3276000 0 0 $X=1051700 $Y=3272000
X394 89 299 14 307 84 132 135 562 189 AOI222XL $T=1537800 3276000 0 0 $X=1533500 $Y=3272000
X395 89 141 14 559 132 84 144 449 189 AOI222XL $T=1590600 3276000 0 0 $X=1586300 $Y=3272000
X396 89 566 14 310 132 84 131 131 189 AOI222XL $T=1663200 3276000 0 180 $X=1606100 $Y=3220200
X397 161 585 14 571 152 158 580 578 189 AOI222XL $T=2092200 3477600 0 180 $X=2035100 $Y=3421800
X398 161 327 14 159 152 158 155 584 189 AOI222XL $T=2105400 3477600 1 180 $X=2048300 $Y=3473600
X399 161 753 14 320 168 182 400 398 189 AOI222XL $T=2191200 3578400 1 0 $X=2186900 $Y=3522600
X400 321 168 14 172 182 170 192 319 189 AOI222XL $T=2257200 3578400 1 0 $X=2252900 $Y=3522600
X401 588 168 14 175 182 174 170 577 189 AOI222XL $T=2277000 3175200 0 0 $X=2272700 $Y=3171200
X402 169 168 14 173 182 455 170 592 189 AOI222XL $T=2277000 3376800 0 0 $X=2272700 $Y=3372800
X403 182 176 14 466 170 589 168 451 189 AOI222XL $T=2329800 3477600 0 180 $X=2272700 $Y=3421800
X404 593 168 14 323 182 170 457 582 189 AOI222XL $T=2336400 3376800 0 0 $X=2332100 $Y=3372800
X405 755 168 14 12 179 179 456 756 189 AOI222XL $T=2356200 3578400 1 0 $X=2351900 $Y=3522600
X406 178 168 14 190 182 170 325 590 189 AOI222XL $T=2402400 3376800 0 0 $X=2398100 $Y=3372800
X407 594 168 14 187 182 170 195 757 189 AOI222XL $T=2481600 3477600 1 0 $X=2477300 $Y=3421800
X408 552 3 189 14 CLKBUFX3 $T=1280400 3376800 1 180 $X=1249700 $Y=3372800
X409 441 439 189 14 CLKBUFX3 $T=2092200 3477600 1 0 $X=2087900 $Y=3421800
X410 523 189 14 61 BUFXL $T=818400 3376800 1 0 $X=814100 $Y=3321000
X411 743 189 14 453 BUFXL $T=1287000 3376800 0 0 $X=1282700 $Y=3372800
X412 584 189 14 512 BUFXL $T=2072400 3578400 0 180 $X=2041700 $Y=3522600
X413 592 189 14 570 BUFXL $T=2217600 3376800 1 180 $X=2186900 $Y=3372800
X414 314 189 14 527 BUFX1 $T=1848000 3074400 1 180 $X=1817300 $Y=3070400
X415 595 189 14 174 BUFX1 $T=2362800 3175200 0 180 $X=2332100 $Y=3119400
X416 402 189 14 172 BUFX1 $T=2376000 3175200 0 0 $X=2371700 $Y=3171200
X417 757 189 14 517 BUFX1 $T=2475000 3477600 1 180 $X=2444300 $Y=3473600
X418 326 189 14 177 BUFX1 $T=2481600 3376800 0 180 $X=2450900 $Y=3321000
X419 404 189 14 188 BUFX1 $T=2607000 3074400 1 180 $X=2576300 $Y=3070400
X420 797 189 438 54 514 44 14 NAND4XL $T=759000 3276000 1 180 $X=721700 $Y=3272000
X421 439 189 499 101 372 58 14 NAND4XL $T=844800 3477600 0 180 $X=807500 $Y=3421800
X422 45 189 533 529 534 531 14 NAND4XL $T=1003200 3376800 1 180 $X=965900 $Y=3372800
X423 71 189 378 537 532 538 14 NAND4XL $T=1016400 3376800 0 0 $X=1012100 $Y=3372800
X424 546 189 540 548 103 66 14 NAND4XL $T=1207800 3376800 1 0 $X=1203500 $Y=3321000
X425 93 189 550 91 547 447 14 NAND4XL $T=1234200 3477600 1 0 $X=1229900 $Y=3421800
X426 488 189 384 745 744 118 14 NAND4XL $T=1287000 3175200 0 0 $X=1282700 $Y=3171200
X427 579 189 577 316 305 575 14 NAND4XL $T=1999800 3175200 0 180 $X=1962500 $Y=3119400
X428 442 23 14 287 19 488 189 AOI22X1 $T=145200 3175200 1 0 $X=140900 $Y=3119400
X429 792 23 14 289 363 490 189 AOI22X1 $T=178200 3074400 0 0 $X=173900 $Y=3070400
X430 733 25 14 64 507 57 189 AOI22X1 $T=574200 3376800 1 0 $X=569900 $Y=3321000
X431 573 158 14 152 574 533 189 AOI22X1 $T=1966800 3477600 1 180 $X=1929500 $Y=3473600
X432 11 14 14 189 CLKINVX4 $T=462000 3074400 1 180 $X=431300 $Y=3070400
X433 11 14 14 189 CLKINVX4 $T=1940400 3175200 0 0 $X=1936100 $Y=3171200
X434 11 184 14 189 CLKINVX4 $T=2422200 3175200 0 0 $X=2417900 $Y=3171200
X435 407 180 189 14 INVX4 $T=2857800 3074400 0 0 $X=2853500 $Y=3070400
X436 11 189 297 14 CLKINVX8 $T=1577400 3175200 0 180 $X=1533500 $Y=3119400
X437 408 189 47 14 CLKINVX8 $T=2943600 3074400 1 180 $X=2899700 $Y=3070400
X438 4 14 189 6 CLKBUFX2 $T=561000 3578400 1 0 $X=556700 $Y=3522600
X439 519 14 189 367 CLKBUFX2 $T=798600 3074400 1 180 $X=767900 $Y=3070400
X440 530 14 189 68 CLKBUFX2 $T=871200 3376800 0 180 $X=840500 $Y=3321000
X441 526 14 189 286 CLKBUFX2 $T=871200 3477600 0 180 $X=840500 $Y=3421800
X442 440 14 189 283 CLKBUFX2 $T=930600 3074400 1 180 $X=899900 $Y=3070400
X443 301 14 189 284 CLKBUFX2 $T=970200 3074400 1 180 $X=939500 $Y=3070400
X444 437 14 189 9 CLKBUFX2 $T=950400 3578400 1 0 $X=946100 $Y=3522600
X445 393 14 189 394 CLKBUFX2 $T=1788600 3175200 1 0 $X=1784300 $Y=3119400
X446 578 14 189 438 CLKBUFX2 $T=1986600 3477600 0 180 $X=1955900 $Y=3421800
X447 736 189 37 14 491 446 NAND3XL $T=607200 3376800 1 180 $X=576500 $Y=3372800
X448 501 189 512 14 292 366 NAND3XL $T=633600 3578400 1 0 $X=629300 $Y=3522600
X449 490 189 513 14 517 544 NAND3XL $T=739200 3477600 1 0 $X=734900 $Y=3421800
X450 448 189 105 14 98 553 NAND3XL $T=1280400 3276000 0 180 $X=1249700 $Y=3220200
X451 746 189 522 14 556 387 NAND3XL $T=1531200 3477600 1 180 $X=1500500 $Y=3473600
X452 324 189 8 14 453 322 NAND3XL $T=2349600 3578400 0 180 $X=2318900 $Y=3522600
X453 449 189 748 506 557 167 14 NAND4X1 $T=1597200 3477600 1 0 $X=1592900 $Y=3421800
X454 391 189 570 567 569 237 14 NAND4X1 $T=1749000 3175200 1 180 $X=1711700 $Y=3171200
X455 576 189 452 318 451 502 14 NAND4X1 $T=2131800 3578400 0 180 $X=2094500 $Y=3522600
X456 582 751 581 153 189 14 551 AND4XL $T=2039400 3477600 0 180 $X=1995500 $Y=3421800
X457 590 591 587 583 189 14 518 AND4XL $T=2164800 3376800 1 180 $X=2120900 $Y=3372800
X458 532 446 77 376 14 189 539 OR4X1 $T=983400 3074400 0 0 $X=979100 $Y=3070400
X459 741 514 544 382 14 189 304 OR4X1 $T=1188000 3477600 1 0 $X=1183700 $Y=3421800
X460 309 90 14 90 568 189 565 569 AOI221XL $T=1663200 3175200 0 0 $X=1658900 $Y=3171200
X461 713 14 716 705 189 NOR2BXL $T=4158000 3376800 1 180 $X=4127300 $Y=3372800
X462 346 263 276 706 189 14 704 ADDFX1 $T=4224000 3175200 1 180 $X=4081100 $Y=3171200
X463 672 663 682 1247 480 1248 189 14 419 CMPR32X1 $T=3643200 3578400 1 0 $X=3638900 $Y=3522600
X464 683 677 421 1249 357 357 189 14 357 CMPR32X1 $T=3755400 3074400 0 0 $X=3751100 $Y=3070400
X465 678 479 355 687 687 1250 189 14 688 CMPR32X1 $T=3755400 3477600 1 0 $X=3751100 $Y=3421800
X466 671 655 353 1251 689 1252 189 14 692 CMPR32X1 $T=3775200 3175200 1 0 $X=3770900 $Y=3119400
X467 675 652 686 1253 690 1254 189 14 693 CMPR32X1 $T=3775200 3376800 1 0 $X=3770900 $Y=3321000
X468 782 674 351 1255 694 1256 189 14 696 CMPR32X1 $T=3801600 3276000 1 0 $X=3797300 $Y=3220200
X469 679 667 787 1257 715 1258 189 14 718 CMPR32X1 $T=4039200 3376800 1 0 $X=4034900 $Y=3321000
X470 83 120 189 14 63 AND2X4 $T=1075800 3376800 0 0 $X=1071500 $Y=3372800
X471 429 267 189 14 270 AND2X4 $T=3993000 3074400 0 0 $X=3988700 $Y=3070400
X472 607 597 189 214 14 201 759 OAI211XL $T=2811600 3578400 1 0 $X=2807300 $Y=3522600
X473 802 620 189 628 14 766 220 OAI211XL $T=3036000 3477600 0 0 $X=3031700 $Y=3473600
X474 801 223 189 627 14 764 228 OAI211XL $T=3042600 3175200 0 0 $X=3038300 $Y=3171200
X475 137 14 89 189 CLKINVX3 $T=1597200 3276000 0 180 $X=1573100 $Y=3220200
X476 405 14 21 189 CLKINVX3 $T=2626800 3578400 1 0 $X=2622500 $Y=3522600
X477 800 75 189 14 BUFX12 $T=1379400 3074400 0 0 $X=1375100 $Y=3070400
X478 156 14 120 189 800 AND2X2 $T=1353000 3074400 0 0 $X=1348700 $Y=3070400
X479 798 14 510 189 60 523 NOR3XL $T=838200 3276000 1 180 $X=807500 $Y=3272000
X480 553 14 129 189 744 743 NOR3XL $T=1326600 3276000 0 180 $X=1295900 $Y=3220200
X481 16 189 293 735 506 14 NOR3X2 $T=594000 3175200 1 180 $X=543500 $Y=3171200
X482 547 189 100 534 549 14 NOR3X2 $T=1207800 3376800 0 0 $X=1203500 $Y=3372800
X483 39 189 443 551 14 48 NAND3BXL $T=534600 3477600 1 0 $X=530300 $Y=3421800
X484 738 189 497 53 14 437 NAND3BXL $T=732600 3477600 0 180 $X=695300 $Y=3421800
X485 56 189 369 518 14 444 NAND3BXL $T=759000 3376800 1 0 $X=754700 $Y=3321000
X486 734 14 46 505 42 294 189 NOR4BX1 $T=574200 3477600 1 0 $X=569900 $Y=3421800
.ENDS
***************************************
.SUBCKT ICV_4 1 2 3 4 5 6 7 8 9 10 11
*.CALIBRE ICV_CELL 9
** N=16 EP=11 IP=18 FDC=68
X0 1 2 12 3 13 4 5 6 7 DFFSXL $T=0 0 0 0 $X=-4300 $Y=-4000
X1 8 9 14 10 15 11 5 16 7 DFFSXL $T=125400 0 0 0 $X=121100 $Y=-4000
.ENDS
***************************************
.SUBCKT ADDFHXL A B CI CO VDD VSS S
** N=17 EP=7 IP=0 FDC=32
M0 VSS A 9 VSS n18 L=1.8e-07 W=3e-07 $X=6600 $Y=5700 $D=6
M1 VSS A 8 VSS n18 L=1.8e-07 W=3e-07 $X=10650 $Y=12700 $D=6
M2 10 8 VSS VSS n18 L=1.8e-07 W=3e-07 $X=16650 $Y=10400 $D=6
M3 11 B 10 VSS n18 L=1.8e-07 W=5.6e-07 $X=24250 $Y=9100 $D=6
M4 9 12 11 VSS n18 L=1.8e-07 W=5.6e-07 $X=31450 $Y=9100 $D=6
M5 13 B 9 VSS n18 L=1.8e-07 W=5.6e-07 $X=38650 $Y=9100 $D=6
M6 10 12 13 VSS n18 L=1.8e-07 W=5.6e-07 $X=45850 $Y=9100 $D=6
M7 12 B VSS VSS n18 L=1.8e-07 W=3e-07 $X=68950 $Y=10850 $D=6
M8 15 11 12 VSS n18 L=1.8e-07 W=5.6e-07 $X=76550 $Y=10850 $D=6
M9 16 13 15 VSS n18 L=1.8e-07 W=5.6e-07 $X=86550 $Y=13150 $D=6
M10 17 11 16 VSS n18 L=1.8e-07 W=5.6e-07 $X=93750 $Y=13150 $D=6
M11 14 13 17 VSS n18 L=1.8e-07 W=5.6e-07 $X=100950 $Y=13150 $D=6
M12 VSS 16 14 VSS n18 L=1.8e-07 W=3e-07 $X=109000 $Y=13150 $D=6
M13 16 CI VSS VSS n18 L=1.8e-07 W=3e-07 $X=115000 $Y=13150 $D=6
M14 VSS 15 CO VSS n18 L=1.8e-07 W=4.2e-07 $X=129650 $Y=12450 $D=6
M15 S 17 VSS VSS n18 L=1.8e-07 W=4.2e-07 $X=137200 $Y=12450 $D=6
M16 VDD A 9 VDD p18 L=1.8e-07 W=4.2e-07 $X=6200 $Y=37200 $D=10
M17 VDD A 8 VDD p18 L=1.8e-07 W=4.2e-07 $X=10250 $Y=29200 $D=10
M18 10 8 VDD VDD p18 L=1.8e-07 W=4.2e-07 $X=16250 $Y=30850 $D=10
M19 11 12 10 VDD p18 L=1.8e-07 W=8.4e-07 $X=23450 $Y=30850 $D=10
M20 9 B 11 VDD p18 L=1.8e-07 W=8.4e-07 $X=30650 $Y=30850 $D=10
M21 13 12 9 VDD p18 L=1.8e-07 W=8.4e-07 $X=37850 $Y=30850 $D=10
M22 10 B 13 VDD p18 L=1.8e-07 W=8.4e-07 $X=45050 $Y=30850 $D=10
M23 12 B VDD VDD p18 L=1.8e-07 W=4.2e-07 $X=61000 $Y=32950 $D=10
M24 15 13 12 VDD p18 L=1.8e-07 W=8.4e-07 $X=75000 $Y=32950 $D=10
M25 16 11 15 VDD p18 L=1.8e-07 W=8.4e-07 $X=82200 $Y=32950 $D=10
M26 17 13 16 VDD p18 L=1.8e-07 W=8.4e-07 $X=90400 $Y=32950 $D=10
M27 14 11 17 VDD p18 L=1.8e-07 W=8.4e-07 $X=97600 $Y=32950 $D=10
M28 VDD 16 14 VDD p18 L=1.8e-07 W=4.2e-07 $X=104800 $Y=32950 $D=10
M29 16 CI VDD VDD p18 L=1.8e-07 W=4.2e-07 $X=112950 $Y=33550 $D=10
M30 VDD 15 CO VDD p18 L=1.8e-07 W=6.4e-07 $X=128800 $Y=29300 $D=10
M31 S 17 VDD VDD p18 L=1.8e-07 W=6.4e-07 $X=137200 $Y=29300 $D=10
.ENDS
***************************************
.SUBCKT INVX3 A VSS VDD Y
** N=4 EP=4 IP=0 FDC=4
M0 VSS A Y VSS n18 L=1.8e-07 W=1e-06 $X=6250 $Y=8200 $D=6
M1 Y A VSS VSS n18 L=1.8e-07 W=8e-07 $X=12250 $Y=10200 $D=6
M2 VDD A Y VDD p18 L=1.8e-07 W=1.4e-06 $X=6250 $Y=27200 $D=10
M3 Y A VDD VDD p18 L=1.8e-07 W=1.3e-06 $X=12250 $Y=27200 $D=10
.ENDS
***************************************
.SUBCKT DFFSX2 CK D 3 4 SN QN VDD VSS Q
** N=24 EP=9 IP=0 FDC=34
M0 VSS CK 4 VSS n18 L=1.8e-07 W=4.2e-07 $X=6250 $Y=11500 $D=6
M1 15 D VSS VSS n18 L=1.8e-07 W=3e-07 $X=16050 $Y=8400 $D=6
M2 3 4 15 VSS n18 L=1.8e-07 W=3e-07 $X=21650 $Y=8400 $D=6
M3 16 11 3 VSS n18 L=1.8e-07 W=3e-07 $X=28400 $Y=15200 $D=6
M4 VSS 10 16 VSS n18 L=1.8e-07 W=3e-07 $X=34000 $Y=15200 $D=6
M5 17 SN VSS VSS n18 L=1.8e-07 W=3.6e-07 $X=40000 $Y=14600 $D=6
M6 10 3 17 VSS n18 L=1.8e-07 W=3.6e-07 $X=45600 $Y=14600 $D=6
M7 VSS 4 11 VSS n18 L=1.8e-07 W=3e-07 $X=53600 $Y=7500 $D=6
M8 18 10 VSS VSS n18 L=1.8e-07 W=6.8e-07 $X=62500 $Y=9050 $D=6
M9 12 11 18 VSS n18 L=1.8e-07 W=6.8e-07 $X=68100 $Y=9050 $D=6
M10 19 4 12 VSS n18 L=1.8e-07 W=3e-07 $X=74100 $Y=7150 $D=6
M11 VSS 13 19 VSS n18 L=1.8e-07 W=3e-07 $X=79700 $Y=7150 $D=6
M12 20 SN VSS VSS n18 L=1.8e-07 W=1e-06 $X=87300 $Y=7150 $D=6
M13 13 12 20 VSS n18 L=1.8e-07 W=1e-06 $X=92900 $Y=7150 $D=6
M14 14 13 VSS VSS n18 L=1.8e-07 W=4.8e-07 $X=105500 $Y=12450 $D=6
M15 VSS 13 QN VSS n18 L=1.8e-07 W=1.2e-06 $X=118100 $Y=5900 $D=6
M16 Q 14 VSS VSS n18 L=1.8e-07 W=1.2e-06 $X=126100 $Y=5900 $D=6
M17 VDD CK 4 VDD p18 L=1.8e-07 W=6.4e-07 $X=6500 $Y=33000 $D=10
M18 21 D VDD VDD p18 L=1.8e-07 W=4.2e-07 $X=13600 $Y=28450 $D=10
M19 3 11 21 VDD p18 L=1.8e-07 W=4.2e-07 $X=19200 $Y=28450 $D=10
M20 22 4 3 VDD p18 L=1.8e-07 W=4.2e-07 $X=26800 $Y=31500 $D=10
M21 VDD 10 22 VDD p18 L=1.8e-07 W=4.2e-07 $X=32400 $Y=31500 $D=10
M22 10 SN VDD VDD p18 L=1.8e-07 W=4e-07 $X=38400 $Y=31100 $D=10
M23 VDD 3 10 VDD p18 L=1.8e-07 W=4e-07 $X=46400 $Y=31100 $D=10
M24 11 4 VDD VDD p18 L=1.8e-07 W=4.4e-07 $X=52400 $Y=27600 $D=10
M25 23 10 VDD VDD p18 L=1.8e-07 W=1.02e-06 $X=65000 $Y=34500 $D=10
M26 12 4 23 VDD p18 L=1.8e-07 W=1.02e-06 $X=70600 $Y=34500 $D=10
M27 24 11 12 VDD p18 L=1.8e-07 W=3e-07 $X=78200 $Y=34500 $D=10
M28 VDD 13 24 VDD p18 L=1.8e-07 W=3e-07 $X=83800 $Y=34500 $D=10
M29 13 SN VDD VDD p18 L=1.8e-07 W=1.14e-06 $X=89800 $Y=26900 $D=10
M30 VDD 12 13 VDD p18 L=1.8e-07 W=1.14e-06 $X=97000 $Y=26900 $D=10
M31 14 13 VDD VDD p18 L=1.8e-07 W=7.2e-07 $X=104200 $Y=31100 $D=10
M32 VDD 13 QN VDD p18 L=1.8e-07 W=1.8e-06 $X=116800 $Y=26700 $D=10
M33 Q 14 VDD VDD p18 L=1.8e-07 W=1.8e-06 $X=124000 $Y=26700 $D=10
.ENDS
***************************************
.SUBCKT CLKBUFX8 A VSS Y VDD
** N=5 EP=4 IP=0 FDC=10
M0 VSS A 5 VSS n18 L=1.8e-07 W=9.6e-07 $X=13400 $Y=5700 $D=6
M1 Y 5 VSS VSS n18 L=1.83022e-07 W=1.20314e-06 $X=19800 $Y=12200 $D=6
M2 VSS 5 Y VSS n18 L=1.83022e-07 W=1.20314e-06 $X=26200 $Y=5700 $D=6
M3 Y 5 VSS VSS n18 L=1.8e-07 W=4.8e-07 $X=33800 $Y=12600 $D=6
M4 5 A VDD VDD p18 L=1.83034e-07 W=1.19814e-06 $X=5400 $Y=27000 $D=10
M5 VDD A 5 VDD p18 L=1.83034e-07 W=1.19814e-06 $X=11800 $Y=32500 $D=10
M6 Y 5 VDD VDD p18 L=1.82016e-07 W=1.80314e-06 $X=19000 $Y=27000 $D=10
M7 VDD 5 Y VDD p18 L=1.82016e-07 W=1.80314e-06 $X=25400 $Y=34600 $D=10
M8 Y 5 VDD VDD p18 L=1.82016e-07 W=1.80314e-06 $X=31800 $Y=27000 $D=10
M9 VDD 5 Y VDD p18 L=1.82016e-07 W=1.80314e-06 $X=38200 $Y=34600 $D=10
.ENDS
***************************************
.SUBCKT BUFX8 A VDD VSS Y
** N=5 EP=4 IP=0 FDC=12
M0 5 A VSS VSS n18 L=1.8e-07 W=9.6e-07 $X=6200 $Y=5700 $D=6
M1 VSS A 5 VSS n18 L=1.8e-07 W=9.6e-07 $X=13400 $Y=5700 $D=6
M2 Y 5 VSS VSS n18 L=1.83022e-07 W=1.20314e-06 $X=19800 $Y=12200 $D=6
M3 VSS 5 Y VSS n18 L=1.83022e-07 W=1.20314e-06 $X=26200 $Y=5700 $D=6
M4 Y 5 VSS VSS n18 L=1.83022e-07 W=1.20314e-06 $X=32600 $Y=12200 $D=6
M5 VSS 5 Y VSS n18 L=1.83022e-07 W=1.20314e-06 $X=39000 $Y=5700 $D=6
M6 5 A VDD VDD p18 L=1.82563e-07 W=1.41814e-06 $X=6200 $Y=27000 $D=10
M7 VDD A 5 VDD p18 L=1.82563e-07 W=1.41814e-06 $X=12600 $Y=32500 $D=10
M8 Y 5 VDD VDD p18 L=1.82016e-07 W=1.80314e-06 $X=19000 $Y=27000 $D=10
M9 VDD 5 Y VDD p18 L=1.82016e-07 W=1.80314e-06 $X=25400 $Y=34600 $D=10
M10 Y 5 VDD VDD p18 L=1.82016e-07 W=1.80314e-06 $X=31800 $Y=27000 $D=10
M11 VDD 5 Y VDD p18 L=1.82016e-07 W=1.80314e-06 $X=38200 $Y=34600 $D=10
.ENDS
***************************************
.SUBCKT OR4X2 A B C VSS D VDD Y
** N=11 EP=7 IP=0 FDC=10
M0 8 A VSS VSS n18 L=1.8e-07 W=4.8e-07 $X=4600 $Y=12750 $D=6
M1 VSS B 8 VSS n18 L=1.8e-07 W=4.8e-07 $X=11800 $Y=12750 $D=6
M2 8 C VSS VSS n18 L=1.8e-07 W=4.8e-07 $X=17900 $Y=12750 $D=6
M3 VSS D 8 VSS n18 L=1.8e-07 W=4.8e-07 $X=25100 $Y=12750 $D=6
M4 Y 8 VSS VSS n18 L=1.8e-07 W=1.2e-06 $X=31100 $Y=5700 $D=6
M5 9 A 8 VDD p18 L=1.8e-07 W=1.32e-06 $X=6200 $Y=28250 $D=10
M6 10 B 9 VDD p18 L=1.8e-07 W=1.32e-06 $X=11800 $Y=28250 $D=10
M7 11 C 10 VDD p18 L=1.8e-07 W=1.32e-06 $X=17900 $Y=28250 $D=10
M8 VDD D 11 VDD p18 L=1.8e-07 W=1.32e-06 $X=23500 $Y=28250 $D=10
M9 Y 8 VDD VDD p18 L=1.8e-07 W=1.74e-06 $X=31500 $Y=27300 $D=10
.ENDS
***************************************
.SUBCKT BUFX16 A Y VSS VDD
** N=5 EP=4 IP=0 FDC=23
M0 VSS A 5 VSS n18 L=1.82889e-07 W=1.25814e-06 $X=5400 $Y=5700 $D=6
M1 5 A VSS VSS n18 L=1.82889e-07 W=1.25814e-06 $X=11800 $Y=12750 $D=6
M2 VSS A 5 VSS n18 L=1.82889e-07 W=1.25814e-06 $X=18200 $Y=5700 $D=6
M3 Y 5 VSS VSS n18 L=1.83009e-07 W=1.20814e-06 $X=25000 $Y=12250 $D=6
M4 VSS 5 Y VSS n18 L=1.83009e-07 W=1.20814e-06 $X=31400 $Y=5700 $D=6
M5 Y 5 VSS VSS n18 L=1.83009e-07 W=1.20814e-06 $X=37800 $Y=12250 $D=6
M6 VSS 5 Y VSS n18 L=1.83009e-07 W=1.20814e-06 $X=44200 $Y=5700 $D=6
M7 Y 5 VSS VSS n18 L=1.83009e-07 W=1.20814e-06 $X=50600 $Y=12250 $D=6
M8 VSS 5 Y VSS n18 L=1.83009e-07 W=1.20814e-06 $X=57000 $Y=5700 $D=6
M9 Y 5 VSS VSS n18 L=1.83009e-07 W=1.20814e-06 $X=64200 $Y=12250 $D=6
M10 VSS 5 Y VSS n18 L=1.83009e-07 W=1.20814e-06 $X=70600 $Y=5700 $D=6
M11 5 A VDD VDD p18 L=1.82563e-07 W=1.41814e-06 $X=5400 $Y=27000 $D=10
M12 VDD A 5 VDD p18 L=1.82563e-07 W=1.41814e-06 $X=11800 $Y=32500 $D=10
M13 5 A VDD VDD p18 L=1.82546e-07 W=1.42814e-06 $X=18200 $Y=27000 $D=10
M14 VDD A 5 VDD p18 L=1.82546e-07 W=1.42814e-06 $X=24600 $Y=32500 $D=10
M15 Y 5 VDD VDD p18 L=1.82016e-07 W=1.80314e-06 $X=31400 $Y=27000 $D=10
M16 VDD 5 Y VDD p18 L=1.82016e-07 W=1.80314e-06 $X=37800 $Y=34600 $D=10
M17 Y 5 VDD VDD p18 L=1.82016e-07 W=1.80314e-06 $X=44200 $Y=27000 $D=10
M18 VDD 5 Y VDD p18 L=1.82016e-07 W=1.80314e-06 $X=50600 $Y=34600 $D=10
M19 Y 5 VDD VDD p18 L=1.82016e-07 W=1.80314e-06 $X=57000 $Y=27000 $D=10
M20 VDD 5 Y VDD p18 L=1.82016e-07 W=1.80314e-06 $X=63800 $Y=34600 $D=10
M21 Y 5 VDD VDD p18 L=1.82016e-07 W=1.80314e-06 $X=71000 $Y=27000 $D=10
M22 VDD 5 Y VDD p18 L=1.82016e-07 W=1.80314e-06 $X=77400 $Y=34600 $D=10
.ENDS
***************************************
.SUBCKT AOI22X2 B0 B1 VDD A0 A1 Y VSS
** N=12 EP=7 IP=0 FDC=16
M0 9 B1 VSS VSS n18 L=1.8e-07 W=8e-07 $X=6200 $Y=10200 $D=6
M1 Y B0 9 VSS n18 L=1.8e-07 W=8e-07 $X=11800 $Y=10200 $D=6
M2 10 B0 Y VSS n18 L=1.8e-07 W=8e-07 $X=19000 $Y=10200 $D=6
M3 VSS B1 10 VSS n18 L=1.8e-07 W=8e-07 $X=24600 $Y=10200 $D=6
M4 11 A1 VSS VSS n18 L=1.8e-07 W=8e-07 $X=30600 $Y=10200 $D=6
M5 Y A0 11 VSS n18 L=1.8e-07 W=8e-07 $X=36200 $Y=10200 $D=6
M6 12 A0 Y VSS n18 L=1.8e-07 W=8e-07 $X=43400 $Y=10200 $D=6
M7 VSS A1 12 VSS n18 L=1.8e-07 W=8e-07 $X=49000 $Y=10200 $D=6
M8 VDD B1 8 VDD p18 L=1.83034e-07 W=1.19814e-06 $X=5400 $Y=35200 $D=10
M9 8 B0 VDD VDD p18 L=1.83034e-07 W=1.19814e-06 $X=11800 $Y=29800 $D=10
M10 VDD B0 8 VDD p18 L=1.83034e-07 W=1.19814e-06 $X=18200 $Y=35200 $D=10
M11 8 B1 VDD VDD p18 L=1.83034e-07 W=1.19814e-06 $X=24600 $Y=29800 $D=10
M12 Y A1 8 VDD p18 L=1.83034e-07 W=1.19814e-06 $X=31000 $Y=35200 $D=10
M13 8 A0 Y VDD p18 L=1.83034e-07 W=1.19814e-06 $X=38200 $Y=35200 $D=10
M14 Y A0 8 VDD p18 L=1.83034e-07 W=1.19814e-06 $X=44600 $Y=29800 $D=10
M15 8 A1 Y VDD p18 L=1.83034e-07 W=1.19814e-06 $X=51000 $Y=35200 $D=10
.ENDS
***************************************
.SUBCKT ICV_5 2 3 4 5 6 7 8 9 11 12 13 15 16 17 18 19 20 21 22 23
+ 24 25 27 28 30 31 34 35 36 39 40 41 42 44 45 46 47 49 50 52
+ 53 54 55 56 57 59 62 65 66 67 68 69 70 71 72 73 74 75 76 77
+ 78 79 80 81 82 83 84 85 86 87 88 90 91 92 93 94 95 96 97 98
+ 99 100 103 104 105 106 108 110 111 112 113 115 116 117 118 119 120 121 123 125
+ 127 129 130 131 132 134 135 136 137 139 140 141 142 143 144 145 146 147 148 149
+ 150 151 152 154 155 157 158 160 161 162 163 164 166 167 168 170 173 174 175 176
+ 177 178 179 180 181 183 184 186 188 191 193 195 196 198 199 201 202 203 204 205
+ 206 208 209 210 212 216 217 218 219 220 222 223 227 228 231 232 233 236 238 239
+ 241 242 243 245 246 248 253 258 259 260 261 262 263 264 266 269 272 274 276 277
+ 278 279 280 281 282 283 284 285 286 287 288 289 290 291 292 293 294 295 296 297
+ 298 299 300 301 302 303 304 305 306 307 308 309 310 311 312 313 314 315 316 317
+ 318 319 320 321 322 323 324 325 326 327 328 329 330 331 332 333 334 335 337 338
+ 339 340 341 342 343 344 345 346 347 348 349 350 351 352 353 354 355 356 357 358
+ 359 360 361 362 363 364 365 366 367 368 369 370 371 372 373 374 375 376 377 378
+ 379 380 381 382 383 384 385 386 387 388 389 390 391 392 393 394 395 396 397 398
+ 399 400 401 402 403 404 405 406 407 408 409 410 411 412 413 414 415 417 418 420
+ 422 423 424 425 426 427
*.CALIBRE ICV_CELL 2
** N=1179 EP=346 IP=2961 FDC=7647
M0 1163 681 725 175 n18 L=1.8e-07 W=4.4e-07 $X=745800 $Y=2959000 $D=6
M1 1164 465 1163 175 n18 L=1.8e-07 W=4.4e-07 $X=751400 $Y=2959000 $D=6
M2 175 4 1164 175 n18 L=1.8e-07 W=4.4e-07 $X=757000 $Y=2959000 $D=6
M3 77 725 175 175 n18 L=1.8e-07 W=4.6e-07 $X=763300 $Y=2958100 $D=6
M4 175 186 738 175 n18 L=1.8e-07 W=5.6e-07 $X=2271700 $Y=2682450 $D=6
M5 1165 533 175 175 n18 L=1.8e-07 W=3.6e-07 $X=2277700 $Y=2681800 $D=6
M6 735 738 1165 175 n18 L=1.8e-07 W=3.6e-07 $X=2283300 $Y=2681800 $D=6
M7 1166 739 735 175 n18 L=1.8e-07 W=3e-07 $X=2291300 $Y=2682400 $D=6
M8 175 736 1166 175 n18 L=1.8e-07 W=3e-07 $X=2296900 $Y=2682400 $D=6
M9 1167 19 175 175 n18 L=1.8e-07 W=5.4e-07 $X=2304500 $Y=2680100 $D=6
M10 736 735 1167 175 n18 L=1.8e-07 W=5.4e-07 $X=2310100 $Y=2680100 $D=6
M11 175 738 739 175 n18 L=1.8e-07 W=4e-07 $X=2326100 $Y=2682500 $D=6
M12 1168 736 175 175 n18 L=1.8e-07 W=6e-07 $X=2333700 $Y=2680600 $D=6
M13 740 739 1168 175 n18 L=1.8e-07 W=6e-07 $X=2339300 $Y=2680600 $D=6
M14 1169 739 740 175 n18 L=1.8e-07 W=6e-07 $X=2346500 $Y=2680600 $D=6
M15 175 736 1169 175 n18 L=1.8e-07 W=6e-07 $X=2352100 $Y=2680600 $D=6
M16 1170 738 740 175 n18 L=1.8e-07 W=3e-07 $X=2366800 $Y=2686300 $D=6
M17 175 741 1170 175 n18 L=1.8e-07 W=3e-07 $X=2373600 $Y=2686300 $D=6
M18 1171 19 175 175 n18 L=1.8e-07 W=9.4e-07 $X=2379600 $Y=2678200 $D=6
M19 741 740 1171 175 n18 L=1.8e-07 W=9.4e-07 $X=2385200 $Y=2678200 $D=6
M20 1172 740 741 175 n18 L=1.8e-07 W=9.4e-07 $X=2392400 $Y=2678200 $D=6
M21 175 19 1172 175 n18 L=1.8e-07 W=9.4e-07 $X=2398000 $Y=2678200 $D=6
M22 742 741 175 175 n18 L=1.8e-07 W=9.6e-07 $X=2405200 $Y=2678200 $D=6
M23 490 741 175 175 n18 L=1.8e-07 W=1.2e-06 $X=2418200 $Y=2676900 $D=6
M24 175 741 490 175 n18 L=1.8e-07 W=1.2e-06 $X=2425400 $Y=2676900 $D=6
M25 166 742 175 175 n18 L=1.8e-07 W=1.2e-06 $X=2432600 $Y=2676900 $D=6
M26 175 742 166 175 n18 L=1.8e-07 W=1.2e-06 $X=2439800 $Y=2676900 $D=6
M27 1173 699 403 175 n18 L=1.8e-07 W=9.4e-07 $X=3119000 $Y=2579400 $D=6
M28 746 202 1173 175 n18 L=1.8e-07 W=9.6e-07 $X=3125000 $Y=2576500 $D=6
M29 175 204 746 175 n18 L=1.8e-07 W=9.6e-07 $X=3132200 $Y=2576500 $D=6
M30 746 574 175 175 n18 L=1.8e-07 W=9.6e-07 $X=3140200 $Y=2576500 $D=6
M31 19 681 725 19 p18 L=1.8e-07 W=4e-07 $X=746000 $Y=2929850 $D=10
M32 725 465 19 19 p18 L=1.8e-07 W=4e-07 $X=750400 $Y=2939150 $D=10
M33 19 4 725 19 p18 L=1.8e-07 W=4e-07 $X=759500 $Y=2942150 $D=10
M34 77 725 19 19 p18 L=1.8e-07 W=6.4e-07 $X=763800 $Y=2930550 $D=10
M35 19 186 738 19 p18 L=1.8e-07 W=8.4e-07 $X=2270900 $Y=2699000 $D=10
M36 1174 533 19 19 p18 L=1.8e-07 W=5.4e-07 $X=2277800 $Y=2699000 $D=10
M37 735 739 1174 19 p18 L=1.8e-07 W=5.4e-07 $X=2283400 $Y=2699000 $D=10
M38 1175 738 735 19 p18 L=1.8e-07 W=4.2e-07 $X=2291400 $Y=2700400 $D=10
M39 19 736 1175 19 p18 L=1.8e-07 W=4.2e-07 $X=2297000 $Y=2700400 $D=10
M40 736 19 19 19 p18 L=1.8e-07 W=6.2e-07 $X=2305500 $Y=2700400 $D=10
M41 19 735 736 19 p18 L=1.8e-07 W=6.2e-07 $X=2312700 $Y=2700400 $D=10
M42 739 738 19 19 p18 L=1.8e-07 W=6e-07 $X=2318700 $Y=2700400 $D=10
M43 1176 736 19 19 p18 L=1.8e-07 W=9e-07 $X=2332100 $Y=2699400 $D=10
M44 740 738 1176 19 p18 L=1.8e-07 W=9e-07 $X=2337700 $Y=2699400 $D=10
M45 1177 738 740 19 p18 L=1.8e-07 W=9e-07 $X=2344900 $Y=2699400 $D=10
M46 19 736 1177 19 p18 L=1.8e-07 W=9e-07 $X=2350500 $Y=2699400 $D=10
M47 1178 739 740 19 p18 L=1.8e-07 W=3e-07 $X=2364000 $Y=2699800 $D=10
M48 19 741 1178 19 p18 L=1.8e-07 W=3e-07 $X=2369600 $Y=2699800 $D=10
M49 741 19 19 19 p18 L=1.8e-07 W=1.06e-06 $X=2375600 $Y=2699800 $D=10
M50 19 740 741 19 p18 L=1.8e-07 W=1.06e-06 $X=2382800 $Y=2699800 $D=10
M51 741 740 19 19 p18 L=1.8e-07 W=1.06e-06 $X=2390000 $Y=2699800 $D=10
M52 19 19 741 19 p18 L=1.8e-07 W=1.06e-06 $X=2397200 $Y=2699800 $D=10
M53 742 741 19 19 p18 L=1.8e-07 W=1.44e-06 $X=2404400 $Y=2699800 $D=10
M54 490 741 19 19 p18 L=1.8e-07 W=1.8e-06 $X=2417000 $Y=2697900 $D=10
M55 19 741 490 19 p18 L=1.8e-07 W=1.8e-06 $X=2424200 $Y=2697900 $D=10
M56 166 742 19 19 p18 L=1.8e-07 W=1.76e-06 $X=2431400 $Y=2698300 $D=10
M57 19 742 166 19 p18 L=1.8e-07 W=1.76e-06 $X=2438600 $Y=2698300 $D=10
M58 19 699 403 19 p18 L=1.8e-07 W=9e-07 $X=3118600 $Y=2602600 $D=10
M59 403 202 19 19 p18 L=1.8e-07 W=9e-07 $X=3126600 $Y=2602600 $D=10
M60 1179 204 403 19 p18 L=1.8e-07 W=1.2e-06 $X=3133800 $Y=2599600 $D=10
M61 19 574 1179 19 p18 L=1.8e-07 W=1.2e-06 $X=3140200 $Y=2599600 $D=10
X62 685 19 175 373 INVXL $T=1227600 2872800 1 0 $X=1223300 $Y=2817000
X63 20 19 175 487 INVXL $T=1623600 2872800 0 0 $X=1619300 $Y=2868800
X64 174 19 175 393 INVXL $T=2640000 2973600 0 180 $X=2622500 $Y=2917800
X65 193 19 175 562 INVXL $T=2970000 3074400 1 0 $X=2965700 $Y=3018600
X66 564 19 175 563 INVXL $T=2996400 2671200 1 180 $X=2978900 $Y=2667200
X67 566 19 175 743 INVXL $T=3009600 2671200 1 180 $X=2992100 $Y=2667200
X68 694 19 175 565 INVXL $T=2996400 2973600 1 0 $X=2992100 $Y=2917800
X69 204 19 175 568 INVXL $T=3055800 2973600 1 0 $X=3051500 $Y=2917800
X70 584 19 175 579 INVXL $T=3115200 2973600 0 180 $X=3097700 $Y=2917800
X71 437 19 175 582 INVXL $T=3121800 2872800 0 0 $X=3117500 $Y=2868800
X72 209 19 175 212 INVXL $T=3154800 2570400 0 0 $X=3150500 $Y=2566400
X73 701 19 175 704 INVXL $T=3174600 2772000 1 0 $X=3170300 $Y=2716200
X74 601 19 175 611 INVXL $T=3267000 2872800 1 0 $X=3262700 $Y=2817000
X75 600 19 175 606 INVXL $T=3300000 2772000 0 0 $X=3295700 $Y=2768000
X76 327 19 175 407 INVXL $T=3339600 3074400 1 0 $X=3335300 $Y=3018600
X77 340 19 175 652 INVXL $T=4052400 2973600 0 0 $X=4048100 $Y=2969600
X78 636 19 175 657 INVXL $T=4085400 2973600 1 0 $X=4081100 $Y=2917800
X79 655 19 175 720 INVXL $T=4111800 2872800 0 0 $X=4107500 $Y=2868800
X80 666 19 175 667 INVXL $T=4204200 2973600 0 180 $X=4186700 $Y=2917800
X81 454 19 175 673 INVXL $T=4210800 2772000 1 0 $X=4206500 $Y=2716200
X82 664 19 175 670 INVXL $T=4243800 2772000 0 0 $X=4239500 $Y=2768000
X83 695 175 193 321 19 435 OAI21XL $T=3003000 2973600 1 180 $X=2972300 $Y=2969600
X84 567 175 569 744 19 697 OAI21XL $T=3042600 3074400 1 0 $X=3038300 $Y=3018600
X85 438 175 698 576 19 572 OAI21XL $T=3095400 2772000 0 180 $X=3064700 $Y=2716200
X86 575 175 568 745 19 585 OAI21XL $T=3088800 2973600 0 0 $X=3084500 $Y=2969600
X87 437 175 578 438 19 580 OAI21XL $T=3095400 2772000 0 0 $X=3091100 $Y=2768000
X88 586 175 580 747 19 592 OAI21XL $T=3154800 2772000 0 0 $X=3150500 $Y=2768000
X89 701 175 439 590 19 219 OAI21XL $T=3161400 2671200 0 0 $X=3157100 $Y=2667200
X90 593 175 212 596 19 708 OAI21XL $T=3220800 2671200 1 0 $X=3216500 $Y=2615400
X91 600 175 442 602 19 443 OAI21XL $T=3267000 2772000 0 0 $X=3262700 $Y=2768000
X92 613 175 617 712 19 713 OAI21XL $T=3385800 2872800 1 0 $X=3381500 $Y=2817000
X93 228 175 619 605 19 621 OAI21XL $T=3392400 2973600 0 0 $X=3388100 $Y=2969600
X94 228 175 713 615 19 714 OAI21XL $T=3399000 2772000 0 0 $X=3394700 $Y=2768000
X95 228 175 445 616 19 412 OAI21XL $T=3405600 2671200 1 0 $X=3401300 $Y=2615400
X96 655 175 643 639 19 645 OAI21XL $T=3966600 2973600 1 0 $X=3962300 $Y=2917800
X97 340 175 341 342 19 645 OAI21XL $T=4019400 3074400 1 0 $X=4015100 $Y=3018600
X98 345 175 650 719 19 637 OAI21XL $T=4065600 2973600 0 180 $X=4034900 $Y=2917800
X99 663 175 455 660 19 665 OAI21XL $T=4191000 2973600 1 180 $X=4160300 $Y=2969600
X100 426 175 272 348 19 672 OAI21XL $T=4243800 3074400 0 180 $X=4213100 $Y=3018600
X101 456 175 349 455 19 666 OAI21XL $T=4250400 2973600 0 0 $X=4246100 $Y=2969600
X102 664 175 675 674 19 669 OAI21XL $T=4263600 2872800 0 0 $X=4259300 $Y=2868800
X103 723 175 19 279 13 NAND2XL $T=165000 2671200 1 180 $X=140900 $Y=2667200
X104 21 175 19 679 22 NAND2XL $T=297000 2671200 0 0 $X=292700 $Y=2667200
X105 23 175 19 464 47 NAND2XL $T=349800 2671200 0 180 $X=325700 $Y=2615400
X106 115 175 19 298 687 NAND2XL $T=1379400 2872800 1 180 $X=1355300 $Y=2868800
X107 175 175 19 151 517 NAND2XL $T=1914000 2772000 1 0 $X=1909700 $Y=2716200
X108 691 175 19 6 387 NAND2XL $T=1947000 3074400 0 180 $X=1922900 $Y=3018600
X109 518 175 19 6 521 NAND2XL $T=1966800 2872800 0 0 $X=1962500 $Y=2868800
X110 731 175 19 6 520 NAND2XL $T=1973400 2973600 0 0 $X=1969100 $Y=2969600
X111 527 175 19 152 80 NAND2XL $T=2072400 2772000 1 180 $X=2048300 $Y=2768000
X112 390 175 19 151 732 NAND2XL $T=2085600 2973600 1 180 $X=2061500 $Y=2969600
X113 528 175 19 152 523 NAND2XL $T=2098800 2872800 1 180 $X=2074700 $Y=2868800
X114 531 175 19 152 524 NAND2XL $T=2125200 2872800 0 0 $X=2120900 $Y=2868800
X115 543 175 19 316 533 NAND2XL $T=2646600 2772000 0 180 $X=2622500 $Y=2716200
X116 396 175 19 316 434 NAND2XL $T=2679600 2772000 0 180 $X=2655500 $Y=2716200
X117 546 175 19 316 537 NAND2XL $T=2719200 2772000 0 180 $X=2695100 $Y=2716200
X118 188 175 19 316 547 NAND2XL $T=2732400 2570400 1 180 $X=2708300 $Y=2566400
X119 549 175 19 316 535 NAND2XL $T=2752200 2772000 0 180 $X=2728100 $Y=2716200
X120 551 175 19 316 540 NAND2XL $T=2798400 2772000 0 180 $X=2774300 $Y=2716200
X121 398 175 19 316 552 NAND2XL $T=2818200 2570400 1 180 $X=2794100 $Y=2566400
X122 553 175 19 316 538 NAND2XL $T=2818200 2872800 0 180 $X=2794100 $Y=2817000
X123 397 175 19 316 548 NAND2XL $T=2844600 2772000 0 180 $X=2820500 $Y=2716200
X124 554 175 19 316 544 NAND2XL $T=2864400 2872800 0 180 $X=2840300 $Y=2817000
X125 556 175 19 316 534 NAND2XL $T=2871000 2671200 0 180 $X=2846900 $Y=2615400
X126 399 175 19 316 559 NAND2XL $T=2877600 2671200 0 0 $X=2873300 $Y=2667200
X127 400 175 19 316 555 NAND2XL $T=2963400 2671200 1 180 $X=2939300 $Y=2667200
X128 321 175 19 562 567 NAND2XL $T=3003000 3074400 0 180 $X=2978900 $Y=3018600
X129 198 175 19 484 695 NAND2XL $T=3029400 2973600 0 180 $X=3005300 $Y=2917800
X130 567 175 19 569 744 NAND2XL $T=3016200 3074400 1 0 $X=3011900 $Y=3018600
X131 695 175 19 565 575 NAND2XL $T=3029400 2973600 1 0 $X=3025100 $Y=2917800
X132 570 175 19 436 566 NAND2XL $T=3055800 2772000 1 180 $X=3031700 $Y=2768000
X133 571 175 19 140 438 NAND2XL $T=3049200 2872800 0 0 $X=3044900 $Y=2868800
X134 201 175 19 573 574 NAND2XL $T=3062400 2570400 0 0 $X=3058100 $Y=2566400
X135 575 175 19 568 745 NAND2XL $T=3069000 2973600 0 0 $X=3064700 $Y=2969600
X136 201 175 19 696 699 NAND2XL $T=3082200 2570400 0 0 $X=3077900 $Y=2566400
X137 196 175 19 697 402 NAND2XL $T=3082200 3074400 1 0 $X=3077900 $Y=3018600
X138 202 175 19 201 748 NAND2XL $T=3095400 2671200 1 0 $X=3091100 $Y=2615400
X139 438 175 19 582 581 NAND2XL $T=3128400 2872800 0 180 $X=3104300 $Y=2817000
X140 577 175 19 302 576 NAND2XL $T=3121800 2671200 0 0 $X=3117500 $Y=2667200
X141 586 175 19 580 747 NAND2XL $T=3128400 2772000 0 0 $X=3124100 $Y=2768000
X142 196 175 19 585 700 NAND2XL $T=3148200 3074400 0 180 $X=3124100 $Y=3018600
X143 433 175 19 571 584 NAND2XL $T=3141600 2872800 0 0 $X=3137300 $Y=2868800
X144 206 175 19 577 590 NAND2XL $T=3148200 2772000 1 0 $X=3143900 $Y=2716200
X145 404 175 19 405 593 NAND2XL $T=3168000 2570400 0 0 $X=3163700 $Y=2566400
X146 584 175 19 583 595 NAND2XL $T=3174600 2973600 1 0 $X=3170300 $Y=2917800
X147 590 175 19 704 594 NAND2XL $T=3187800 2772000 1 0 $X=3183500 $Y=2716200
X148 196 175 19 705 702 NAND2XL $T=3214200 2872800 0 180 $X=3190100 $Y=2817000
X149 593 175 19 212 596 NAND2XL $T=3201000 2570400 0 0 $X=3196700 $Y=2566400
X150 196 175 19 592 706 NAND2XL $T=3240600 2772000 0 180 $X=3216500 $Y=2716200
X151 440 175 19 441 600 NAND2XL $T=3247200 2772000 0 0 $X=3242900 $Y=2768000
X152 196 175 19 708 707 NAND2XL $T=3260400 2671200 1 0 $X=3256100 $Y=2615400
X153 181 175 19 598 602 NAND2XL $T=3273600 2772000 1 0 $X=3269300 $Y=2716200
X154 444 175 19 603 325 NAND2XL $T=3293400 3074400 1 0 $X=3289100 $Y=3018600
X155 600 175 19 611 613 NAND2XL $T=3313200 2872800 1 0 $X=3308900 $Y=2817000
X156 613 175 19 617 712 NAND2XL $T=3379200 2872800 1 180 $X=3355100 $Y=2868800
X157 618 175 19 324 610 NAND2XL $T=3372600 2570400 0 0 $X=3368300 $Y=2566400
X158 261 175 19 324 318 NAND2XL $T=3372600 2671200 0 0 $X=3368300 $Y=2667200
X159 329 175 19 324 558 NAND2XL $T=3399000 2671200 0 180 $X=3374900 $Y=2615400
X160 327 175 19 328 614 NAND2XL $T=3379200 3074400 1 0 $X=3374900 $Y=3018600
X161 330 175 19 324 560 NAND2XL $T=3412200 2671200 1 180 $X=3388100 $Y=2667200
X162 448 175 19 324 609 NAND2XL $T=3412200 2772000 0 180 $X=3388100 $Y=2716200
X163 447 175 19 324 410 NAND2XL $T=3418800 2570400 1 180 $X=3394700 $Y=2566400
X164 332 175 19 324 591 NAND2XL $T=3438600 2772000 0 180 $X=3414500 $Y=2716200
X165 334 175 19 324 557 NAND2XL $T=3478200 2772000 0 180 $X=3454100 $Y=2716200
X166 446 175 19 324 413 NAND2XL $T=3484800 2570400 1 180 $X=3460700 $Y=2566400
X167 414 175 19 324 588 NAND2XL $T=3504600 2570400 1 180 $X=3480500 $Y=2566400
X168 631 175 19 717 655 NAND2XL $T=3841200 2872800 0 0 $X=3836900 $Y=2868800
X169 339 175 19 453 630 NAND2XL $T=3900600 2772000 1 180 $X=3876500 $Y=2768000
X170 339 175 19 637 635 NAND2XL $T=3913800 2872800 1 180 $X=3889700 $Y=2868800
X171 339 175 19 450 716 NAND2XL $T=3940200 2772000 1 180 $X=3916100 $Y=2768000
X172 449 175 19 638 639 NAND2XL $T=3920400 2872800 0 0 $X=3916100 $Y=2868800
X173 644 175 19 640 340 NAND2XL $T=3953400 2973600 0 0 $X=3949100 $Y=2969600
X174 345 175 19 650 719 NAND2XL $T=4085400 2973600 1 180 $X=4061300 $Y=2969600
X175 339 175 19 451 641 NAND2XL $T=4111800 2872800 0 180 $X=4087700 $Y=2817000
X176 655 175 19 657 658 NAND2XL $T=4092000 2872800 0 0 $X=4087700 $Y=2868800
X177 339 175 19 662 452 NAND2XL $T=4151400 2872800 0 180 $X=4127300 $Y=2817000
X178 661 175 19 648 663 NAND2XL $T=4131600 2973600 0 0 $X=4127300 $Y=2969600
X179 656 175 19 653 664 NAND2XL $T=4138200 2772000 1 0 $X=4133900 $Y=2716200
X180 339 175 19 668 721 NAND2XL $T=4171200 2772000 1 0 $X=4166900 $Y=2716200
X181 654 175 19 634 674 NAND2XL $T=4217400 2872800 0 0 $X=4213100 $Y=2868800
X182 664 175 19 673 664 NAND2XL $T=4224000 2772000 0 0 $X=4219700 $Y=2768000
X183 457 175 19 427 456 NAND2XL $T=4276800 2973600 0 0 $X=4272500 $Y=2969600
X184 710 711 175 19 445 XOR2XL $T=3339600 2772000 0 0 $X=3335300 $Y=2768000
X185 647 649 175 19 450 XOR2XL $T=4045800 2973600 1 180 $X=3988700 $Y=2969600
X186 646 651 175 19 642 XOR2XL $T=4078800 2872800 1 180 $X=4021700 $Y=2868800
X187 658 667 175 19 453 XOR2XL $T=4184400 2872800 1 180 $X=4127300 $Y=2868800
X188 671 670 175 19 662 XOR2XL $T=4243800 2872800 0 180 $X=4186700 $Y=2817000
X189 7 20 750 19 751 460 175 752 19 DFFSXL $T=6600 2671200 0 0 $X=2300 $Y=2667200
X190 8 20 753 19 754 461 175 755 19 DFFSXL $T=52800 2872800 1 0 $X=48500 $Y=2817000
X191 8 36 756 19 757 462 175 758 19 DFFSXL $T=52800 3074400 1 0 $X=48500 $Y=3018600
X192 9 36 759 19 760 676 175 761 19 DFFSXL $T=66000 2973600 1 0 $X=61700 $Y=2917800
X193 9 15 762 19 763 284 175 764 19 DFFSXL $T=184800 2772000 0 0 $X=180500 $Y=2768000
X194 16 15 765 19 766 351 175 767 19 DFFSXL $T=198000 2973600 0 0 $X=193700 $Y=2969600
X195 16 350 768 19 769 34 175 770 19 DFFSXL $T=244200 3074400 1 0 $X=239900 $Y=3018600
X196 16 91 771 19 772 27 175 773 19 DFFSXL $T=270600 2973600 1 0 $X=266300 $Y=2917800
X197 16 17 774 19 775 470 175 776 19 DFFSXL $T=316800 2872800 0 0 $X=312500 $Y=2868800
X198 28 30 777 19 778 680 175 779 19 DFFSXL $T=382800 3074400 1 0 $X=378500 $Y=3018600
X199 16 30 780 19 781 472 175 782 19 DFFSXL $T=389400 2772000 0 0 $X=385100 $Y=2768000
X200 11 67 783 19 19 473 175 784 19 DFFSXL $T=402600 2671200 1 0 $X=398300 $Y=2615400
X201 16 276 785 288 786 475 175 787 19 DFFSXL $T=442200 2872800 1 0 $X=437900 $Y=2817000
X202 7 12 788 288 789 479 175 790 19 DFFSXL $T=528000 2772000 1 0 $X=523700 $Y=2716200
X203 11 88 791 19 792 480 175 793 19 DFFSXL $T=534600 2570400 0 0 $X=530300 $Y=2566400
X204 16 76 794 288 795 57 175 796 19 DFFSXL $T=580800 2872800 1 0 $X=576500 $Y=2817000
X205 16 50 797 288 798 482 175 799 19 DFFSXL $T=580800 2973600 1 0 $X=576500 $Y=2917800
X206 39 50 800 288 801 486 175 802 19 DFFSXL $T=679800 2973600 0 0 $X=675500 $Y=2969600
X207 16 12 803 288 804 492 175 805 19 DFFSXL $T=686400 2772000 0 0 $X=682100 $Y=2768000
X208 39 67 806 288 807 489 175 808 19 DFFSXL $T=798600 2671200 1 0 $X=794300 $Y=2615400
X209 39 66 809 288 810 72 175 811 19 DFFSXL $T=805200 2872800 1 0 $X=800900 $Y=2817000
X210 39 36 812 288 813 362 175 814 19 DFFSXL $T=805200 2973600 1 0 $X=800900 $Y=2917800
X211 28 56 815 288 816 726 175 817 19 DFFSXL $T=811800 2872800 0 0 $X=807500 $Y=2868800
X212 54 292 818 19 819 728 175 820 19 DFFSXL $T=917400 2570400 0 0 $X=913100 $Y=2566400
X213 78 91 821 288 822 366 175 823 19 DFFSXL $T=924000 2973600 0 0 $X=919700 $Y=2969600
X214 28 76 824 288 825 367 175 826 19 DFFSXL $T=943800 2872800 1 0 $X=939500 $Y=2817000
X215 78 76 827 288 828 500 175 829 19 DFFSXL $T=943800 2973600 1 0 $X=939500 $Y=2917800
X216 28 12 830 19 831 495 175 832 19 DFFSXL $T=963600 2671200 0 0 $X=959300 $Y=2667200
X217 293 67 833 288 834 119 175 835 19 DFFSXL $T=1042800 3074400 1 0 $X=1038500 $Y=3018600
X218 90 113 836 19 837 431 175 838 19 DFFSXL $T=1227600 2772000 1 0 $X=1223300 $Y=2716200
X219 90 292 839 19 840 505 175 841 19 DFFSXL $T=1240800 2772000 0 0 $X=1236500 $Y=2768000
X220 108 88 842 19 843 378 175 844 19 DFFSXL $T=1320000 3074400 1 0 $X=1315700 $Y=3018600
X221 293 40 845 19 846 121 175 847 19 DFFSXL $T=1333200 2973600 1 0 $X=1328900 $Y=2917800
X222 293 12 848 19 849 379 175 850 19 DFFSXL $T=1339800 2872800 1 0 $X=1335500 $Y=2817000
X223 90 56 851 19 852 508 175 853 19 DFFSXL $T=1386000 2671200 0 0 $X=1381700 $Y=2667200
X224 5 299 854 19 855 132 175 856 19 DFFSXL $T=1491600 2570400 0 0 $X=1487300 $Y=2566400
X225 293 36 857 19 858 382 175 859 19 DFFSXL $T=1498200 2973600 0 0 $X=1493900 $Y=2969600
X226 120 36 860 19 861 383 175 862 19 DFFSXL $T=1584000 3074400 1 0 $X=1579700 $Y=3018600
X227 90 176 863 19 864 514 175 865 19 DFFSXL $T=1636800 2671200 0 0 $X=1632500 $Y=2667200
X228 123 296 866 19 867 384 175 868 19 DFFSXL $T=1643400 2570400 0 0 $X=1639100 $Y=2566400
X229 139 36 869 19 870 516 175 871 19 DFFSXL $T=1782000 3074400 1 0 $X=1777700 $Y=3018600
X230 150 88 872 19 873 733 175 874 19 DFFSXL $T=1993200 2772000 1 0 $X=1988900 $Y=2716200
X231 158 50 875 19 876 157 175 877 19 DFFSXL $T=2032800 3074400 1 0 $X=2028500 $Y=3018600
X232 158 36 878 19 879 522 175 880 19 DFFSXL $T=2059200 2973600 1 0 $X=2054900 $Y=2917800
X233 158 56 881 19 882 528 175 883 19 DFFSXL $T=2131800 2772000 0 0 $X=2127500 $Y=2768000
X234 158 88 884 19 885 527 175 886 19 DFFSXL $T=2138400 2671200 0 0 $X=2134100 $Y=2667200
X235 158 163 887 19 888 531 175 889 19 DFFSXL $T=2151600 2872800 0 0 $X=2147300 $Y=2868800
X236 164 91 890 19 891 312 175 892 19 DFFSXL $T=2204400 2973600 0 0 $X=2200100 $Y=2969600
X237 164 15 893 19 894 314 175 895 19 DFFSXL $T=2277000 2973600 1 0 $X=2272700 $Y=2917800
X238 186 535 896 19 897 536 175 898 19 DFFSXL $T=2349600 2671200 1 0 $X=2345300 $Y=2615400
X239 158 76 899 19 900 502 175 901 19 DFFSXL $T=2415600 2973600 1 0 $X=2411300 $Y=2917800
X240 186 537 902 19 903 539 175 904 19 DFFSXL $T=2448600 2772000 1 0 $X=2444300 $Y=2716200
X241 175 166 905 19 906 315 175 907 19 DFFSXL $T=2508000 2872800 0 0 $X=2503700 $Y=2868800
X242 186 434 908 19 909 545 175 910 19 DFFSXL $T=2633400 2872800 1 0 $X=2629100 $Y=2817000
X243 183 610 911 317 912 546 175 913 19 DFFSXL $T=2719200 2671200 1 0 $X=2714900 $Y=2615400
X244 186 547 914 19 915 186 175 916 19 DFFSXL $T=2739000 3074400 1 0 $X=2734700 $Y=3018600
X245 183 557 917 317 918 549 175 919 19 DFFSXL $T=2871000 2772000 1 0 $X=2866700 $Y=2716200
X246 183 588 920 317 921 556 175 922 19 DFFSXL $T=2877600 2570400 0 0 $X=2873300 $Y=2566400
X247 183 560 923 317 924 551 175 925 19 DFFSXL $T=2897400 2671200 1 0 $X=2893100 $Y=2615400
X248 186 559 926 317 927 561 175 928 19 DFFSXL $T=2943600 2872800 1 0 $X=2939300 $Y=2817000
X249 205 700 929 322 930 198 175 749 19 DFFSXL $T=3121800 2973600 0 0 $X=3117500 $Y=2969600
X250 205 702 931 322 932 571 175 604 19 DFFSXL $T=3168000 2872800 0 0 $X=3163700 $Y=2868800
X251 205 706 933 19 934 577 175 709 19 DFFSXL $T=3207600 2671200 0 0 $X=3203300 $Y=2667200
X252 205 707 935 19 936 408 175 409 19 DFFSXL $T=3240600 2570400 0 0 $X=3236300 $Y=2566400
X253 232 714 937 322 938 715 175 939 19 DFFSXL $T=3412200 2671200 0 0 $X=3407900 $Y=2667200
X254 231 411 940 322 941 623 175 942 19 DFFSXL $T=3412200 2872800 0 0 $X=3407900 $Y=2868800
X255 231 243 943 322 944 624 175 945 19 DFFSXL $T=3544200 2872800 1 0 $X=3539900 $Y=2817000
X256 232 621 946 19 947 337 175 948 19 DFFSXL $T=3636600 2671200 1 0 $X=3632300 $Y=2615400
X257 232 245 949 322 950 628 175 951 19 DFFSXL $T=3663000 3074400 1 0 $X=3658700 $Y=3018600
X258 248 716 952 19 953 332 175 954 19 DFFSXL $T=3808200 2772000 1 0 $X=3803900 $Y=2716200
X259 248 338 955 19 956 329 175 957 19 DFFSXL $T=3834600 2671200 0 0 $X=3830300 $Y=2667200
X260 248 718 958 19 959 258 175 960 19 DFFSXL $T=3953400 2772000 1 0 $X=3949100 $Y=2716200
X261 248 264 961 19 962 262 175 963 19 DFFSXL $T=3993000 2671200 0 0 $X=3988700 $Y=2667200
X262 248 344 964 19 965 260 175 966 19 DFFSXL $T=4032600 2671200 1 0 $X=4028300 $Y=2615400
X263 248 424 967 19 968 236 175 969 19 DFFSXL $T=4144800 2570400 0 0 $X=4140500 $Y=2566400
X264 248 721 970 19 971 618 175 972 19 DFFSXL $T=4164600 2671200 0 0 $X=4160300 $Y=2667200
X265 361 71 19 494 973 175 491 AOI21XL $T=884400 2671200 1 180 $X=853700 $Y=2667200
X266 743 568 19 563 974 175 209 AOI21XL $T=3022800 2671200 0 0 $X=3018500 $Y=2667200
X267 435 570 19 572 975 175 564 AOI21XL $T=3055800 2772000 0 180 $X=3025100 $Y=2716200
X268 573 568 19 696 976 175 589 AOI21XL $T=3055800 2671200 1 0 $X=3051500 $Y=2615400
X269 436 568 19 435 977 175 578 AOI21XL $T=3075600 2872800 1 0 $X=3071300 $Y=2817000
X270 583 210 19 579 978 175 439 AOI21XL $T=3128400 2973600 1 0 $X=3124100 $Y=2917800
X271 581 578 19 587 979 175 705 AOI21XL $T=3154800 2872800 1 0 $X=3150500 $Y=2817000
X272 748 589 19 703 980 175 216 AOI21XL $T=3181200 2671200 1 0 $X=3176900 $Y=2615400
X273 594 439 19 597 981 175 598 AOI21XL $T=3214200 2772000 0 0 $X=3209900 $Y=2768000
X274 444 222 19 443 982 175 233 AOI21XL $T=3293400 2973600 1 0 $X=3289100 $Y=2917800
X275 611 617 19 606 983 175 711 AOI21XL $T=3339600 2872800 1 0 $X=3335300 $Y=2817000
X276 339 642 19 253 984 175 718 AOI21XL $T=3986400 2772000 1 180 $X=3955700 $Y=2768000
X277 423 650 19 652 985 175 649 AOI21XL $T=4092000 3074400 0 180 $X=4061300 $Y=3018600
X278 645 661 19 645 986 175 660 AOI21XL $T=4131600 2973600 1 180 $X=4100900 $Y=2969600
X279 657 666 19 720 987 175 651 AOI21XL $T=4125000 2973600 1 0 $X=4120700 $Y=2917800
X280 672 457 19 669 988 175 455 AOI21XL $T=4230600 2973600 0 180 $X=4199900 $Y=2917800
X281 673 722 19 670 989 175 670 AOI21XL $T=4290000 2772000 1 180 $X=4259300 $Y=2768000
X282 698 175 576 990 19 586 NAND2BXL $T=3102000 2772000 1 0 $X=3097700 $Y=2716200
X283 326 175 603 991 19 608 NAND2BXL $T=3326400 2973600 1 180 $X=3295700 $Y=2969600
X284 442 175 602 992 19 710 NAND2BXL $T=3313200 2772000 0 0 $X=3308900 $Y=2768000
X285 222 175 608 993 19 617 NAND2BXL $T=3326400 2973600 1 0 $X=3322100 $Y=2917800
X286 341 175 342 994 19 647 NAND2BXL $T=3966600 3074400 1 0 $X=3962300 $Y=3018600
X287 643 175 639 639 19 646 NAND2BXL $T=3986400 2872800 0 0 $X=3982100 $Y=2868800
X288 645 175 659 995 19 650 NAND2BXL $T=4125000 2973600 0 180 $X=4094300 $Y=2917800
X289 667 175 648 996 19 659 NAND2BXL $T=4184400 2973600 0 180 $X=4153700 $Y=2917800
X290 675 175 674 997 19 671 NAND2BXL $T=4283400 2872800 0 180 $X=4252700 $Y=2817000
X291 672 175 458 454 19 722 NAND2BXL $T=4263600 2973600 1 0 $X=4259300 $Y=2917800
X292 349 175 427 998 19 458 NAND2BXL $T=4263600 3074400 1 0 $X=4259300 $Y=3018600
X293 19 198 484 694 175 NOR2XL $T=2989800 2973600 0 180 $X=2965700 $Y=2917800
X294 19 193 694 436 175 NOR2XL $T=2983200 2872800 0 0 $X=2978900 $Y=2868800
X295 19 571 140 437 175 NOR2XL $T=3036000 2872800 1 180 $X=3011900 $Y=2868800
X296 19 199 566 573 175 NOR2XL $T=3022800 2671200 1 0 $X=3018500 $Y=2615400
X297 19 577 302 698 175 NOR2XL $T=3088800 2671200 1 180 $X=3064700 $Y=2667200
X298 19 698 437 570 175 NOR2XL $T=3088800 2772000 1 180 $X=3064700 $Y=2768000
X299 19 206 577 701 175 NOR2XL $T=3128400 2671200 1 0 $X=3124100 $Y=2615400
X300 19 581 578 587 175 NOR2XL $T=3128400 2872800 1 0 $X=3124100 $Y=2817000
X301 19 748 589 703 175 NOR2XL $T=3148200 2671200 1 0 $X=3143900 $Y=2615400
X302 19 594 439 597 175 NOR2XL $T=3187800 2772000 0 0 $X=3183500 $Y=2768000
X303 19 184 323 223 175 NOR2XL $T=3201000 3074400 1 0 $X=3196700 $Y=3018600
X304 19 440 441 601 175 NOR2XL $T=3227400 2872800 1 0 $X=3223100 $Y=2817000
X305 19 217 323 599 175 NOR2XL $T=3227400 3074400 1 0 $X=3223100 $Y=3018600
X306 19 181 598 442 175 NOR2XL $T=3253800 2772000 1 0 $X=3249500 $Y=2716200
X307 19 223 406 603 175 NOR2XL $T=3260400 3074400 1 0 $X=3256100 $Y=3018600
X308 19 601 442 444 175 NOR2XL $T=3293400 2872800 1 0 $X=3289100 $Y=2817000
X309 19 217 441 607 175 NOR2XL $T=3293400 2872800 0 0 $X=3289100 $Y=2868800
X310 19 217 598 612 175 NOR2XL $T=3313200 2772000 1 0 $X=3308900 $Y=2716200
X311 19 631 717 636 175 NOR2XL $T=3867600 2872800 0 0 $X=3863300 $Y=2868800
X312 19 449 638 643 175 NOR2XL $T=3946800 2872800 0 0 $X=3942500 $Y=2868800
X313 19 644 640 346 175 NOR2XL $T=3973200 2973600 0 0 $X=3968900 $Y=2969600
X314 19 643 636 648 175 NOR2XL $T=4006200 2973600 1 0 $X=4001900 $Y=2917800
X315 19 656 653 454 175 NOR2XL $T=4098600 2772000 1 0 $X=4094300 $Y=2716200
X316 19 341 346 661 175 NOR2XL $T=4105200 3074400 1 0 $X=4100900 $Y=3018600
X317 19 654 634 675 175 NOR2XL $T=4191000 2872800 0 0 $X=4186700 $Y=2868800
X318 19 675 454 457 175 NOR2XL $T=4257000 2973600 0 180 $X=4232900 $Y=2917800
X319 19 663 456 456 175 NOR2XL $T=4243800 3074400 1 0 $X=4239500 $Y=3018600
X320 71 352 468 175 999 45 19 OAI2BB1XL $T=607200 2872800 1 180 $X=569900 $Y=2868800
X321 287 475 49 175 1000 353 19 OAI2BB1XL $T=673200 2872800 1 180 $X=635900 $Y=2868800
X322 71 363 79 175 1001 430 19 OAI2BB1XL $T=943800 3074400 1 0 $X=939500 $Y=3018600
X323 568 565 695 175 1002 569 19 OAI2BB1XL $T=3069000 2973600 1 180 $X=3031700 $Y=2969600
X324 425 347 175 19 451 XNOR2XL $T=4191000 3074400 0 180 $X=4133900 $Y=3018600
X325 664 722 175 19 668 XNOR2XL $T=4290000 2772000 0 180 $X=4232900 $Y=2716200
X326 595 210 175 19 441 XNOR2X1 $T=3286800 2973600 0 180 $X=3229700 $Y=2917800
X327 749 175 19 220 175 599 605 AOI211XL $T=3260400 2973600 0 0 $X=3256100 $Y=2969600
X328 604 175 19 220 175 607 615 AOI211XL $T=3319800 2872800 0 0 $X=3315500 $Y=2868800
X329 709 175 19 220 175 612 616 AOI211XL $T=3326400 2671200 1 0 $X=3322100 $Y=2615400
X330 614 326 175 19 619 XOR2X1 $T=3333000 2973600 0 0 $X=3328700 $Y=2969600
X331 7 91 1003 19 459 175 1004 19 11 276 1005 19 1006 677 1007 ICV_1 $T=6600 2671200 1 0 $X=2300 $Y=2615400
X332 7 15 1008 19 428 175 1009 19 8 91 1010 19 1011 678 1012 ICV_1 $T=6600 2772000 1 0 $X=2300 $Y=2716200
X333 8 52 1013 19 278 175 1014 19 9 91 1015 19 1016 466 1017 ICV_1 $T=26400 2872800 0 0 $X=22100 $Y=2868800
X334 11 15 1018 19 463 175 1019 19 11 56 1020 19 1021 467 1022 ICV_1 $T=264000 2570400 0 0 $X=259700 $Y=2566400
X335 9 20 1023 19 469 175 1024 19 11 76 1025 19 1026 474 1027 ICV_1 $T=270600 2772000 1 0 $X=266300 $Y=2716200
X336 28 20 20 19 471 175 1028 19 39 12 1029 19 1030 478 1031 ICV_1 $T=356400 2973600 0 0 $X=352100 $Y=2969600
X337 7 76 1032 288 488 175 1033 19 54 88 1034 288 1035 682 1036 ICV_1 $T=541200 2671200 1 0 $X=536900 $Y=2615400
X338 16 487 1037 288 1038 175 485 19 39 490 1039 288 1040 1041 497 ICV_1 $T=673200 2772000 1 0 $X=668900 $Y=2716200
X339 28 292 292 19 684 175 1042 19 78 12 1043 19 1044 503 1045 ICV_1 $T=983400 2772000 0 0 $X=979100 $Y=2768000
X340 78 67 1046 288 501 175 1047 19 293 20 1048 19 1049 112 1050 ICV_1 $T=1069200 2973600 1 0 $X=1064900 $Y=2917800
X341 90 66 1051 19 686 175 1052 19 90 299 1053 19 1054 509 1055 ICV_1 $T=1082400 2671200 1 0 $X=1078100 $Y=2615400
X342 90 296 1056 19 506 175 1057 19 293 296 1058 19 1059 300 1060 ICV_1 $T=1194600 2570400 0 0 $X=1190300 $Y=2566400
X343 90 376 1061 19 510 175 1062 19 90 180 1063 19 1064 688 1065 ICV_1 $T=1372800 2772000 1 0 $X=1368500 $Y=2716200
X344 5 66 1066 19 301 175 1067 19 90 173 1068 19 1069 689 1070 ICV_1 $T=1392600 2671200 1 0 $X=1388300 $Y=2615400
X345 293 276 1071 19 380 175 1072 19 120 88 1073 19 1074 127 1075 ICV_1 $T=1458600 2973600 1 0 $X=1454300 $Y=2917800
X346 90 134 1076 19 690 175 1077 19 90 88 1078 19 1079 513 1080 ICV_1 $T=1636800 2772000 1 0 $X=1632500 $Y=2716200
X347 136 20 1081 19 141 175 1082 19 136 50 1083 19 1084 691 1085 ICV_1 $T=1722600 2973600 1 0 $X=1718300 $Y=2917800
X348 139 137 1086 19 386 175 1087 19 136 137 1088 19 19 147 1089 ICV_1 $T=1768800 2570400 0 0 $X=1764500 $Y=2566400
X349 150 113 1090 19 391 175 1091 19 158 113 1092 19 1093 167 1094 ICV_1 $T=2019600 2671200 1 0 $X=2015300 $Y=2615400
X350 175 20 1095 19 392 175 1096 19 175 67 1097 19 1098 395 1099 ICV_1 $T=2428800 3074400 1 0 $X=2424500 $Y=3018600
X351 186 548 1100 19 319 175 1101 19 186 555 1102 317 1103 320 1104 ICV_1 $T=2712600 2973600 1 0 $X=2708300 $Y=2917800
X352 232 227 1105 322 415 175 1106 19 232 243 1107 322 1108 625 1109 ICV_1 $T=3399000 3074400 1 0 $X=3394700 $Y=3018600
X353 231 714 1110 322 620 175 1111 19 231 621 1112 322 1113 417 1114 ICV_1 $T=3425400 2772000 0 0 $X=3421100 $Y=2768000
X354 231 227 1115 19 246 175 1116 19 232 242 1117 19 1118 633 1119 ICV_1 $T=3544200 2772000 1 0 $X=3539900 $Y=2716200
X355 248 630 1120 19 447 175 1121 19 248 641 1122 19 1123 343 1124 ICV_1 $T=3762000 2671200 1 0 $X=3757700 $Y=2615400
X356 248 635 1125 322 448 175 1126 19 248 259 1127 19 1128 261 1129 ICV_1 $T=3814800 2872800 1 0 $X=3810500 $Y=2817000
X357 269 456 19 665 266 175 AOI21X1 $T=4224000 2973600 1 180 $X=4193300 $Y=2969600
X358 71 726 19 175 364 AND2XL $T=943800 2872800 0 0 $X=939500 $Y=2868800
X359 571 433 175 19 583 OR2XL $T=3088800 2872800 0 0 $X=3084500 $Y=2868800
X360 54 276 1130 288 499 175 1131 19 DFFSX1 $T=943800 2772000 1 0 $X=939500 $Y=2716200
X361 90 369 1132 19 504 175 1133 19 DFFSX1 $T=1095600 2671200 0 0 $X=1091300 $Y=2667200
X362 293 541 1134 19 1135 175 92 19 DFFSX1 $T=1465200 2872800 0 0 $X=1460900 $Y=2868800
X363 164 88 1136 19 433 175 1137 19 DFFSX1 $T=2369400 2872800 0 180 $X=2239700 $Y=2817000
X364 676 19 24 31 462 282 175 AOI22XL $T=184800 3074400 1 0 $X=180500 $Y=3018600
X365 677 19 280 25 499 723 175 AOI22XL $T=224400 2671200 1 180 $X=187100 $Y=2667200
X366 428 19 281 280 463 464 175 AOI22XL $T=211200 2570400 0 0 $X=206900 $Y=2566400
X367 460 19 281 285 18 465 175 AOI22XL $T=250800 2671200 0 0 $X=246500 $Y=2667200
X368 459 19 281 285 283 679 175 AOI22XL $T=277200 2671200 1 0 $X=272900 $Y=2615400
X369 678 19 31 24 466 468 175 AOI22XL $T=290400 2872800 1 0 $X=286100 $Y=2817000
X370 472 19 287 71 680 41 175 AOI22XL $T=495000 2973600 1 0 $X=490700 $Y=2917800
X371 42 19 25 287 470 62 175 AOI22XL $T=534600 2973600 1 0 $X=530300 $Y=2917800
X372 289 19 281 25 682 483 175 AOI22XL $T=752400 2671200 0 0 $X=748100 $Y=2667200
X373 473 19 280 65 489 291 175 AOI22XL $T=798600 2671200 0 0 $X=794300 $Y=2667200
X374 482 19 287 65 486 69 175 AOI22XL $T=818400 2973600 0 0 $X=814100 $Y=2969600
X375 359 19 281 287 360 496 175 AOI22XL $T=831600 2570400 0 0 $X=827300 $Y=2566400
X376 480 19 280 285 73 429 175 AOI22XL $T=904200 2671200 0 0 $X=899900 $Y=2667200
X377 365 19 285 65 497 727 175 AOI22XL $T=1029600 2671200 0 180 $X=992300 $Y=2615400
X378 728 19 25 71 684 368 175 AOI22XL $T=1069200 2570400 0 0 $X=1064900 $Y=2566400
X379 31 461 19 485 287 65 357 681 175 AOI222XL $T=785400 2872800 0 180 $X=728300 $Y=2817000
X380 65 478 19 492 287 71 495 683 175 AOI222XL $T=858000 2973600 0 0 $X=853700 $Y=2969600
X381 280 474 19 488 281 152 502 502 175 AOI222XL $T=1075800 2872800 1 0 $X=1071500 $Y=2817000
X382 94 93 19 290 25 285 372 685 175 AOI222XL $T=1128600 2772000 1 0 $X=1124300 $Y=2716200
X383 31 371 19 295 152 281 479 297 175 AOI222XL $T=1168200 3074400 1 0 $X=1163900 $Y=3018600
X384 152 522 19 148 6 151 516 389 175 AOI222XL $T=2019600 3074400 0 180 $X=1962500 $Y=3018600
X385 152 525 19 515 6 151 146 432 175 AOI222XL $T=2065800 2872800 1 180 $X=2008700 $Y=2868800
X386 733 143 19 433 306 440 307 532 175 AOI222XL $T=2178000 2772000 1 0 $X=2173700 $Y=2716200
X387 530 143 19 310 306 307 184 526 175 AOI222XL $T=2277000 3074400 1 0 $X=2272700 $Y=3018600
X388 683 82 175 19 CLKBUFX3 $T=910800 3074400 1 0 $X=906500 $Y=3018600
X389 501 2 175 19 CLKBUFX3 $T=1062600 2872800 1 180 $X=1031900 $Y=2868800
X390 502 175 19 95 BUFXL $T=1141800 2872800 0 0 $X=1137500 $Y=2868800
X391 432 175 19 498 BUFXL $T=1993200 2772000 1 180 $X=1962500 $Y=2768000
X392 532 175 19 85 BUFXL $T=2158200 2772000 0 180 $X=2127500 $Y=2716200
X393 493 175 429 70 68 483 19 NAND4XL $T=871200 2772000 1 180 $X=833900 $Y=2768000
X394 103 175 511 110 481 687 19 NAND4XL $T=1320000 2973600 0 0 $X=1315700 $Y=2969600
X395 521 175 523 305 81 517 19 NAND4XL $T=2046000 2973600 0 180 $X=2008700 $Y=2917800
X396 467 280 19 25 286 74 175 AOI22X1 $T=336600 2671200 0 0 $X=332300 $Y=2667200
X397 388 151 19 6 519 493 175 AOI22X1 $T=1933800 2772000 1 0 $X=1929500 $Y=2716200
X398 35 19 19 175 CLKINVX4 $T=468600 2973600 0 180 $X=437900 $Y=2917800
X399 35 19 19 175 CLKINVX4 $T=2442000 2772000 0 180 $X=2411300 $Y=2716200
X400 35 317 19 175 CLKINVX4 $T=3003000 2772000 0 0 $X=2998700 $Y=2768000
X401 35 19 19 175 CLKINVX4 $T=3352800 2772000 1 0 $X=3348500 $Y=2716200
X402 35 19 19 175 CLKINVX4 $T=3649800 2872800 1 180 $X=3619100 $Y=2868800
X403 539 91 175 19 INVX4 $T=2428800 2872800 1 180 $X=2398100 $Y=2868800
X404 692 20 175 19 INVX4 $T=2468400 2570400 0 0 $X=2464100 $Y=2566400
X405 542 17 175 19 INVX4 $T=2640000 2872800 0 0 $X=2635700 $Y=2868800
X406 545 40 175 19 INVX4 $T=2699400 2973600 1 180 $X=2668700 $Y=2969600
X407 550 276 175 19 INVX4 $T=2739000 2973600 1 180 $X=2708300 $Y=2969600
X408 186 56 175 19 INVX4 $T=2739000 3074400 0 180 $X=2708300 $Y=3018600
X409 693 76 175 19 INVX4 $T=2923800 2973600 0 0 $X=2919500 $Y=2969600
X410 35 175 19 19 CLKINVX8 $T=1511400 3074400 0 180 $X=1467500 $Y=3018600
X411 35 175 19 19 CLKINVX8 $T=1551000 2772000 0 0 $X=1546700 $Y=2768000
X412 35 175 19 19 CLKINVX8 $T=1551000 2872800 1 0 $X=1546700 $Y=2817000
X413 536 175 67 19 CLKINVX8 $T=2395800 2772000 0 180 $X=2351900 $Y=2716200
X414 35 175 19 19 CLKINVX8 $T=2508000 2671200 1 0 $X=2503700 $Y=2615400
X415 561 175 30 19 CLKINVX8 $T=2917200 3074400 0 180 $X=2873300 $Y=3018600
X416 491 19 175 75 CLKBUFX2 $T=891000 2772000 0 0 $X=886700 $Y=2768000
X417 500 19 175 274 CLKBUFX2 $T=1029600 2872800 1 180 $X=998900 $Y=2868800
X418 294 19 175 86 CLKBUFX2 $T=1069200 2671200 0 180 $X=1038500 $Y=2615400
X419 370 19 175 84 CLKBUFX2 $T=1155000 2570400 1 180 $X=1124300 $Y=2566400
X420 503 19 175 277 CLKBUFX2 $T=1161600 2872800 0 180 $X=1130900 $Y=2817000
X421 431 19 175 87 CLKBUFX2 $T=1207800 2872800 0 180 $X=1177100 $Y=2817000
X422 686 19 175 98 CLKBUFX2 $T=1214400 2872800 1 180 $X=1183700 $Y=2868800
X423 505 19 175 100 CLKBUFX2 $T=1247400 2872800 1 180 $X=1216700 $Y=2868800
X424 506 19 175 104 CLKBUFX2 $T=1280400 2872800 0 180 $X=1249700 $Y=2817000
X425 508 19 175 375 CLKBUFX2 $T=1300200 2872800 1 180 $X=1269500 $Y=2868800
X426 504 19 175 111 CLKBUFX2 $T=1300200 2872800 1 0 $X=1295900 $Y=2817000
X427 510 19 175 97 CLKBUFX2 $T=1346400 2872800 1 180 $X=1315700 $Y=2868800
X428 509 19 175 377 CLKBUFX2 $T=1399200 2872800 0 0 $X=1394900 $Y=2868800
X429 381 19 175 116 CLKBUFX2 $T=1597200 2671200 1 180 $X=1566500 $Y=2667200
X430 689 19 175 129 CLKBUFX2 $T=1623600 2772000 1 180 $X=1592900 $Y=2768000
X431 688 19 175 130 CLKBUFX2 $T=1623600 2872800 0 180 $X=1592900 $Y=2817000
X432 513 19 175 131 CLKBUFX2 $T=1676400 2772000 1 180 $X=1645700 $Y=2768000
X433 690 19 175 303 CLKBUFX2 $T=1788600 2772000 1 180 $X=1757900 $Y=2768000
X434 514 19 175 142 CLKBUFX2 $T=1881000 2772000 0 0 $X=1876700 $Y=2768000
X435 498 175 496 19 727 494 NAND3XL $T=970200 2671200 0 180 $X=939500 $Y=2615400
X436 732 526 524 520 175 19 511 AND4XL $T=2046000 2973600 1 180 $X=2002100 $Y=2969600
X437 481 55 59 356 19 175 484 OR4X1 $T=693000 2872800 0 0 $X=688700 $Y=2868800
X438 628 627 447 449 175 19 717 ADDFX1 $T=3682800 2872800 0 0 $X=3678500 $Y=2868800
X439 632 335 448 420 175 19 640 ADDFX1 $T=3814800 2973600 0 0 $X=3810500 $Y=2969600
X440 633 626 618 654 175 19 653 ADDFX1 $T=4210800 2772000 1 180 $X=4067900 $Y=2768000
X441 625 624 446 1138 631 1139 175 19 634 CMPR32X1 $T=3676200 2872800 1 0 $X=3671900 $Y=2817000
X442 622 623 258 1140 644 1141 175 19 638 CMPR32X1 $T=3814800 2973600 1 0 $X=3810500 $Y=2917800
X443 629 422 343 1142 656 1143 175 19 263 CMPR32X1 $T=3979800 2570400 0 0 $X=3975500 $Y=2566400
X444 145 46 175 19 139 AND2X4 $T=1927200 2772000 0 0 $X=1922900 $Y=2768000
X445 191 46 175 19 175 AND2X4 $T=2501400 2671200 0 0 $X=2497100 $Y=2667200
X446 203 218 175 19 205 AND2X4 $T=3088800 2671200 0 0 $X=3084500 $Y=2667200
X447 238 218 175 19 231 AND2X4 $T=3537600 2671200 0 0 $X=3533300 $Y=2667200
X448 241 218 175 19 232 AND2X4 $T=3610200 2671200 0 0 $X=3605900 $Y=2667200
X449 199 564 175 195 19 401 696 OAI211XL $T=3022800 2570400 0 0 $X=3018500 $Y=2566400
X450 161 19 306 175 CLKINVX3 $T=2072400 2671200 0 0 $X=2068100 $Y=2667200
X451 160 19 307 175 CLKINVX3 $T=2092200 2570400 0 0 $X=2087900 $Y=2566400
X452 476 8 175 19 BUFX12 $T=587400 2671200 0 0 $X=583100 $Y=2667200
X453 507 5 175 19 BUFX12 $T=1300200 2671200 0 0 $X=1295900 $Y=2667200
X454 512 123 175 19 BUFX12 $T=1465200 2772000 0 0 $X=1460900 $Y=2768000
X455 3 19 46 175 476 AND2X2 $T=561000 2671200 0 0 $X=556700 $Y=2667200
X456 44 19 46 175 477 AND2X2 $T=574200 2772000 0 0 $X=569900 $Y=2768000
X457 154 19 46 175 355 AND2X2 $T=693000 2570400 0 0 $X=688700 $Y=2566400
X458 83 19 46 175 724 AND2X2 $T=719400 2570400 0 0 $X=715100 $Y=2566400
X459 168 19 46 175 507 AND2X2 $T=1273800 2671200 0 0 $X=1269500 $Y=2667200
X460 135 19 46 175 729 AND2X2 $T=1386000 2973600 0 0 $X=1381700 $Y=2969600
X461 118 19 46 175 512 AND2X2 $T=1438800 2772000 0 0 $X=1434500 $Y=2768000
X462 125 19 46 175 90 AND2X2 $T=1458600 2570400 0 0 $X=1454300 $Y=2566400
X463 155 19 46 175 730 AND2X2 $T=1874400 2671200 0 0 $X=1870100 $Y=2667200
X464 162 19 46 175 529 AND2X2 $T=2092200 2973600 0 0 $X=2087900 $Y=2969600
X465 311 19 46 175 734 AND2X2 $T=2277000 2772000 0 0 $X=2272700 $Y=2768000
X466 170 19 46 175 737 AND2X2 $T=2303400 2872800 0 0 $X=2299100 $Y=2868800
X467 16 52 288 354 175 1144 19 39 53 288 358 ICV_4 $T=561000 3074400 1 0 $X=556700 $Y=3018600
X468 293 56 288 96 175 1145 19 293 91 19 117 ICV_4 $T=1062600 2973600 0 0 $X=1058300 $Y=2969600
X469 90 177 19 304 175 1146 19 139 56 19 175 ICV_4 $T=1636800 2872800 1 0 $X=1632500 $Y=2817000
X470 136 166 19 515 175 1147 19 136 12 19 144 ICV_4 $T=1702800 2872800 0 0 $X=1698500 $Y=2868800
X471 5 550 19 1148 175 385 19 136 163 19 731 ICV_4 $T=1716000 2973600 0 0 $X=1711700 $Y=2969600
X472 139 296 19 149 175 1149 19 136 88 19 519 ICV_4 $T=1768800 2671200 1 0 $X=1764500 $Y=2615400
X473 136 56 19 518 175 1150 19 150 163 19 530 ICV_4 $T=1887600 2872800 1 0 $X=1883300 $Y=2817000
X474 164 299 19 309 175 313 19 186 534 19 692 ICV_4 $T=2217600 2570400 0 0 $X=2213300 $Y=2566400
X475 158 166 19 525 175 1151 19 186 540 19 542 ICV_4 $T=2369400 2872800 1 0 $X=2365100 $Y=2817000
X476 158 91 19 308 175 1152 19 175 56 19 394 ICV_4 $T=2409000 2973600 0 0 $X=2404700 $Y=2969600
X477 175 88 317 440 175 1153 19 183 591 317 543 ICV_4 $T=2593800 2671200 0 0 $X=2589500 $Y=2667200
X478 186 544 19 550 175 1154 19 186 552 317 693 ICV_4 $T=2692800 2872800 0 0 $X=2688500 $Y=2868800
X479 183 609 317 553 175 1155 19 183 558 317 554 ICV_4 $T=2745600 2772000 0 0 $X=2741300 $Y=2768000
X480 232 411 322 622 175 1156 19 231 242 19 626 ICV_4 $T=3425400 2973600 1 0 $X=3421100 $Y=2917800
X481 231 245 322 627 175 1157 19 232 418 322 632 ICV_4 $T=3557400 2973600 0 0 $X=3553100 $Y=2969600
X482 232 239 19 629 175 1158 19 248 452 19 446 ICV_4 $T=3630000 2570400 0 0 $X=3625700 $Y=2566400
X483 620 715 236 333 19 175 331 ADDFHXL $T=3590400 2671200 0 180 $X=3440900 $Y=2615400
X484 35 175 19 322 INVX3 $T=3399000 2973600 0 180 $X=3368300 $Y=2917800
X485 186 538 1160 1159 19 541 19 175 174 DFFSX2 $T=2475000 2772000 0 0 $X=2470700 $Y=2768000
X486 183 178 1162 1161 19 180 19 175 179 DFFSX2 $T=2574000 2671200 1 0 $X=2569700 $Y=2615400
X487 730 175 136 19 CLKBUFX8 $T=1900800 2671200 0 0 $X=1896500 $Y=2667200
X488 734 175 158 19 CLKBUFX8 $T=2303400 2772000 0 0 $X=2299100 $Y=2768000
X489 737 175 164 19 CLKBUFX8 $T=2329800 2872800 0 0 $X=2325500 $Y=2868800
X490 724 19 175 39 BUFX8 $T=745800 2570400 0 0 $X=741500 $Y=2566400
X491 729 19 175 108 BUFX8 $T=1412400 2973600 0 0 $X=1408100 $Y=2969600
X492 529 19 175 150 BUFX8 $T=2204400 2973600 1 180 $X=2140700 $Y=2969600
X493 99 374 430 175 105 19 208 OR4X2 $T=1267200 3074400 0 180 $X=1223300 $Y=3018600
X494 477 9 175 19 BUFX16 $T=600600 2772000 0 0 $X=596300 $Y=2768000
X495 24 469 19 71 471 106 175 AOI22X2 $T=468600 2872800 0 0 $X=464300 $Y=2868800
.ENDS
***************************************
.SUBCKT ICV_6 1 3 5 6 7 9 10 11 12 13 14 15 16 17 18 20 22 23 24 25
+ 27 28 29 31 32 33 34 35 36 37 41 43 44 45 46 49 50 51 52 53
+ 54 55 56 57 58 59 60 61 64 65 67 68 70 71 72 73 75 76 77 78
+ 79 80 81 82 83 84 85 87 88 90 94 96 97 98 99 100 103 104 106 107
+ 109 114 115 117 121 122 123 125 128 129 130 131 132 134 138 140 141 142 146 148
+ 150 151 152 155 158 159 161 162 163 166 168 169 171 173 174 176 177 179 181 182
+ 183 184 187 188 189 190 191 192 194 195 197 198 201 202 204 205 207 209 211 214
+ 215 216 220 225 226 233 234 235 239 244 245 246 247 248 249 250 251 252 253 254
+ 255 256 257 258 259 260 261 262 263 264 265 266 267 268 269 270 271 272 273 274
+ 275 276 278 279 280 281 282 283 284 285 286 287 288 289 290 291 292 293 294 295
+ 296 297 298 299 300 301 302 303 304 305 306 307 308 309 310 311 312 313 314 315
+ 316 317 318 319 320 321 322 326 327 328 329 330 331 332 333 334 336 337 338 339
+ 340 341 342 343 344 345 346 347 348 349 350 351 352 353 354 355 357 358 359 360
+ 361 362 363 364 365 366 367 368 369 370 371 372 373 374 375 376 379 380 382 383
+ 384 385 386
*.CALIBRE ICV_CELL 11
** N=1303 EP=283 IP=3342 FDC=8321
X0 404 22 197 560 INVXL $T=2983200 2268000 0 180 $X=2965700 $Y=2212200
X1 558 22 197 566 INVXL $T=3036000 2268000 1 0 $X=3031700 $Y=2212200
X2 405 22 197 369 INVXL $T=3148200 2570400 1 0 $X=3143900 $Y=2514600
X3 730 22 197 583 INVXL $T=3174600 2368800 0 0 $X=3170300 $Y=2364800
X4 731 22 197 589 INVXL $T=3227400 2167200 1 0 $X=3223100 $Y=2111400
X5 733 22 197 585 INVXL $T=3227400 2268000 0 0 $X=3223100 $Y=2264000
X6 593 22 197 736 INVXL $T=3253800 2368800 0 0 $X=3249500 $Y=2364800
X7 610 22 197 741 INVXL $T=3458400 2066400 1 180 $X=3440900 $Y=2062400
X8 412 22 197 614 INVXL $T=3445200 2469600 0 0 $X=3440900 $Y=2465600
X9 624 22 197 622 INVXL $T=3491400 2268000 1 0 $X=3487100 $Y=2212200
X10 417 22 197 621 INVXL $T=3511200 2167200 1 0 $X=3506900 $Y=2111400
X11 311 22 197 618 INVXL $T=3524400 2469600 1 180 $X=3506900 $Y=2465600
X12 423 22 197 668 INVXL $T=4085400 2368800 1 0 $X=4081100 $Y=2313000
X13 424 22 197 680 INVXL $T=4118400 2167200 0 0 $X=4114100 $Y=2163200
X14 675 22 197 763 INVXL $T=4197600 2066400 0 0 $X=4193300 $Y=2062400
X15 673 22 197 690 INVXL $T=4204200 2469600 1 0 $X=4199900 $Y=2413800
X16 239 22 197 427 INVXL $T=4217400 2469600 1 0 $X=4213100 $Y=2413800
X17 427 22 197 427 INVXL $T=4250400 2368800 1 180 $X=4232900 $Y=2364800
X18 179 197 577 576 22 571 OAI21XL $T=3121800 2469600 1 180 $X=3091100 $Y=2465600
X19 405 197 368 179 22 579 OAI21XL $T=3121800 2570400 1 0 $X=3117500 $Y=2514600
X20 408 197 579 773 22 734 OAI21XL $T=3194400 2570400 1 0 $X=3190100 $Y=2514600
X21 582 197 735 588 22 307 OAI21XL $T=3247200 2167200 1 0 $X=3242900 $Y=2111400
X22 593 197 592 586 22 595 OAI21XL $T=3260400 2368800 1 0 $X=3256100 $Y=2313000
X23 414 197 610 740 22 609 OAI21XL $T=3432000 2167200 0 180 $X=3401300 $Y=2111400
X24 601 197 608 413 22 418 OAI21XL $T=3412200 2368800 0 0 $X=3407900 $Y=2364800
X25 624 197 621 414 22 209 OAI21XL $T=3504600 2167200 0 180 $X=3473900 $Y=2111400
X26 214 197 748 620 22 625 OAI21XL $T=3544200 2167200 1 180 $X=3513500 $Y=2163200
X27 746 197 211 626 22 748 OAI21XL $T=3524400 2268000 1 0 $X=3520100 $Y=2212200
X28 214 197 747 619 22 422 OAI21XL $T=3537600 2469600 0 0 $X=3533300 $Y=2465600
X29 214 197 627 613 22 631 OAI21XL $T=3557400 2368800 1 0 $X=3553100 $Y=2313000
X30 214 197 751 416 22 630 OAI21XL $T=3590400 2268000 0 180 $X=3559700 $Y=2212200
X31 214 197 753 415 22 633 OAI21XL $T=3590400 2268000 1 0 $X=3586100 $Y=2212200
X32 428 197 666 660 22 669 OAI21XL $T=4125000 2469600 1 180 $X=4094300 $Y=2465600
X33 757 197 687 758 22 684 OAI21XL $T=4125000 2167200 1 0 $X=4120700 $Y=2111400
X34 677 197 686 685 22 679 OAI21XL $T=4191000 2368800 0 180 $X=4160300 $Y=2313000
X35 426 197 427 686 22 693 OAI21XL $T=4210800 2368800 0 0 $X=4206500 $Y=2364800
X36 694 197 693 694 22 691 OAI21XL $T=4250400 2368800 0 0 $X=4246100 $Y=2364800
X37 388 197 22 13 79 NAND2XL $T=204600 2368800 0 0 $X=200300 $Y=2364800
X38 436 197 22 700 31 NAND2XL $T=369600 2570400 1 0 $X=365300 $Y=2514600
X39 449 197 22 23 49 NAND2XL $T=646800 2066400 0 0 $X=642500 $Y=2062400
X40 452 197 22 257 332 NAND2XL $T=739200 2368800 0 180 $X=715100 $Y=2313000
X41 447 197 22 51 54 NAND2XL $T=752400 2167200 1 0 $X=748100 $Y=2111400
X42 336 197 22 455 456 NAND2XL $T=884400 2066400 0 0 $X=880100 $Y=2062400
X43 264 197 22 251 391 NAND2XL $T=976800 2066400 0 180 $X=952700 $Y=2010600
X44 483 197 22 90 486 NAND2XL $T=1471800 2469600 1 0 $X=1467500 $Y=2413800
X45 488 197 22 90 769 NAND2XL $T=1544400 2268000 0 180 $X=1520300 $Y=2212200
X46 503 197 22 100 500 NAND2XL $T=1656600 2268000 1 180 $X=1632500 $Y=2264000
X47 715 197 22 100 492 NAND2XL $T=1702800 2268000 1 180 $X=1678700 $Y=2264000
X48 714 197 22 100 495 NAND2XL $T=1722600 2469600 1 180 $X=1698500 $Y=2465600
X49 536 197 22 152 532 NAND2XL $T=2547600 2268000 1 180 $X=2523500 $Y=2264000
X50 723 197 22 152 528 NAND2XL $T=2580600 2167200 1 180 $X=2556500 $Y=2163200
X51 539 197 22 152 535 NAND2XL $T=2587200 2268000 1 180 $X=2563100 $Y=2264000
X52 544 197 22 152 541 NAND2XL $T=2699400 2268000 1 180 $X=2675300 $Y=2264000
X53 546 197 22 152 724 NAND2XL $T=2706000 2167200 0 180 $X=2681900 $Y=2111400
X54 548 197 22 152 530 NAND2XL $T=2732400 2268000 1 180 $X=2708300 $Y=2264000
X55 725 197 22 152 542 NAND2XL $T=2752200 2469600 0 180 $X=2728100 $Y=2413800
X56 158 197 22 161 533 NAND2XL $T=2871000 2066400 0 180 $X=2846900 $Y=2010600
X57 551 197 22 161 534 NAND2XL $T=2871000 2268000 0 180 $X=2846900 $Y=2212200
X58 362 197 22 161 552 NAND2XL $T=2871000 2066400 1 0 $X=2866700 $Y=2010600
X59 402 197 22 161 547 NAND2XL $T=2897400 2167200 0 180 $X=2873300 $Y=2111400
X60 580 197 22 161 555 NAND2XL $T=2897400 2167200 1 180 $X=2873300 $Y=2163200
X61 166 197 22 363 726 NAND2XL $T=2890800 2066400 1 0 $X=2886500 $Y=2010600
X62 233 197 22 161 150 NAND2XL $T=2910600 2268000 0 180 $X=2886500 $Y=2212200
X63 403 197 22 161 550 NAND2XL $T=2917200 2167200 1 180 $X=2893100 $Y=2163200
X64 560 197 22 556 558 NAND2XL $T=2917200 2368800 0 180 $X=2893100 $Y=2313000
X65 559 197 22 161 543 NAND2XL $T=2930400 2167200 0 180 $X=2906300 $Y=2111400
X66 365 197 22 161 163 NAND2XL $T=2943600 2469600 0 180 $X=2919500 $Y=2413800
X67 562 197 22 561 404 NAND2XL $T=2970000 2268000 0 180 $X=2945900 $Y=2212200
X68 169 197 22 564 563 NAND2XL $T=2989800 2469600 0 180 $X=2965700 $Y=2413800
X69 299 197 22 161 554 NAND2XL $T=2996400 2469600 0 0 $X=2992100 $Y=2465600
X70 564 197 22 565 171 NAND2XL $T=3003000 2570400 1 0 $X=2998700 $Y=2514600
X71 410 197 22 401 169 NAND2XL $T=3049200 2368800 1 180 $X=3025100 $Y=2364800
X72 564 197 22 571 367 NAND2XL $T=3029400 2570400 1 0 $X=3025100 $Y=2514600
X73 572 197 22 566 298 NAND2XL $T=3069000 2268000 0 180 $X=3044900 $Y=2212200
X74 234 197 22 161 549 NAND2XL $T=3082200 2368800 1 180 $X=3058100 $Y=2364800
X75 574 197 22 502 174 NAND2XL $T=3075600 2469600 1 0 $X=3071300 $Y=2413800
X76 407 197 22 302 576 NAND2XL $T=3121800 2469600 1 0 $X=3117500 $Y=2413800
X77 523 197 22 191 730 NAND2XL $T=3148200 2368800 0 0 $X=3143900 $Y=2364800
X78 408 197 22 579 773 NAND2XL $T=3161400 2570400 1 0 $X=3157100 $Y=2514600
X79 191 197 22 406 179 NAND2XL $T=3187800 2469600 0 180 $X=3163700 $Y=2413800
X80 183 197 22 176 370 NAND2XL $T=3174600 2066400 1 0 $X=3170300 $Y=2010600
X81 5 197 22 187 409 NAND2XL $T=3201000 2469600 1 180 $X=3176900 $Y=2465600
X82 301 197 22 407 586 NAND2XL $T=3187800 2368800 0 0 $X=3183500 $Y=2364800
X83 730 197 22 578 732 NAND2XL $T=3187800 2469600 1 0 $X=3183500 $Y=2413800
X84 589 197 22 188 584 NAND2XL $T=3220800 2066400 0 180 $X=3196700 $Y=2010600
X85 527 197 22 574 588 NAND2XL $T=3207600 2268000 0 0 $X=3203300 $Y=2264000
X86 522 197 22 410 733 NAND2XL $T=3207600 2368800 1 0 $X=3203300 $Y=2313000
X87 5 197 22 575 587 NAND2XL $T=3227400 2469600 1 180 $X=3203300 $Y=2465600
X88 5 197 22 189 305 NAND2XL $T=3247200 2066400 0 180 $X=3223100 $Y=2010600
X89 733 197 22 585 597 NAND2XL $T=3227400 2368800 1 0 $X=3223100 $Y=2313000
X90 5 197 22 734 596 NAND2XL $T=3227400 2570400 1 0 $X=3223100 $Y=2514600
X91 306 197 22 161 553 NAND2XL $T=3253800 2469600 1 180 $X=3229700 $Y=2465600
X92 586 197 22 736 737 NAND2XL $T=3267000 2368800 0 0 $X=3262700 $Y=2364800
X93 282 197 22 599 601 NAND2XL $T=3333000 2469600 1 0 $X=3328700 $Y=2413800
X94 195 197 22 598 413 NAND2XL $T=3379200 2368800 1 180 $X=3355100 $Y=2364800
X95 740 197 22 741 310 NAND2XL $T=3425400 2066400 0 0 $X=3421100 $Y=2062400
X96 601 197 22 614 616 NAND2XL $T=3425400 2469600 0 0 $X=3421100 $Y=2465600
X97 400 197 22 591 414 NAND2XL $T=3438600 2167200 0 0 $X=3434300 $Y=2163200
X98 537 197 22 600 740 NAND2XL $T=3478200 2066400 0 180 $X=3454100 $Y=2010600
X99 310 197 22 209 309 NAND2XL $T=3504600 2066400 0 180 $X=3480500 $Y=2010600
X100 414 197 22 622 420 NAND2XL $T=3504600 2167200 1 180 $X=3480500 $Y=2163200
X101 531 197 22 604 628 NAND2XL $T=3498000 2368800 0 0 $X=3493700 $Y=2364800
X102 418 197 22 623 629 NAND2XL $T=3517800 2368800 0 0 $X=3513500 $Y=2364800
X103 746 197 22 211 626 NAND2XL $T=3524400 2268000 0 0 $X=3520100 $Y=2264000
X104 628 197 22 623 421 NAND2XL $T=3531000 2368800 1 0 $X=3526700 $Y=2313000
X105 617 197 22 623 752 NAND2XL $T=3564000 2469600 1 0 $X=3559700 $Y=2413800
X106 166 197 22 656 573 NAND2XL $T=4052400 2167200 0 180 $X=4028300 $Y=2111400
X107 755 197 22 647 424 NAND2XL $T=4032600 2268000 0 0 $X=4028300 $Y=2264000
X108 650 197 22 644 660 NAND2XL $T=4039200 2469600 0 0 $X=4034900 $Y=2465600
X109 313 197 22 653 685 NAND2XL $T=4052400 2368800 0 0 $X=4048100 $Y=2364800
X110 640 197 22 318 423 NAND2XL $T=4052400 2469600 1 0 $X=4048100 $Y=2413800
X111 226 197 22 645 428 NAND2XL $T=4052400 2570400 1 0 $X=4048100 $Y=2514600
X112 166 197 22 663 570 NAND2XL $T=4059000 2066400 0 0 $X=4054700 $Y=2062400
X113 655 197 22 756 675 NAND2XL $T=4059000 2167200 1 0 $X=4054700 $Y=2111400
X114 661 197 22 657 758 NAND2XL $T=4072200 2268000 1 0 $X=4067900 $Y=2212200
X115 166 197 22 664 569 NAND2XL $T=4092000 2268000 1 180 $X=4067900 $Y=2264000
X116 423 197 22 658 665 NAND2XL $T=4072200 2368800 0 0 $X=4067900 $Y=2364800
X117 652 197 22 659 676 NAND2XL $T=4092000 2268000 0 0 $X=4087700 $Y=2264000
X118 424 197 22 662 672 NAND2XL $T=4098600 2268000 1 0 $X=4094300 $Y=2212200
X119 166 197 22 425 321 NAND2XL $T=4125000 2570400 0 180 $X=4100900 $Y=2514600
X120 654 197 22 667 322 NAND2XL $T=4125000 2066400 1 0 $X=4120700 $Y=2010600
X121 674 197 22 679 759 NAND2XL $T=4125000 2268000 0 0 $X=4120700 $Y=2264000
X122 166 197 22 681 235 NAND2XL $T=4125000 2368800 1 0 $X=4120700 $Y=2313000
X123 166 197 22 762 648 NAND2XL $T=4164600 2570400 0 180 $X=4140500 $Y=2514600
X124 675 197 22 670 761 NAND2XL $T=4197600 2066400 1 180 $X=4173500 $Y=2062400
X125 166 197 22 688 384 NAND2XL $T=4177800 2570400 1 0 $X=4173500 $Y=2514600
X126 658 197 22 682 426 NAND2XL $T=4184400 2368800 0 0 $X=4180100 $Y=2364800
X127 676 197 22 674 765 NAND2XL $T=4204200 2268000 1 0 $X=4199900 $Y=2212200
X128 674 197 22 692 689 NAND2XL $T=4210800 2268000 0 0 $X=4206500 $Y=2264000
X129 166 197 22 691 386 NAND2XL $T=4210800 2570400 1 0 $X=4206500 $Y=2514600
X130 694 197 22 693 694 NAND2XL $T=4276800 2368800 0 0 $X=4272500 $Y=2364800
X131 428 197 22 690 764 NAND2XL $T=4276800 2469600 1 0 $X=4272500 $Y=2413800
X132 665 678 197 22 425 XOR2XL $T=4151400 2469600 0 180 $X=4094300 $Y=2413800
X133 671 687 197 22 656 XOR2XL $T=4204200 2167200 0 180 $X=4147100 $Y=2111400
X134 765 695 197 22 681 XOR2XL $T=4290000 2268000 1 180 $X=4232900 $Y=2264000
X135 6 34 774 22 775 429 197 776 22 DFFSXL $T=0 2066400 1 0 $X=-4300 $Y=2010600
X136 6 10 777 22 778 431 197 779 22 DFFSXL $T=0 2570400 1 0 $X=-4300 $Y=2514600
X137 7 245 780 22 781 433 197 782 22 DFFSXL $T=6600 2368800 1 0 $X=2300 $Y=2313000
X138 6 244 783 22 784 696 197 785 22 DFFSXL $T=6600 2469600 1 0 $X=2300 $Y=2413800
X139 3 141 786 22 787 13 197 788 22 DFFSXL $T=92400 2066400 0 0 $X=88100 $Y=2062400
X140 3 246 789 22 790 388 197 791 22 DFFSXL $T=92400 2167200 1 0 $X=88100 $Y=2111400
X141 3 244 244 22 792 434 197 793 22 DFFSXL $T=105600 2167200 0 0 $X=101300 $Y=2163200
X142 9 245 794 22 795 435 197 796 22 DFFSXL $T=138600 2570400 1 0 $X=134300 $Y=2514600
X143 9 141 797 22 798 698 197 799 22 DFFSXL $T=145200 2469600 1 0 $X=140900 $Y=2413800
X144 7 141 800 22 801 697 197 802 22 DFFSXL $T=165000 2368800 1 0 $X=160700 $Y=2313000
X145 7 14 803 22 804 36 197 805 22 DFFSXL $T=244200 2066400 0 0 $X=239900 $Y=2062400
X146 7 248 806 22 807 328 197 808 22 DFFSXL $T=244200 2167200 0 0 $X=239900 $Y=2163200
X147 7 34 809 22 810 440 197 811 22 DFFSXL $T=250800 2167200 1 0 $X=246500 $Y=2111400
X148 7 249 812 22 813 766 197 814 22 DFFSXL $T=264000 2268000 0 0 $X=259700 $Y=2264000
X149 3 245 815 22 816 439 197 817 22 DFFSXL $T=290400 2469600 0 0 $X=286100 $Y=2465600
X150 7 250 818 22 819 703 197 820 22 DFFSXL $T=349800 2066400 1 0 $X=345500 $Y=2010600
X151 9 17 821 22 822 438 197 823 22 DFFSXL $T=363000 2368800 0 0 $X=358700 $Y=2364800
X152 9 34 824 22 825 441 197 826 22 DFFSXL $T=415800 2167200 0 0 $X=411500 $Y=2163200
X153 3 252 827 22 828 442 197 829 22 DFFSXL $T=415800 2570400 1 0 $X=411500 $Y=2514600
X154 9 250 830 22 831 444 197 832 22 DFFSXL $T=422400 2167200 1 0 $X=418100 $Y=2111400
X155 3 250 833 22 834 329 197 835 22 DFFSXL $T=429000 2469600 1 0 $X=424700 $Y=2413800
X156 9 253 836 22 837 330 197 838 22 DFFSXL $T=475200 2066400 1 0 $X=470900 $Y=2010600
X157 9 46 839 22 840 445 197 841 22 DFFSXL $T=488400 2268000 0 0 $X=484100 $Y=2264000
X158 7 253 842 22 843 449 197 844 22 DFFSXL $T=501600 2066400 0 0 $X=497300 $Y=2062400
X159 6 68 845 22 846 331 197 847 22 DFFSXL $T=541200 2570400 1 0 $X=536900 $Y=2514600
X160 7 252 848 22 849 390 197 850 22 DFFSXL $T=547800 2469600 0 0 $X=543500 $Y=2465600
X161 35 250 851 22 852 255 197 853 22 DFFSXL $T=561000 2167200 1 0 $X=556700 $Y=2111400
X162 6 254 854 22 855 451 197 856 22 DFFSXL $T=580800 2167200 0 0 $X=576500 $Y=2163200
X163 35 249 857 22 858 259 197 859 22 DFFSXL $T=613800 2368800 0 0 $X=609500 $Y=2364800
X164 6 76 860 22 861 333 197 862 22 DFFSXL $T=627000 2066400 1 0 $X=622700 $Y=2010600
X165 7 10 863 22 864 334 197 865 22 DFFSXL $T=673200 2469600 0 0 $X=668900 $Y=2465600
X166 35 104 866 22 867 453 197 868 22 DFFSXL $T=693000 2066400 0 0 $X=688700 $Y=2062400
X167 7 76 869 22 870 454 197 871 22 DFFSXL $T=699600 2268000 1 0 $X=695300 $Y=2212200
X168 35 58 872 22 873 337 197 874 22 DFFSXL $T=778800 2066400 1 0 $X=774500 $Y=2010600
X169 56 17 875 22 876 260 197 877 22 DFFSXL $T=818400 2469600 1 0 $X=814100 $Y=2413800
X170 56 76 878 22 879 768 197 880 22 DFFSXL $T=825000 2167200 1 0 $X=820700 $Y=2111400
X171 43 76 881 22 882 461 197 883 22 DFFSXL $T=924000 2268000 0 0 $X=919700 $Y=2264000
X172 57 58 884 22 885 463 197 886 22 DFFSXL $T=950400 2368800 0 0 $X=946100 $Y=2364800
X173 3 68 887 22 888 340 197 889 22 DFFSXL $T=1069200 2469600 1 0 $X=1064900 $Y=2413800
X174 3 265 890 22 891 341 197 892 22 DFFSXL $T=1069200 2570400 1 0 $X=1064900 $Y=2514600
X175 57 104 893 22 894 473 197 895 22 DFFSXL $T=1115400 2268000 0 0 $X=1111100 $Y=2264000
X176 3 76 896 22 897 478 197 898 22 DFFSXL $T=1115400 2368800 0 0 $X=1111100 $Y=2364800
X177 44 131 899 22 900 344 197 901 22 DFFSXL $T=1122000 2066400 1 0 $X=1117700 $Y=2010600
X178 72 273 902 22 903 343 197 904 22 DFFSXL $T=1155000 2469600 0 0 $X=1150700 $Y=2465600
X179 78 17 905 22 906 82 197 907 22 DFFSXL $T=1221000 2167200 1 0 $X=1216700 $Y=2111400
X180 57 76 76 22 908 710 197 909 22 DFFSXL $T=1234200 2268000 1 0 $X=1229900 $Y=2212200
X181 83 58 910 22 911 481 197 912 22 DFFSXL $T=1326600 2570400 1 0 $X=1322300 $Y=2514600
X182 78 76 913 22 914 393 197 915 22 DFFSXL $T=1333200 2469600 1 0 $X=1328900 $Y=2413800
X183 83 269 916 22 917 392 197 918 22 DFFSXL $T=1372800 2268000 1 0 $X=1368500 $Y=2212200
X184 83 254 919 22 920 85 197 921 22 DFFSXL $T=1379400 2167200 1 0 $X=1375100 $Y=2111400
X185 87 76 922 22 923 711 197 924 22 DFFSXL $T=1452000 2469600 0 0 $X=1447700 $Y=2465600
X186 78 104 925 22 926 488 197 927 22 DFFSXL $T=1504800 2167200 0 0 $X=1500500 $Y=2163200
X187 72 96 928 22 929 272 197 930 22 DFFSXL $T=1544400 2368800 0 0 $X=1540100 $Y=2364800
X188 78 273 931 22 932 351 197 933 22 DFFSXL $T=1617000 2066400 1 0 $X=1612700 $Y=2010600
X189 97 104 934 22 935 715 197 936 22 DFFSXL $T=1630200 2268000 1 0 $X=1625900 $Y=2212200
X190 84 76 937 22 938 494 197 939 22 DFFSXL $T=1650000 2570400 1 0 $X=1645700 $Y=2514600
X191 97 269 940 22 941 501 197 942 22 DFFSXL $T=1676400 2167200 1 0 $X=1672100 $Y=2111400
X192 97 81 943 22 944 503 197 945 22 DFFSXL $T=1676400 2469600 1 0 $X=1672100 $Y=2413800
X193 84 104 946 22 947 491 197 948 22 DFFSXL $T=1702800 2368800 0 0 $X=1698500 $Y=2364800
X194 84 273 949 22 950 275 197 951 22 DFFSXL $T=1722600 2066400 0 0 $X=1718300 $Y=2062400
X195 107 68 952 22 953 278 197 954 22 DFFSXL $T=1788600 2469600 0 0 $X=1784300 $Y=2465600
X196 107 269 955 22 956 504 197 957 22 DFFSXL $T=1815000 2167200 1 0 $X=1810700 $Y=2111400
X197 107 131 958 22 959 771 197 960 22 DFFSXL $T=1828200 2469600 1 0 $X=1823900 $Y=2413800
X198 107 249 961 22 962 352 197 963 22 DFFSXL $T=1841400 2368800 0 0 $X=1837100 $Y=2364800
X199 109 58 964 22 965 506 197 966 22 DFFSXL $T=1894200 2167200 0 0 $X=1889900 $Y=2163200
X200 109 131 967 22 968 394 197 969 22 DFFSXL $T=1894200 2570400 1 0 $X=1889900 $Y=2514600
X201 109 81 970 22 971 353 197 972 22 DFFSXL $T=1953600 2066400 1 0 $X=1949300 $Y=2010600
X202 109 141 973 22 974 123 197 975 22 DFFSXL $T=1960200 2469600 0 0 $X=1955900 $Y=2465600
X203 109 76 976 22 977 508 197 978 22 DFFSXL $T=1966800 2368800 1 0 $X=1962500 $Y=2313000
X204 122 58 979 22 980 515 197 981 22 DFFSXL $T=2019600 2167200 0 0 $X=2015300 $Y=2163200
X205 122 76 982 22 983 509 197 984 22 DFFSXL $T=2019600 2570400 1 0 $X=2015300 $Y=2514600
X206 125 76 985 22 986 398 197 987 22 DFFSXL $T=2138400 2469600 1 0 $X=2134100 $Y=2413800
X207 122 269 988 22 989 518 197 990 22 DFFSXL $T=2145000 2570400 1 0 $X=2140700 $Y=2514600
X208 125 269 991 22 992 520 197 993 22 DFFSXL $T=2158200 2368800 1 0 $X=2153900 $Y=2313000
X209 125 131 994 22 995 525 197 996 22 DFFSXL $T=2191200 2368800 0 0 $X=2186900 $Y=2364800
X210 132 41 997 22 998 722 197 999 22 DFFSXL $T=2211000 2066400 0 0 $X=2206700 $Y=2062400
X211 132 81 1000 22 1001 522 197 1002 22 DFFSXL $T=2237400 2268000 0 0 $X=2233100 $Y=2264000
X212 125 58 1003 22 1004 526 197 1005 22 DFFSXL $T=2303400 2469600 1 0 $X=2299100 $Y=2413800
X213 197 81 1006 22 1007 531 197 1008 22 DFFSXL $T=2349600 2368800 0 0 $X=2345300 $Y=2364800
X214 197 58 58 22 1009 400 197 1010 22 DFFSXL $T=2356200 2368800 1 0 $X=2351900 $Y=2313000
X215 148 530 1011 22 1012 524 197 1013 22 DFFSXL $T=2389200 2268000 0 0 $X=2384900 $Y=2264000
X216 197 76 1014 22 1015 142 197 1016 22 DFFSXL $T=2389200 2469600 0 0 $X=2384900 $Y=2465600
X217 197 131 1017 288 1018 537 197 1019 22 DFFSXL $T=2461800 2066400 1 0 $X=2457500 $Y=2010600
X218 140 534 534 22 1020 536 197 1021 22 DFFSXL $T=2481600 2368800 1 0 $X=2477300 $Y=2313000
X219 197 265 1022 22 1023 358 197 1024 22 DFFSXL $T=2488200 2066400 0 0 $X=2483900 $Y=2062400
X220 148 532 1025 22 1026 519 197 1027 22 DFFSXL $T=2488200 2570400 1 0 $X=2483900 $Y=2514600
X221 148 535 1028 22 1029 540 197 1030 22 DFFSXL $T=2501400 2469600 1 0 $X=2497100 $Y=2413800
X222 197 269 1031 22 1032 517 197 1033 22 DFFSXL $T=2514600 2469600 0 0 $X=2510300 $Y=2465600
X223 148 359 1034 288 1035 360 197 1036 22 DFFSXL $T=2600400 2066400 1 0 $X=2596100 $Y=2010600
X224 148 541 541 22 1037 538 197 1038 22 DFFSXL $T=2607000 2368800 1 0 $X=2602700 $Y=2313000
X225 140 289 1039 22 1040 544 197 1041 22 DFFSXL $T=2613600 2167200 0 0 $X=2609300 $Y=2163200
X226 140 547 1042 288 1043 290 197 1044 22 DFFSXL $T=2725800 2066400 1 0 $X=2721500 $Y=2010600
X227 155 304 1045 292 1046 295 197 1047 22 DFFSXL $T=2739000 2469600 0 0 $X=2734700 $Y=2465600
X228 140 552 1048 288 1049 546 197 1050 22 DFFSXL $T=2745600 2167200 1 0 $X=2741300 $Y=2111400
X229 140 555 1051 288 1052 159 197 1053 22 DFFSXL $T=2752200 2167200 0 0 $X=2747900 $Y=2163200
X230 140 550 1054 292 1055 548 197 1056 22 DFFSXL $T=2758800 2268000 0 0 $X=2754500 $Y=2264000
X231 140 549 1057 292 1058 725 197 1059 22 DFFSXL $T=2758800 2368800 1 0 $X=2754500 $Y=2313000
X232 155 553 1060 292 1061 291 197 1062 22 DFFSXL $T=2864400 2469600 0 0 $X=2860100 $Y=2465600
X233 162 557 1063 292 1064 556 197 1065 22 DFFSXL $T=2890800 2368800 0 0 $X=2886500 $Y=2364800
X234 162 728 1066 292 1067 562 197 1068 22 DFFSXL $T=2897400 2268000 0 0 $X=2893100 $Y=2264000
X235 162 727 1069 292 1070 561 197 1071 22 DFFSXL $T=2904000 2066400 0 0 $X=2899700 $Y=2062400
X236 162 729 1072 292 1073 572 197 1074 22 DFFSXL $T=3016200 2368800 1 0 $X=3011900 $Y=2313000
X237 162 570 1075 292 1076 580 197 1077 22 DFFSXL $T=3042600 2167200 1 0 $X=3038300 $Y=2111400
X238 162 573 1078 22 1079 551 197 1080 22 DFFSXL $T=3062400 2167200 0 0 $X=3058100 $Y=2163200
X239 194 596 1081 22 1082 407 197 411 22 DFFSXL $T=3273600 2570400 1 0 $X=3269300 $Y=2514600
X240 194 594 1083 22 1084 581 197 606 22 DFFSXL $T=3280200 2066400 0 0 $X=3275900 $Y=2062400
X241 194 409 1085 22 1086 574 197 607 22 DFFSXL $T=3280200 2268000 0 0 $X=3275900 $Y=2264000
X242 194 587 1087 22 1088 410 197 739 22 DFFSXL $T=3280200 2469600 0 0 $X=3275900 $Y=2465600
X243 220 625 1089 22 1090 1091 197 374 22 DFFSXL $T=3537600 2066400 1 0 $X=3533300 $Y=2010600
X244 220 205 1092 22 1093 754 197 1094 22 DFFSXL $T=3583800 2469600 0 0 $X=3579500 $Y=2465600
X245 216 316 1095 22 1096 639 197 1097 22 DFFSXL $T=3663000 2066400 1 0 $X=3658700 $Y=2010600
X246 220 316 1098 22 1099 651 197 1100 22 DFFSXL $T=3788400 2066400 1 0 $X=3784100 $Y=2010600
X247 225 648 1101 22 1102 315 197 1103 22 DFFSXL $T=3867600 2570400 1 0 $X=3863300 $Y=2514600
X248 274 100 22 713 1104 197 498 AOI21XL $T=1630200 2570400 0 180 $X=1599500 $Y=2514600
X249 563 567 22 568 1105 197 575 AOI21XL $T=3055800 2469600 0 0 $X=3051500 $Y=2465600
X250 565 182 22 571 1106 197 567 AOI21XL $T=3082200 2570400 0 180 $X=3051500 $Y=2514600
X251 578 190 22 583 1107 197 592 AOI21XL $T=3214200 2368800 0 0 $X=3209900 $Y=2364800
X252 585 595 22 585 1108 197 735 AOI21XL $T=3247200 2268000 0 0 $X=3242900 $Y=2264000
X253 737 592 22 738 1109 197 598 AOI21XL $T=3306600 2368800 0 0 $X=3302300 $Y=2364800
X254 417 615 22 609 1110 197 207 AOI21XL $T=3491400 2066400 1 180 $X=3460700 $Y=2062400
X255 617 618 22 418 1111 197 419 AOI21XL $T=3511200 2469600 1 0 $X=3506900 $Y=2413800
X256 421 419 22 749 1112 197 751 AOI21XL $T=3564000 2268000 0 0 $X=3559700 $Y=2264000
X257 420 621 22 750 1113 197 753 AOI21XL $T=3570600 2167200 0 0 $X=3566300 $Y=2163200
X258 658 669 22 668 1114 197 686 AOI21XL $T=4131600 2368800 0 0 $X=4127300 $Y=2364800
X259 682 427 22 669 1115 197 678 AOI21XL $T=4197600 2469600 0 180 $X=4166900 $Y=2413800
X260 670 684 22 763 1116 197 385 AOI21XL $T=4177800 2066400 1 0 $X=4173500 $Y=2010600
X261 662 760 22 680 1117 197 687 AOI21XL $T=4191000 2167200 0 0 $X=4186700 $Y=2163200
X262 692 427 22 679 1118 197 695 AOI21XL $T=4263600 2368800 1 0 $X=4259300 $Y=2313000
X263 577 197 576 1119 22 408 NAND2BXL $T=3135000 2469600 0 0 $X=3130700 $Y=2465600
X264 582 197 588 1120 22 590 NAND2BXL $T=3201000 2268000 1 0 $X=3196700 $Y=2212200
X265 608 197 413 1121 22 744 NAND2BXL $T=3438600 2368800 1 0 $X=3434300 $Y=2313000
X266 757 197 758 1122 22 671 NAND2BXL $T=4085400 2167200 0 0 $X=4081100 $Y=2163200
X267 666 197 660 1123 22 683 NAND2BXL $T=4138200 2469600 0 0 $X=4133900 $Y=2465600
X268 320 197 322 1124 22 319 NAND2BXL $T=4177800 2066400 0 180 $X=4147100 $Y=2010600
X269 677 197 685 1125 22 694 NAND2BXL $T=4197600 2368800 1 0 $X=4193300 $Y=2313000
X270 22 563 567 568 197 NOR2XL $T=3029400 2469600 0 0 $X=3025100 $Y=2465600
X271 22 577 405 565 197 NOR2XL $T=3108600 2570400 0 180 $X=3084500 $Y=2514600
X272 22 407 302 577 197 NOR2XL $T=3115200 2469600 0 180 $X=3091100 $Y=2413800
X273 22 191 406 405 197 NOR2XL $T=3161400 2469600 0 180 $X=3137300 $Y=2413800
X274 22 301 407 593 197 NOR2XL $T=3148200 2368800 1 0 $X=3143900 $Y=2313000
X275 22 527 574 582 197 NOR2XL $T=3161400 2268000 1 0 $X=3157100 $Y=2212200
X276 22 737 592 738 197 NOR2XL $T=3286800 2469600 1 0 $X=3282500 $Y=2413800
X277 22 201 598 603 197 NOR2XL $T=3379200 2368800 0 180 $X=3355100 $Y=2313000
X278 22 201 604 605 197 NOR2XL $T=3379200 2469600 0 180 $X=3355100 $Y=2413800
X279 22 201 600 373 197 NOR2XL $T=3392400 2066400 0 180 $X=3368300 $Y=2010600
X280 22 282 599 412 197 NOR2XL $T=3379200 2469600 1 0 $X=3374900 $Y=2413800
X281 22 195 598 608 197 NOR2XL $T=3385800 2368800 0 0 $X=3381500 $Y=2364800
X282 22 537 600 610 197 NOR2XL $T=3405600 2066400 1 0 $X=3401300 $Y=2010600
X283 22 201 591 742 197 NOR2XL $T=3405600 2268000 0 0 $X=3401300 $Y=2264000
X284 22 201 599 611 197 NOR2XL $T=3405600 2469600 0 0 $X=3401300 $Y=2465600
X285 22 201 612 743 197 NOR2XL $T=3418800 2268000 1 0 $X=3414500 $Y=2212200
X286 22 412 608 617 197 NOR2XL $T=3438600 2368800 0 0 $X=3434300 $Y=2364800
X287 22 624 610 615 197 NOR2XL $T=3465000 2167200 0 180 $X=3440900 $Y=2111400
X288 22 400 591 624 197 NOR2XL $T=3465000 2167200 0 0 $X=3460700 $Y=2163200
X289 22 421 419 749 197 NOR2XL $T=3544200 2268000 0 0 $X=3539900 $Y=2264000
X290 22 420 621 750 197 NOR2XL $T=3550800 2167200 1 0 $X=3546500 $Y=2111400
X291 22 661 657 757 197 NOR2XL $T=4059000 2167200 0 0 $X=4054700 $Y=2163200
X292 22 650 644 666 197 NOR2XL $T=4072200 2469600 0 0 $X=4067900 $Y=2465600
X293 22 654 667 320 197 NOR2XL $T=4085400 2066400 1 0 $X=4081100 $Y=2010600
X294 22 226 645 673 197 NOR2XL $T=4085400 2570400 1 0 $X=4081100 $Y=2514600
X295 22 313 653 677 197 NOR2XL $T=4098600 2368800 0 0 $X=4094300 $Y=2364800
X296 22 666 673 682 197 NOR2XL $T=4151400 2469600 1 0 $X=4147100 $Y=2413800
X297 22 677 426 692 197 NOR2XL $T=4237200 2368800 1 0 $X=4232900 $Y=2313000
X298 65 450 437 197 1126 448 22 OAI2BB1XL $T=633600 2268000 0 180 $X=596300 $Y=2212200
X299 27 706 459 197 1127 708 22 OAI2BB1XL $T=1042800 2167200 1 0 $X=1038500 $Y=2111400
X300 23 454 460 197 1128 466 22 OAI2BB1XL $T=1069200 2268000 0 0 $X=1064900 $Y=2264000
X301 27 462 70 197 1129 267 22 OAI2BB1XL $T=1108800 2368800 1 0 $X=1104500 $Y=2313000
X302 263 469 470 197 1130 471 22 OAI2BB1XL $T=1122000 2167200 1 0 $X=1117700 $Y=2111400
X303 99 98 493 197 1131 497 22 OAI2BB1XL $T=1630200 2066400 1 180 $X=1592900 $Y=2062400
X304 90 393 496 197 1132 713 22 OAI2BB1XL $T=1630200 2469600 1 180 $X=1592900 $Y=2465600
X305 618 614 601 197 1133 745 22 OAI2BB1XL $T=3465000 2469600 1 0 $X=3460700 $Y=2413800
X306 427 690 428 197 428 428 22 OAI2BB1XL $T=4237200 2469600 1 0 $X=4232900 $Y=2413800
X307 581 303 197 22 731 XNOR2XL $T=3161400 2066400 0 0 $X=3157100 $Y=2062400
X308 286 606 197 22 602 XNOR2XL $T=3418800 2268000 0 180 $X=3361700 $Y=2212200
X309 616 618 197 22 747 XNOR2XL $T=3458400 2469600 0 0 $X=3454100 $Y=2465600
X310 761 684 197 22 663 XNOR2XL $T=4171200 2066400 1 180 $X=4114100 $Y=2062400
X311 672 760 197 22 664 XNOR2XL $T=4184400 2268000 0 180 $X=4127300 $Y=2212200
X312 764 427 197 22 688 XNOR2XL $T=4290000 2570400 0 180 $X=4232900 $Y=2514600
X313 732 190 197 22 599 XNOR2X1 $T=3214200 2469600 1 0 $X=3209900 $Y=2413800
X314 371 307 197 22 600 XNOR2X1 $T=3253800 2066400 1 0 $X=3249500 $Y=2010600
X315 597 595 197 22 604 XNOR2X1 $T=3293400 2368800 1 0 $X=3289100 $Y=2313000
X316 744 745 197 22 627 XNOR2X1 $T=3471600 2368800 1 0 $X=3467300 $Y=2313000
X317 683 428 197 22 762 XNOR2X1 $T=4230600 2469600 1 180 $X=4173500 $Y=2465600
X318 411 197 22 204 197 603 613 AOI211XL $T=3399000 2368800 1 0 $X=3394700 $Y=2313000
X319 739 197 22 204 197 605 416 AOI211XL $T=3412200 2469600 1 0 $X=3407900 $Y=2413800
X320 308 197 22 204 197 611 619 AOI211XL $T=3425400 2570400 1 0 $X=3421100 $Y=2514600
X321 607 197 22 204 197 742 415 AOI211XL $T=3432000 2268000 0 0 $X=3427700 $Y=2264000
X322 606 197 22 204 197 743 620 AOI211XL $T=3445200 2268000 1 0 $X=3440900 $Y=2212200
X323 590 735 197 22 591 XOR2X1 $T=3293400 2268000 0 180 $X=3236300 $Y=2212200
X324 602 202 197 22 612 XOR2X1 $T=3379200 2167200 0 0 $X=3374900 $Y=2163200
X325 517 612 197 22 746 XOR2X1 $T=3471600 2268000 0 0 $X=3467300 $Y=2264000
X326 7 17 1134 22 430 197 1135 22 7 246 1136 22 1137 389 1138 ICV_1 $T=0 2268000 0 0 $X=-4300 $Y=2264000
X327 6 245 1139 22 432 197 1140 22 9 246 1141 22 1142 12 1143 ICV_1 $T=6600 2469600 0 0 $X=2300 $Y=2465600
X328 9 249 1144 22 443 197 1145 22 35 34 1146 22 1147 450 1148 ICV_1 $T=369600 2368800 1 0 $X=365300 $Y=2313000
X329 6 249 1149 22 256 197 1150 22 3 17 1151 22 1152 15 1153 ICV_1 $T=554400 2469600 1 0 $X=550100 $Y=2413800
X330 7 61 1154 22 52 197 1155 22 7 254 1156 22 1157 704 1158 ICV_1 $T=660000 2268000 0 0 $X=655700 $Y=2264000
X331 7 46 1159 22 446 197 1160 22 44 76 1161 22 1162 458 1163 ICV_1 $T=706200 2167200 0 0 $X=701900 $Y=2163200
X332 57 249 1164 22 59 197 1165 22 3 249 1166 22 1167 339 1168 ICV_1 $T=798600 2469600 0 0 $X=794300 $Y=2465600
X333 44 58 1169 22 705 197 1170 22 43 131 1171 22 1172 462 1173 ICV_1 $T=805200 2368800 1 0 $X=800900 $Y=2313000
X334 7 58 1174 22 457 197 1175 22 3 61 1176 22 1177 266 1178 ICV_1 $T=805200 2570400 1 0 $X=800900 $Y=2514600
X335 43 58 1179 22 706 197 1180 22 44 104 1181 22 1182 469 1183 ICV_1 $T=917400 2066400 0 0 $X=913100 $Y=2062400
X336 35 76 1184 22 707 197 1185 22 3 104 1186 22 1187 709 1188 ICV_1 $T=970200 2167200 0 0 $X=965900 $Y=2163200
X337 78 269 1189 22 480 197 1190 22 84 269 1191 22 1192 484 1193 ICV_1 $T=1240800 2066400 0 0 $X=1236500 $Y=2062400
X338 72 342 1194 22 479 197 1195 22 83 81 1196 22 1197 485 1198 ICV_1 $T=1247400 2368800 1 0 $X=1243100 $Y=2313000
X339 72 104 1199 22 268 197 1200 22 78 58 1201 22 1202 483 1203 ICV_1 $T=1267200 2368800 0 0 $X=1262900 $Y=2364800
X340 84 270 1204 22 345 197 1205 22 87 81 81 22 1206 490 1207 ICV_1 $T=1353000 2066400 1 0 $X=1348700 $Y=2010600
X341 83 104 1208 22 482 197 1209 22 87 104 104 22 1210 487 1211 ICV_1 $T=1353000 2268000 0 0 $X=1348700 $Y=2264000
X342 97 58 1212 22 714 197 1213 22 84 58 1214 22 1215 489 1216 ICV_1 $T=1617000 2368800 1 0 $X=1612700 $Y=2313000
X343 107 141 1217 22 117 197 1218 22 109 269 1219 22 1220 716 1221 ICV_1 $T=1834800 2268000 0 0 $X=1830500 $Y=2264000
X344 107 58 1222 283 505 197 1223 22 122 104 104 22 1224 718 1225 ICV_1 $T=1848000 2066400 0 0 $X=1843700 $Y=2062400
X345 125 104 1226 283 399 197 1227 22 132 104 1228 283 1229 523 1230 ICV_1 $T=2092200 2066400 1 0 $X=2087900 $Y=2010600
X346 132 58 1231 22 527 197 1232 22 148 528 1233 22 1234 529 1235 ICV_1 $T=2244000 2167200 0 0 $X=2239700 $Y=2163200
X347 140 533 1236 22 723 197 1237 22 140 543 1238 288 1239 539 1240 ICV_1 $T=2501400 2268000 1 0 $X=2497100 $Y=2212200
X348 148 542 1241 292 545 197 1242 22 155 181 1243 292 1244 294 1245 ICV_1 $T=2626800 2368800 0 0 $X=2622500 $Y=2364800
X349 155 293 1246 292 361 197 1247 22 155 554 1248 292 1249 297 1250 ICV_1 $T=2739000 2570400 1 0 $X=2734700 $Y=2514600
X350 162 726 1251 292 403 197 296 22 162 300 1252 292 1253 559 1254 ICV_1 $T=2910600 2066400 1 0 $X=2906300 $Y=2010600
X351 216 205 1255 22 632 197 1256 22 216 375 1257 22 1258 317 1259 ICV_1 $T=3517800 2570400 1 0 $X=3513500 $Y=2514600
X352 216 625 1260 22 1261 197 215 22 216 376 1262 22 1263 379 1264 ICV_1 $T=3524400 2066400 0 0 $X=3520100 $Y=2062400
X353 216 312 1265 22 634 197 1266 22 220 312 1267 22 1268 641 1269 ICV_1 $T=3597000 2368800 0 0 $X=3592700 $Y=2364800
X354 216 422 422 22 635 197 1270 22 220 422 1271 22 1272 642 1273 ICV_1 $T=3610200 2368800 1 0 $X=3605900 $Y=2313000
X355 216 631 1274 22 636 197 1275 22 220 631 1276 22 1277 643 1278 ICV_1 $T=3616800 2268000 0 0 $X=3612500 $Y=2264000
X356 216 630 1279 22 637 197 1280 22 220 630 1281 22 1282 646 1283 ICV_1 $T=3630000 2167200 0 0 $X=3625700 $Y=2163200
X357 216 633 1284 22 638 197 1285 22 220 633 1286 22 1287 649 1288 ICV_1 $T=3643200 2167200 1 0 $X=3638900 $Y=2111400
X358 562 364 197 22 728 OR2XL $T=2950200 2167200 1 180 $X=2919500 $Y=2163200
X359 401 410 197 22 564 OR2XL $T=3029400 2469600 0 180 $X=2998700 $Y=2413800
X360 502 574 197 22 173 OR2XL $T=3042600 2469600 1 0 $X=3038300 $Y=2413800
X361 191 523 197 22 578 OR2XL $T=3108600 2368800 0 0 $X=3104300 $Y=2364800
X362 410 522 197 22 585 OR2XL $T=3168000 2368800 1 0 $X=3163700 $Y=2313000
X363 604 531 197 22 623 OR2XL $T=3465000 2368800 0 0 $X=3460700 $Y=2364800
X364 318 640 197 22 658 OR2XL $T=4019400 2469600 1 0 $X=4015100 $Y=2413800
X365 647 755 197 22 662 OR2XL $T=4032600 2268000 1 0 $X=4028300 $Y=2212200
X366 659 652 197 22 674 OR2XL $T=4059000 2368800 1 0 $X=4054700 $Y=2313000
X367 756 655 197 22 670 OR2XL $T=4078800 2066400 0 0 $X=4074500 $Y=2062400
X368 84 254 1289 22 80 197 1290 22 DFFSX1 $T=1762200 2167200 0 0 $X=1757900 $Y=2163200
X369 132 76 1291 22 177 197 1292 22 DFFSX1 $T=2263800 2469600 0 0 $X=2259500 $Y=2465600
X370 148 724 1293 288 387 197 1294 22 DFFSX1 $T=2745600 2066400 1 180 $X=2615900 $Y=2062400
X371 162 569 1295 292 402 197 1296 22 DFFSX1 $T=3036000 2268000 0 0 $X=3031700 $Y=2264000
X372 434 22 13 11 696 247 197 AOI22XL $T=165000 2368800 1 180 $X=127700 $Y=2364800
X373 429 22 11 13 327 437 197 AOI22XL $T=211200 2066400 1 0 $X=206900 $Y=2010600
X374 432 22 11 25 435 436 197 AOI22XL $T=270600 2570400 1 0 $X=266300 $Y=2514600
X375 430 22 23 25 438 699 197 AOI22XL $T=303600 2368800 1 0 $X=299300 $Y=2313000
X376 433 22 23 13 439 700 197 AOI22XL $T=316800 2469600 1 0 $X=312500 $Y=2413800
X377 16 22 13 11 431 37 197 AOI22XL $T=316800 2570400 1 0 $X=312500 $Y=2514600
X378 442 22 13 23 390 20 197 AOI22XL $T=402600 2469600 0 180 $X=365300 $Y=2413800
X379 440 22 23 25 441 702 197 AOI22XL $T=376200 2167200 0 0 $X=371900 $Y=2163200
X380 703 22 23 25 444 18 197 AOI22XL $T=415800 2066400 1 180 $X=378500 $Y=2062400
X381 766 22 23 25 443 701 197 AOI22XL $T=409200 2268000 0 0 $X=404900 $Y=2264000
X382 445 22 25 23 446 447 197 AOI22XL $T=547800 2268000 1 0 $X=543500 $Y=2212200
X383 451 22 11 23 704 452 197 AOI22XL $T=884400 2268000 1 0 $X=880100 $Y=2212200
X384 705 22 263 64 261 459 197 AOI22XL $T=957000 2268000 1 0 $X=952700 $Y=2212200
X385 768 22 64 263 458 455 197 AOI22XL $T=970200 2167200 1 0 $X=965900 $Y=2111400
X386 338 22 27 65 453 464 197 AOI22XL $T=1003200 2066400 1 0 $X=998900 $Y=2010600
X387 707 22 65 27 461 460 197 AOI22XL $T=1075800 2268000 0 180 $X=1038500 $Y=2212200
X388 457 22 23 73 463 465 197 AOI22XL $T=1069200 2368800 1 0 $X=1064900 $Y=2313000
X389 709 22 13 73 473 470 197 AOI22XL $T=1201200 2268000 0 180 $X=1163900 $Y=2212200
X390 710 22 73 13 478 476 197 AOI22XL $T=1280400 2167200 1 180 $X=1243100 $Y=2163200
X391 392 22 100 94 484 493 197 AOI22XL $T=1511400 2066400 0 0 $X=1507100 $Y=2062400
X392 771 22 279 121 394 395 197 AOI22XL $T=1966800 2469600 1 0 $X=1962500 $Y=2413800
X393 114 22 121 279 276 396 197 AOI22XL $T=2006400 2469600 1 0 $X=2002100 $Y=2413800
X394 505 22 279 121 506 397 197 AOI22XL $T=2019600 2167200 1 0 $X=2015300 $Y=2111400
X395 716 22 121 279 504 507 197 AOI22XL $T=2059200 2268000 0 180 $X=2021900 $Y=2212200
X396 115 22 279 129 509 717 197 AOI22XL $T=2046000 2469600 1 0 $X=2041700 $Y=2413800
X397 508 22 121 130 398 719 197 AOI22XL $T=2092200 2368800 1 0 $X=2087900 $Y=2313000
X398 718 22 129 128 282 514 197 AOI22XL $T=2125200 2167200 1 0 $X=2120900 $Y=2111400
X399 518 22 129 128 517 720 197 AOI22XL $T=2158200 2368800 1 180 $X=2120900 $Y=2364800
X400 129 22 515 128 400 521 197 AOI22XL $T=2151600 2167200 0 0 $X=2147300 $Y=2163200
X401 281 22 129 128 537 516 197 AOI22XL $T=2158200 2066400 0 0 $X=2153900 $Y=2062400
X402 355 22 128 130 520 512 197 AOI22XL $T=2197800 2268000 1 180 $X=2160500 $Y=2264000
X403 399 22 130 128 523 510 197 AOI22XL $T=2197800 2167200 1 0 $X=2193500 $Y=2111400
X404 134 22 130 128 522 721 197 AOI22XL $T=2230800 2167200 1 180 $X=2193500 $Y=2163200
X405 526 22 130 128 527 772 197 AOI22XL $T=2250600 2268000 0 180 $X=2213300 $Y=2212200
X406 284 22 128 130 525 513 197 AOI22XL $T=2250600 2167200 1 0 $X=2246300 $Y=2111400
X407 177 22 128 128 142 511 197 AOI22XL $T=2362800 2570400 0 180 $X=2325500 $Y=2514600
X408 100 481 22 346 99 94 489 770 197 AOI222XL $T=1511400 2469600 1 0 $X=1507100 $Y=2413800
X409 99 487 22 482 100 94 491 712 197 AOI222XL $T=1518000 2368800 1 0 $X=1513700 $Y=2313000
X410 100 347 22 711 99 94 494 496 197 AOI222XL $T=1537800 2570400 1 0 $X=1533500 $Y=2514600
X411 100 485 22 490 99 94 348 499 197 AOI222XL $T=1544400 2167200 1 0 $X=1540100 $Y=2111400
X412 702 24 197 22 CLKBUFX3 $T=369600 2268000 0 180 $X=338900 $Y=2212200
X413 701 29 197 22 CLKBUFX3 $T=396000 2268000 1 0 $X=391700 $Y=2212200
X414 721 197 22 103 BUFXL $T=2184600 2167200 0 180 $X=2153900 $Y=2111400
X415 699 197 22 32 BUFX1 $T=330000 2368800 0 0 $X=325700 $Y=2364800
X416 486 197 495 468 502 770 22 NAND4XL $T=1577400 2469600 1 0 $X=1573100 $Y=2413800
X417 512 197 71 507 280 720 22 NAND4XL $T=2125200 2268000 0 0 $X=2120900 $Y=2264000
X418 697 23 22 25 698 28 197 AOI22X1 $T=257400 2368800 0 0 $X=253100 $Y=2364800
X419 354 129 22 128 531 60 197 AOI22X1 $T=2125200 2469600 0 180 $X=2087900 $Y=2413800
X420 524 269 197 22 INVX4 $T=2224200 2469600 1 180 $X=2193500 $Y=2465600
X421 529 81 197 22 INVX4 $T=2409000 2268000 0 180 $X=2378300 $Y=2212200
X422 357 131 197 22 INVX4 $T=2415600 2066400 0 180 $X=2384900 $Y=2010600
X423 538 58 197 22 INVX4 $T=2580600 2368800 1 180 $X=2549900 $Y=2364800
X424 540 68 197 22 INVX4 $T=2633400 2570400 1 0 $X=2629100 $Y=2514600
X425 545 252 197 22 INVX4 $T=2699400 2469600 1 180 $X=2668700 $Y=2465600
X426 33 197 22 22 CLKINVX8 $T=488400 2268000 0 180 $X=444500 $Y=2212200
X427 33 197 22 22 CLKINVX8 $T=495000 2268000 1 0 $X=490700 $Y=2212200
X428 519 197 254 22 CLKINVX8 $T=2138400 2469600 1 180 $X=2094500 $Y=2465600
X429 448 22 197 53 CLKBUFX2 $T=633600 2268000 0 0 $X=629300 $Y=2264000
X430 479 22 197 77 CLKBUFX2 $T=1240800 2469600 0 180 $X=1210100 $Y=2413800
X431 722 22 197 138 CLKBUFX2 $T=2329800 2167200 1 0 $X=2325500 $Y=2111400
X432 192 22 197 168 CLKBUFX2 $T=3121800 2268000 0 180 $X=3091100 $Y=2212200
X433 198 22 197 184 CLKBUFX2 $T=3194400 2268000 1 180 $X=3163700 $Y=2264000
X434 514 197 510 22 396 472 NAND3XL $T=2098800 2167200 0 180 $X=2068100 $Y=2111400
X435 511 197 719 22 717 474 NAND3XL $T=2098800 2368800 1 180 $X=2068100 $Y=2364800
X436 516 197 513 22 395 271 NAND3XL $T=2118600 2066400 0 0 $X=2114300 $Y=2062400
X437 521 197 772 22 397 467 NAND3XL $T=2211000 2268000 0 180 $X=2180300 $Y=2212200
X438 389 197 23 22 75 NAND2X1 $T=270600 2469600 1 0 $X=266300 $Y=2413800
X439 498 197 475 22 350 NAND2X1 $T=1643400 2469600 0 0 $X=1639100 $Y=2465600
X440 769 197 492 477 712 406 22 NAND4X1 $T=1564200 2268000 1 0 $X=1559900 $Y=2212200
X441 500 197 88 499 67 401 22 NAND4X1 $T=1617000 2167200 1 0 $X=1612700 $Y=2111400
X442 480 90 22 100 501 197 497 349 AOI221XL $T=1683000 2066400 1 180 $X=1632500 $Y=2062400
X443 754 632 315 1297 640 1298 197 22 644 CMPR32X1 $T=3722400 2469600 1 0 $X=3718100 $Y=2413800
X444 642 635 234 1299 755 1300 197 22 659 CMPR32X1 $T=3913800 2368800 1 0 $X=3909500 $Y=2313000
X445 106 45 197 22 83 AND2X4 $T=1280400 2469600 0 0 $X=1276100 $Y=2465600
X446 287 151 197 22 148 AND2X4 $T=2626800 2268000 0 0 $X=2622500 $Y=2264000
X447 146 151 197 22 155 AND2X4 $T=2831400 2066400 0 0 $X=2827100 $Y=2062400
X448 556 560 197 558 22 166 557 OAI211XL $T=2937000 2368800 1 0 $X=2932700 $Y=2313000
X449 562 561 197 404 22 166 727 OAI211XL $T=2989800 2167200 0 180 $X=2945900 $Y=2111400
X450 572 566 197 298 22 166 729 OAI211XL $T=3042600 2167200 1 180 $X=2998700 $Y=2163200
X451 589 188 197 5 22 584 594 OAI211XL $T=3227400 2066400 0 0 $X=3223100 $Y=2062400
X452 752 311 197 628 22 629 417 OAI211XL $T=3583800 2368800 1 180 $X=3539900 $Y=2364800
X453 689 239 197 676 22 759 760 OAI211XL $T=4191000 2268000 1 180 $X=4147100 $Y=2264000
X454 387 22 76 197 CLKINVX3 $T=1947000 2368800 0 180 $X=1922900 $Y=2313000
X455 258 35 197 22 BUFX12 $T=673200 2570400 1 0 $X=668900 $Y=2514600
X456 55 22 45 197 767 AND2X2 $T=759000 2368800 0 0 $X=754700 $Y=2364800
X457 366 22 151 197 162 AND2X2 $T=3029400 2066400 0 0 $X=3025100 $Y=2062400
X458 465 22 467 708 391 468 197 NOR4BX1 $T=1082400 2268000 1 0 $X=1078100 $Y=2212200
X459 476 22 474 466 456 475 197 NOR4BX1 $T=1201200 2368800 0 180 $X=1157300 $Y=2313000
X460 464 22 472 471 262 477 197 NOR4BX1 $T=1168200 2167200 1 0 $X=1163900 $Y=2111400
X461 634 641 233 652 22 197 653 ADDFHXL $T=3854400 2368800 0 0 $X=3850100 $Y=2364800
X462 314 382 380 650 22 197 645 ADDFHXL $T=4019400 2469600 1 180 $X=3869900 $Y=2465600
X463 636 643 402 661 22 197 647 ADDFHXL $T=4026000 2268000 0 180 $X=3876500 $Y=2212200
X464 638 649 580 654 22 197 756 ADDFHXL $T=3900600 2066400 0 0 $X=3896300 $Y=2062400
X465 637 646 551 655 22 197 657 ADDFHXL $T=3900600 2167200 0 0 $X=3896300 $Y=2163200
X466 639 651 559 383 22 197 667 ADDFHXL $T=3927000 2066400 1 0 $X=3922700 $Y=2010600
X467 148 285 1302 1301 22 1303 22 197 96 DFFSX2 $T=2343000 2066400 0 0 $X=2338700 $Y=2062400
X468 1 197 151 22 CLKBUFX8 $T=3194400 2167200 0 0 $X=3190100 $Y=2163200
X469 767 22 197 57 BUFX8 $T=785400 2368800 0 0 $X=781100 $Y=2364800
X470 1 45 197 22 BUFX16 $T=3280200 2167200 0 0 $X=3275900 $Y=2163200
X471 1 372 197 22 BUFX16 $T=3286800 2167200 1 0 $X=3282500 $Y=2111400
X472 11 326 22 13 13 50 197 AOI22X2 $T=204600 2268000 1 0 $X=200300 $Y=2212200
.ENDS
***************************************
.SUBCKT NOR2X1 VDD B A Y VSS
** N=6 EP=5 IP=0 FDC=4
M0 Y B VSS VSS n18 L=1.8e-07 W=6e-07 $X=5400 $Y=10200 $D=6
M1 VSS A Y VSS n18 L=1.8e-07 W=6e-07 $X=12600 $Y=10200 $D=6
M2 6 B VDD VDD p18 L=1.8e-07 W=1.2e-06 $X=6200 $Y=28100 $D=10
M3 Y A 6 VDD p18 L=1.8e-07 W=1.2e-06 $X=11800 $Y=28100 $D=10
.ENDS
***************************************
.SUBCKT TLATNXL GN 2 D 4 Q VSS VDD
** N=14 EP=7 IP=0 FDC=18
M0 2 GN VSS VSS n18 L=1.8e-07 W=3e-07 $X=4600 $Y=14100 $D=6
M1 VSS 2 4 VSS n18 L=1.8e-07 W=3e-07 $X=13600 $Y=8300 $D=6
M2 11 D VSS VSS n18 L=1.8e-07 W=5.6e-07 $X=21600 $Y=5700 $D=6
M3 8 2 11 VSS n18 L=1.8e-07 W=5.6e-07 $X=27200 $Y=5700 $D=6
M4 12 4 8 VSS n18 L=1.8e-07 W=3e-07 $X=34800 $Y=8300 $D=6
M5 VSS 9 12 VSS n18 L=1.8e-07 W=3e-07 $X=40400 $Y=8300 $D=6
M6 Q 8 VSS VSS n18 L=1.8e-07 W=4.2e-07 $X=48400 $Y=5900 $D=6
M7 9 8 VSS VSS n18 L=1.8e-07 W=3e-07 $X=48400 $Y=13600 $D=6
M8 QN 9 VSS VSS n18 L=1.8e-07 W=4.2e-07 $X=63600 $Y=11200 $D=6
M9 2 GN VDD VDD p18 L=1.8e-07 W=4.2e-07 $X=4600 $Y=27000 $D=10
M10 VDD 2 4 VDD p18 L=1.8e-07 W=4.2e-07 $X=13600 $Y=34200 $D=10
M11 13 D VDD VDD p18 L=1.8e-07 W=8.4e-07 $X=21950 $Y=30000 $D=10
M12 8 4 13 VDD p18 L=1.8e-07 W=8.4e-07 $X=27550 $Y=30000 $D=10
M13 14 2 8 VDD p18 L=1.8e-07 W=4.2e-07 $X=35150 $Y=30000 $D=10
M14 VDD 9 14 VDD p18 L=1.8e-07 W=4.2e-07 $X=40750 $Y=30000 $D=10
M15 9 8 VDD VDD p18 L=1.8e-07 W=4.2e-07 $X=50000 $Y=28100 $D=10
M16 Q 8 VDD VDD p18 L=1.8e-07 W=6.4e-07 $X=50000 $Y=36750 $D=10
M17 QN 9 VDD VDD p18 L=1.8e-07 W=6.4e-07 $X=64600 $Y=30100 $D=10
.ENDS
***************************************
.SUBCKT NAND2X2 A B Y VSS VDD
** N=7 EP=5 IP=0 FDC=8
M0 6 B VSS VSS n18 L=1.8e-07 W=7.5e-07 $X=6600 $Y=8950 $D=6
M1 Y A 6 VSS n18 L=1.8e-07 W=7.5e-07 $X=12200 $Y=8950 $D=6
M2 7 A Y VSS n18 L=1.8e-07 W=8.5e-07 $X=19400 $Y=8950 $D=6
M3 VSS B 7 VSS n18 L=1.8e-07 W=8.5e-07 $X=25000 $Y=8950 $D=6
M4 Y B VDD VDD p18 L=1.8e-07 W=9.2e-07 $X=6400 $Y=28600 $D=10
M5 VDD A Y VDD p18 L=1.8e-07 W=9.2e-07 $X=13600 $Y=28600 $D=10
M6 Y A VDD VDD p18 L=1.83388e-07 W=9.38995e-07 $X=19200 $Y=28600 $D=10
M7 VDD B Y VDD p18 L=1.83388e-07 W=9.38995e-07 $X=25700 $Y=33300 $D=10
.ENDS
***************************************
.SUBCKT BUFX2 A VDD VSS Y
** N=5 EP=4 IP=0 FDC=4
M0 VSS A 5 VSS n18 L=1.8e-07 W=4.8e-07 $X=7200 $Y=10550 $D=6
M1 Y 5 VSS VSS n18 L=1.8e-07 W=1.2e-06 $X=13600 $Y=5700 $D=6
M2 VDD A 5 VDD p18 L=1.8e-07 W=7.2e-07 $X=7200 $Y=27200 $D=10
M3 Y 5 VDD VDD p18 L=1.8e-07 W=1.76e-06 $X=13200 $Y=27100 $D=10
.ENDS
***************************************
.SUBCKT NAND3X1 C VSS B VDD A Y
** N=8 EP=6 IP=0 FDC=6
M0 7 C VSS VSS n18 L=1.8e-07 W=9.6e-07 $X=7200 $Y=5700 $D=6
M1 8 B 7 VSS n18 L=1.8e-07 W=9.6e-07 $X=12800 $Y=5700 $D=6
M2 Y A 8 VSS n18 L=1.8e-07 W=9.6e-07 $X=18400 $Y=5700 $D=6
M3 Y C VDD VDD p18 L=1.84493e-07 W=1.01142e-06 $X=4600 $Y=30300 $D=10
M4 VDD B Y VDD p18 L=1.84493e-07 W=1.01142e-06 $X=11250 $Y=35300 $D=10
M5 Y A VDD VDD p18 L=1.84493e-07 W=1.01142e-06 $X=18400 $Y=30300 $D=10
.ENDS
***************************************
.SUBCKT ICV_7 7 9 10 11 12 13 14 15 16 17 18 19 20 21 22 24 26 28 30 31
+ 32 33 34 35 36 37 38 39 40 41 44 45 46 47 48 49 50 51 52 53
+ 54 58 59 60 62 63 64 65 66 67 68 69 70 71 73 74 76 77 78 79
+ 80 81 85 86 87 88 89 91 92 94 96 99 101 102 103 105 106 112 113 115
+ 117 118 126 127 128 132 135 136 137 138 139 142 143 144 146 148 150 151 152 153
+ 154 156 157 159 163 165 166 169 170 174 175 176 177 178 179 180 181 182 185 188
+ 189 192 193 195 196 197 199 201 204 205 209 211 212 216 217 225 226 227 228 229
+ 230 231 232 233 234 235 236 237 238 239 240 241 242 243 244 245 246 247 248 249
+ 250 251 252 253 254 255 256 257 258 259 260 261 262 263 264 265 266 267 268 269
+ 270 271 272 273 274 275 276 277 278 279 280 281 282 283 284 285 286 287 288 289
+ 290 291 292 293 294 295 296 297 298 300 301 302 303 304 305 306 307 308 309 310
+ 311 312 313 314 315 316 317 318 319 321 322 323 324 325 326 328 329 330 331 332
+ 333 334 335 336 337 338 339 340 341 342 343 344 345 346 347 348 349 350 352 354
+ 355 356 357 358
*.CALIBRE ICV_CELL 2
** N=1202 EP=264 IP=3115 FDC=7586
M0 152 273 159 159 n18 L=1.8e-07 W=1.2e-06 $X=2956400 $Y=1972000 $D=6
M1 159 735 152 159 n18 L=1.8e-07 W=1.2e-06 $X=2963600 $Y=1972000 $D=6
M2 735 555 159 159 n18 L=1.8e-07 W=5.8e-07 $X=2981800 $Y=1976400 $D=6
M3 1201 273 50 50 p18 L=1.8e-07 W=1.2e-06 $X=2956600 $Y=1993600 $D=10
M4 152 735 1201 50 p18 L=1.8e-07 W=1.2e-06 $X=2962200 $Y=1993600 $D=10
M5 1202 735 152 50 p18 L=1.8e-07 W=1.2e-06 $X=2969400 $Y=1993600 $D=10
M6 50 273 1202 50 p18 L=1.8e-07 W=1.2e-06 $X=2975000 $Y=1993600 $D=10
M7 735 555 50 50 p18 L=1.8e-07 W=8.8e-07 $X=2981800 $Y=1993600 $D=10
X8 668 50 159 373 INVXL $T=600600 1562400 0 0 $X=596300 $Y=1558400
X9 163 50 159 265 INVXL $T=2626800 1461600 0 0 $X=2622500 $Y=1457600
X10 538 50 159 694 INVXL $T=2831400 1562400 0 180 $X=2813900 $Y=1506600
X11 273 50 159 556 INVXL $T=3016200 1965600 0 0 $X=3011900 $Y=1961600
X12 562 50 159 339 INVXL $T=3108600 1461600 1 180 $X=3091100 $Y=1457600
X13 570 50 159 565 INVXL $T=3207600 1965600 1 0 $X=3203300 $Y=1909800
X14 573 50 159 588 INVXL $T=3280200 1965600 1 0 $X=3275900 $Y=1909800
X15 583 50 159 591 INVXL $T=3339600 1461600 0 0 $X=3335300 $Y=1457600
X16 589 50 159 705 INVXL $T=3385800 1663200 0 0 $X=3381500 $Y=1659200
X17 401 50 159 709 INVXL $T=3465000 1764000 0 0 $X=3460700 $Y=1760000
X18 598 50 159 608 INVXL $T=3498000 1663200 1 0 $X=3493700 $Y=1607400
X19 601 50 159 714 INVXL $T=3524400 1562400 1 0 $X=3520100 $Y=1506600
X20 281 50 159 615 INVXL $T=3544200 1461600 0 0 $X=3539900 $Y=1457600
X21 723 50 159 629 INVXL $T=3788400 1562400 1 180 $X=3770900 $Y=1558400
X22 290 50 159 638 INVXL $T=4092000 1562400 0 180 $X=4074500 $Y=1506600
X23 730 50 159 728 INVXL $T=4092000 1663200 1 180 $X=4074500 $Y=1659200
X24 356 50 159 636 INVXL $T=4098600 1461600 1 180 $X=4081100 $Y=1457600
X25 289 50 159 639 INVXL $T=4118400 1663200 0 180 $X=4100900 $Y=1607400
X26 659 50 159 660 INVXL $T=4171200 1864800 0 0 $X=4166900 $Y=1860800
X27 291 50 159 637 INVXL $T=4197600 1764000 0 180 $X=4180100 $Y=1708200
X28 292 50 159 599 INVXL $T=4217400 1864800 0 180 $X=4199900 $Y=1809000
X29 537 159 535 543 50 540 OAI21XL $T=2844600 1764000 1 0 $X=2840300 $Y=1708200
X30 555 159 556 552 50 557 OAI21XL $T=3075600 1965600 0 180 $X=3044900 $Y=1909800
X31 701 159 567 702 50 569 OAI21XL $T=3207600 1562400 1 180 $X=3176900 $Y=1558400
X32 169 159 166 342 50 178 OAI21XL $T=3201000 1965600 0 0 $X=3196700 $Y=1961600
X33 564 159 569 568 50 392 OAI21XL $T=3207600 1461600 0 0 $X=3203300 $Y=1457600
X34 572 159 176 736 50 581 OAI21XL $T=3214200 1864800 1 0 $X=3209900 $Y=1809000
X35 394 159 395 703 50 277 OAI21XL $T=3319800 1663200 0 0 $X=3315500 $Y=1659200
X36 583 159 587 396 50 397 OAI21XL $T=3379200 1562400 0 0 $X=3374900 $Y=1558400
X37 348 159 199 347 50 612 OAI21XL $T=3465000 1965600 0 0 $X=3460700 $Y=1961600
X38 601 159 614 609 50 607 OAI21XL $T=3498000 1562400 0 0 $X=3493700 $Y=1558400
X39 401 159 197 603 50 402 OAI21XL $T=3504600 1764000 1 0 $X=3500300 $Y=1708200
X40 143 159 612 605 50 280 OAI21XL $T=3531000 1965600 1 180 $X=3500300 $Y=1961600
X41 607 159 613 713 50 716 OAI21XL $T=3517800 1663200 0 0 $X=3513500 $Y=1659200
X42 143 159 403 610 50 404 OAI21XL $T=3537600 1663200 1 0 $X=3533300 $Y=1607400
X43 143 159 716 616 50 618 OAI21XL $T=3537600 1764000 1 0 $X=3533300 $Y=1708200
X44 143 159 738 611 50 619 OAI21XL $T=3550800 1864800 1 0 $X=3546500 $Y=1809000
X45 143 159 620 600 50 283 OAI21XL $T=3570600 1663200 1 0 $X=3566300 $Y=1607400
X46 720 159 621 623 50 279 OAI21XL $T=3702600 1562400 0 180 $X=3671900 $Y=1506600
X47 722 159 362 739 50 721 OAI21XL $T=3748800 1663200 0 180 $X=3718100 $Y=1607400
X48 641 159 647 640 50 362 OAI21XL $T=3973200 1663200 0 180 $X=3942500 $Y=1607400
X49 643 159 644 727 50 642 OAI21XL $T=3999600 1764000 1 0 $X=3995300 $Y=1708200
X50 731 159 656 654 50 644 OAI21XL $T=4118400 1764000 1 180 $X=4087700 $Y=1760000
X51 358 159 288 357 50 657 OAI21XL $T=4177800 1965600 1 180 $X=4147100 $Y=1961600
X52 236 159 50 53 427 NAND2XL $T=792000 1461600 0 0 $X=787700 $Y=1457600
X53 428 159 50 673 305 NAND2XL $T=924000 1965600 1 0 $X=919700 $Y=1909800
X54 368 159 50 441 372 NAND2XL $T=1023000 1864800 1 0 $X=1018700 $Y=1809000
X55 434 159 50 450 452 NAND2XL $T=1122000 1663200 1 0 $X=1117700 $Y=1607400
X56 464 159 50 88 679 NAND2XL $T=1386000 1764000 0 0 $X=1381700 $Y=1760000
X57 680 159 50 88 74 NAND2XL $T=1465200 1764000 0 0 $X=1460900 $Y=1760000
X58 684 159 50 88 374 NAND2XL $T=1504800 1764000 1 180 $X=1480700 $Y=1760000
X59 473 159 50 88 78 NAND2XL $T=1524600 1663200 1 180 $X=1500500 $Y=1659200
X60 484 159 50 87 468 NAND2XL $T=1716000 1663200 0 180 $X=1691900 $Y=1607400
X61 482 159 50 454 576 NAND2XL $T=1749000 1764000 1 0 $X=1744700 $Y=1708200
X62 514 159 50 139 505 NAND2XL $T=2494800 1461600 0 0 $X=2490500 $Y=1457600
X63 516 159 50 139 502 NAND2XL $T=2527800 1562400 0 180 $X=2503700 $Y=1506600
X64 517 159 50 139 511 NAND2XL $T=2534400 1562400 1 180 $X=2510300 $Y=1558400
X65 144 159 50 139 503 NAND2XL $T=2600400 1461600 1 180 $X=2576300 $Y=1457600
X66 520 159 50 139 512 NAND2XL $T=2620200 1764000 1 180 $X=2596100 $Y=1760000
X67 330 159 50 139 329 NAND2XL $T=2646600 1965600 1 180 $X=2622500 $Y=1961600
X68 524 159 50 139 504 NAND2XL $T=2659800 1562400 0 180 $X=2635700 $Y=1506600
X69 692 159 50 139 507 NAND2XL $T=2666400 1864800 0 180 $X=2642300 $Y=1809000
X70 523 159 50 139 519 NAND2XL $T=2673000 1864800 1 180 $X=2648900 $Y=1860800
X71 530 159 50 139 331 NAND2XL $T=2739000 1965600 1 180 $X=2714900 $Y=1961600
X72 532 159 50 151 522 NAND2XL $T=2791800 1562400 1 180 $X=2767700 $Y=1558400
X73 533 159 50 151 528 NAND2XL $T=2791800 1764000 0 180 $X=2767700 $Y=1708200
X74 534 159 50 151 387 NAND2XL $T=2798400 1663200 1 180 $X=2774300 $Y=1659200
X75 536 159 50 151 525 NAND2XL $T=2818200 1663200 0 180 $X=2794100 $Y=1607400
X76 541 159 50 151 268 NAND2XL $T=2838000 1965600 1 180 $X=2813900 $Y=1961600
X77 391 159 50 151 526 NAND2XL $T=2844600 1864800 1 180 $X=2820500 $Y=1860800
X78 542 159 50 151 529 NAND2XL $T=2851200 1864800 0 180 $X=2827100 $Y=1809000
X79 538 159 50 539 695 NAND2XL $T=2871000 1562400 0 180 $X=2846900 $Y=1506600
X80 389 159 50 151 527 NAND2XL $T=2871000 1864800 1 180 $X=2846900 $Y=1860800
X81 533 159 50 545 538 NAND2XL $T=2897400 1562400 1 180 $X=2873300 $Y=1558400
X82 271 159 50 697 544 NAND2XL $T=2897400 1663200 1 180 $X=2873300 $Y=1659200
X83 271 159 50 547 698 NAND2XL $T=2910600 1562400 1 0 $X=2906300 $Y=1506600
X84 536 159 50 548 543 NAND2XL $T=2930400 1764000 0 180 $X=2906300 $Y=1708200
X85 271 159 50 335 550 NAND2XL $T=2943600 1562400 1 0 $X=2939300 $Y=1506600
X86 532 159 50 554 336 NAND2XL $T=2996400 1461600 0 0 $X=2992100 $Y=1457600
X87 271 159 50 558 699 NAND2XL $T=3049200 1663200 1 0 $X=3044900 $Y=1607400
X88 562 159 50 165 700 NAND2XL $T=3128400 1461600 1 180 $X=3104300 $Y=1457600
X89 340 159 50 274 564 NAND2XL $T=3135000 1461600 0 0 $X=3130700 $Y=1457600
X90 564 159 50 569 568 NAND2XL $T=3161400 1461600 0 0 $X=3157100 $Y=1457600
X91 570 159 50 563 169 NAND2XL $T=3194400 1965600 1 180 $X=3170300 $Y=1961600
X92 534 159 50 566 562 NAND2XL $T=3201000 1562400 0 180 $X=3176900 $Y=1506600
X93 572 159 50 176 736 NAND2XL $T=3201000 1864800 0 180 $X=3176900 $Y=1809000
X94 573 159 50 390 570 NAND2XL $T=3201000 1965600 0 180 $X=3176900 $Y=1909800
X95 578 159 50 576 575 NAND2XL $T=3227400 1764000 0 180 $X=3203300 $Y=1708200
X96 179 159 50 392 577 NAND2XL $T=3214200 1562400 0 0 $X=3209900 $Y=1558400
X97 580 159 50 475 702 NAND2XL $T=3234000 1663200 0 180 $X=3209900 $Y=1607400
X98 275 159 50 573 573 NAND2XL $T=3220800 1965600 1 0 $X=3216500 $Y=1909800
X99 179 159 50 177 584 NAND2XL $T=3253800 1562400 1 180 $X=3229700 $Y=1558400
X100 179 159 50 582 393 NAND2XL $T=3253800 1764000 0 180 $X=3229700 $Y=1708200
X101 509 159 50 580 703 NAND2XL $T=3247200 1663200 1 0 $X=3242900 $Y=1607400
X102 575 159 50 579 572 NAND2XL $T=3247200 1764000 0 0 $X=3242900 $Y=1760000
X103 179 159 50 581 585 NAND2XL $T=3247200 1864800 1 0 $X=3242900 $Y=1809000
X104 573 159 50 586 343 NAND2XL $T=3247200 1965600 0 0 $X=3242900 $Y=1961600
X105 506 159 50 276 396 NAND2XL $T=3300000 1461600 0 0 $X=3295700 $Y=1457600
X106 515 159 50 578 589 NAND2XL $T=3313200 1764000 1 0 $X=3308900 $Y=1708200
X107 589 159 50 593 592 NAND2XL $T=3379200 1663200 1 180 $X=3355100 $Y=1659200
X108 396 159 50 591 594 NAND2XL $T=3379200 1461600 0 0 $X=3374900 $Y=1457600
X109 132 159 50 596 598 NAND2XL $T=3399000 1663200 0 0 $X=3394700 $Y=1659200
X110 518 159 50 590 603 NAND2XL $T=3399000 1764000 0 0 $X=3394700 $Y=1760000
X111 385 159 50 606 609 NAND2XL $T=3478200 1562400 1 0 $X=3473900 $Y=1506600
X112 598 159 50 604 613 NAND2XL $T=3478200 1663200 0 0 $X=3473900 $Y=1659200
X113 603 159 50 709 711 NAND2XL $T=3478200 1764000 0 0 $X=3473900 $Y=1760000
X114 607 159 50 613 713 NAND2XL $T=3511200 1663200 1 0 $X=3506900 $Y=1607400
X115 281 159 50 710 715 NAND2XL $T=3524400 1461600 0 0 $X=3520100 $Y=1457600
X116 609 159 50 714 617 NAND2XL $T=3531000 1562400 0 0 $X=3526700 $Y=1558400
X117 271 159 50 718 561 NAND2XL $T=3630000 1663200 0 180 $X=3605900 $Y=1607400
X118 574 159 50 719 623 NAND2XL $T=3643200 1663200 1 0 $X=3638900 $Y=1607400
X119 271 159 50 721 560 NAND2XL $T=3715800 1663200 0 180 $X=3691700 $Y=1607400
X120 723 159 50 630 722 NAND2XL $T=3748800 1562400 0 0 $X=3744500 $Y=1558400
X121 722 159 50 362 739 NAND2XL $T=3762000 1663200 1 0 $X=3757700 $Y=1607400
X122 628 159 50 633 723 NAND2XL $T=3801600 1663200 0 180 $X=3777500 $Y=1607400
X123 271 159 50 724 551 NAND2XL $T=3900600 1663200 1 180 $X=3876500 $Y=1659200
X124 725 159 50 627 640 NAND2XL $T=3900600 1663200 1 0 $X=3896300 $Y=1607400
X125 271 159 50 642 559 NAND2XL $T=3979800 1764000 1 180 $X=3955700 $Y=1760000
X126 271 159 50 645 553 NAND2XL $T=3999600 1764000 0 0 $X=3995300 $Y=1760000
X127 271 159 50 646 549 NAND2XL $T=4026000 1864800 1 180 $X=4001900 $Y=1860800
X128 643 159 50 644 727 NAND2XL $T=4052400 1764000 0 180 $X=4028300 $Y=1708200
X129 271 159 50 648 354 NAND2XL $T=4052400 1965600 1 180 $X=4028300 $Y=1961600
X130 730 159 50 729 643 NAND2XL $T=4085400 1764000 0 180 $X=4061300 $Y=1708200
X131 649 159 50 651 730 NAND2XL $T=4065600 1764000 0 0 $X=4061300 $Y=1760000
X132 652 159 50 650 654 NAND2XL $T=4078800 1864800 1 0 $X=4074500 $Y=1809000
X133 287 159 50 653 659 NAND2XL $T=4125000 1965600 1 0 $X=4120700 $Y=1909800
X134 659 159 50 658 655 NAND2XL $T=4171200 1965600 0 180 $X=4147100 $Y=1909800
X135 571 567 159 50 582 XOR2XL $T=3214200 1663200 0 0 $X=3209900 $Y=1659200
X136 622 621 159 50 718 XOR2XL $T=3669600 1562400 1 180 $X=3612500 $Y=1558400
X137 726 647 159 50 724 XOR2XL $T=4032600 1663200 1 180 $X=3975500 $Y=1659200
X138 355 288 159 50 648 XOR2XL $T=4085400 1965600 0 0 $X=4081100 $Y=1961600
X139 732 656 159 50 645 XOR2XL $T=4158000 1764000 0 180 $X=4100900 $Y=1708200
X140 10 293 740 50 741 294 159 742 50 DFFSXL $T=0 1965600 1 0 $X=-4300 $Y=1909800
X141 11 225 225 50 743 296 159 744 50 DFFSXL $T=105600 1965600 0 0 $X=101300 $Y=1961600
X142 11 226 745 50 746 407 159 747 50 DFFSXL $T=125400 1965600 1 0 $X=121100 $Y=1909800
X143 10 54 748 38 749 408 159 750 50 DFFSXL $T=138600 1562400 0 0 $X=134300 $Y=1558400
X144 11 295 751 50 50 13 159 752 50 DFFSXL $T=151800 1764000 0 0 $X=147500 $Y=1760000
X145 19 229 753 38 754 230 159 755 50 DFFSXL $T=198000 1461600 0 0 $X=193700 $Y=1457600
X146 11 12 756 50 757 663 159 758 50 DFFSXL $T=204600 1663200 0 0 $X=200300 $Y=1659200
X147 17 228 759 50 760 410 159 761 50 DFFSXL $T=231000 1965600 0 0 $X=226700 $Y=1961600
X148 11 54 762 50 763 412 159 764 50 DFFSXL $T=250800 1663200 1 0 $X=246500 $Y=1607400
X149 19 54 765 38 766 411 159 767 50 DFFSXL $T=323400 1461600 0 0 $X=319100 $Y=1457600
X150 14 54 768 38 769 364 159 770 50 DFFSXL $T=343200 1663200 0 0 $X=338900 $Y=1659200
X151 19 12 12 50 771 409 159 772 50 DFFSXL $T=356400 1965600 1 0 $X=352100 $Y=1909800
X152 14 233 773 38 774 415 159 775 50 DFFSXL $T=369600 1562400 0 0 $X=365300 $Y=1558400
X153 10 226 776 50 777 416 159 778 50 DFFSXL $T=435600 1864800 0 0 $X=431300 $Y=1860800
X154 19 18 779 38 780 300 159 781 50 DFFSXL $T=462000 1461600 0 0 $X=457700 $Y=1457600
X155 7 233 233 38 782 369 159 783 50 DFFSXL $T=481800 1663200 0 0 $X=477500 $Y=1659200
X156 7 71 784 38 785 47 159 786 50 DFFSXL $T=488400 1663200 1 0 $X=484100 $Y=1607400
X157 14 26 787 38 788 365 159 789 50 DFFSXL $T=501600 1562400 1 0 $X=497300 $Y=1506600
X158 28 54 790 38 791 424 159 792 50 DFFSXL $T=613800 1663200 1 0 $X=609500 $Y=1607400
X159 10 126 793 50 794 367 159 795 50 DFFSXL $T=627000 1764000 0 0 $X=622700 $Y=1760000
X160 7 33 796 50 797 670 159 798 50 DFFSXL $T=640200 1764000 1 0 $X=635900 $Y=1708200
X161 10 36 799 38 800 426 159 801 50 DFFSXL $T=679800 1562400 1 0 $X=675500 $Y=1506600
X162 7 54 54 50 802 432 159 803 50 DFFSXL $T=732600 1663200 0 0 $X=728300 $Y=1659200
X163 19 240 804 50 805 431 159 806 50 DFFSXL $T=752400 1864800 1 0 $X=748100 $Y=1809000
X164 19 36 807 50 808 433 159 809 50 DFFSXL $T=765600 1764000 0 0 $X=761300 $Y=1760000
X165 7 69 810 50 811 436 159 812 50 DFFSXL $T=864600 1764000 1 0 $X=860300 $Y=1708200
X166 17 69 813 50 814 438 159 815 50 DFFSXL $T=877800 1864800 1 0 $X=873500 $Y=1809000
X167 14 36 816 244 817 437 159 818 50 DFFSXL $T=884400 1562400 1 0 $X=880100 $Y=1506600
X168 17 33 819 50 820 370 159 821 50 DFFSXL $T=884400 1663200 1 0 $X=880100 $Y=1607400
X169 17 36 822 244 823 443 159 824 50 DFFSXL $T=976800 1562400 0 0 $X=972500 $Y=1558400
X170 39 54 825 50 826 448 159 827 50 DFFSXL $T=990000 1965600 0 0 $X=985700 $Y=1961600
X171 39 36 828 50 829 675 159 830 50 DFFSXL $T=1003200 1764000 1 0 $X=998900 $Y=1708200
X172 39 69 831 244 832 449 159 833 50 DFFSXL $T=1016400 1461600 0 0 $X=1012100 $Y=1457600
X173 40 69 834 50 835 734 159 836 50 DFFSXL $T=1115400 1562400 0 0 $X=1111100 $Y=1558400
X174 11 229 837 50 838 451 159 839 50 DFFSXL $T=1115400 1965600 0 0 $X=1111100 $Y=1961600
X175 40 59 840 50 841 676 159 842 50 DFFSXL $T=1155000 1461600 0 0 $X=1150700 $Y=1457600
X176 14 69 843 50 844 458 159 845 50 DFFSXL $T=1221000 1663200 1 0 $X=1216700 $Y=1607400
X177 14 45 45 50 846 462 159 847 50 DFFSXL $T=1234200 1864800 0 0 $X=1229900 $Y=1860800
X178 64 45 848 50 849 464 159 850 50 DFFSXL $T=1240800 1965600 0 0 $X=1236500 $Y=1961600
X179 66 59 851 50 852 378 159 853 50 DFFSXL $T=1346400 1461600 0 0 $X=1342100 $Y=1457600
X180 66 36 36 50 854 470 159 855 50 DFFSXL $T=1359600 1663200 0 0 $X=1355300 $Y=1659200
X181 70 45 856 50 857 376 159 858 50 DFFSXL $T=1372800 1965600 1 0 $X=1368500 $Y=1909800
X182 73 71 859 50 860 469 159 861 50 DFFSXL $T=1471800 1663200 1 0 $X=1467500 $Y=1607400
X183 70 71 71 50 862 377 159 863 50 DFFSXL $T=1485000 1965600 0 0 $X=1480700 $Y=1961600
X184 73 85 864 50 865 316 159 866 50 DFFSXL $T=1584000 1461600 0 0 $X=1579700 $Y=1457600
X185 64 36 867 50 868 483 159 869 50 DFFSXL $T=1650000 1864800 1 0 $X=1645700 $Y=1809000
X186 86 36 870 50 871 479 159 872 50 DFFSXL $T=1689600 1764000 0 0 $X=1685300 $Y=1760000
X187 94 69 873 96 874 486 159 875 50 DFFSXL $T=1815000 1764000 0 0 $X=1810700 $Y=1760000
X188 255 69 876 96 877 381 159 878 50 DFFSXL $T=1821600 1663200 1 0 $X=1817300 $Y=1607400
X189 255 36 879 96 880 687 159 881 50 DFFSXL $T=1821600 1764000 1 0 $X=1817300 $Y=1708200
X190 94 59 882 50 883 487 159 884 50 DFFSXL $T=1828200 1965600 1 0 $X=1823900 $Y=1909800
X191 255 59 885 96 886 686 159 887 50 DFFSXL $T=1841400 1562400 0 0 $X=1837100 $Y=1558400
X192 99 69 888 96 889 492 159 890 50 DFFSXL $T=1947000 1764000 1 0 $X=1942700 $Y=1708200
X193 94 45 891 96 892 324 159 893 50 DFFSXL $T=1973400 1764000 0 0 $X=1969100 $Y=1760000
X194 99 106 106 96 894 325 159 895 50 DFFSXL $T=1980000 1562400 1 0 $X=1975700 $Y=1506600
X195 99 59 896 96 897 383 159 898 50 DFFSXL $T=2006400 1461600 0 0 $X=2002100 $Y=1457600
X196 94 71 899 96 900 497 159 901 50 DFFSXL $T=2079000 1663200 0 0 $X=2074700 $Y=1659200
X197 94 106 902 96 903 499 159 904 50 DFFSXL $T=2098800 1663200 1 0 $X=2094500 $Y=1607400
X198 113 71 905 96 906 495 159 907 50 DFFSXL $T=2098800 1764000 0 0 $X=2094500 $Y=1760000
X199 113 106 908 96 909 498 159 910 50 DFFSXL $T=2098800 1864800 1 0 $X=2094500 $Y=1809000
X200 258 503 911 96 912 326 159 913 50 DFFSXL $T=2197800 1461600 0 0 $X=2193500 $Y=1457600
X201 118 106 914 96 915 175 159 916 50 DFFSXL $T=2204400 1663200 0 0 $X=2200100 $Y=1659200
X202 118 45 917 96 918 275 159 919 50 DFFSXL $T=2211000 1965600 1 0 $X=2206700 $Y=1909800
X203 118 71 920 96 921 506 159 922 50 DFFSXL $T=2224200 1764000 1 0 $X=2219900 $Y=1708200
X204 159 106 923 96 924 690 159 925 50 DFFSXL $T=2224200 1864800 0 0 $X=2219900 $Y=1860800
X205 258 505 926 96 927 510 159 928 50 DFFSXL $T=2323200 1461600 0 0 $X=2318900 $Y=1457600
X206 258 507 929 50 930 262 159 931 50 DFFSXL $T=2336400 1965600 0 0 $X=2332100 $Y=1961600
X207 258 511 932 96 933 513 159 934 50 DFFSXL $T=2442000 1663200 1 0 $X=2437700 $Y=1607400
X208 159 69 935 263 936 518 159 937 50 DFFSXL $T=2455200 1764000 0 0 $X=2450900 $Y=1760000
X209 159 59 59 263 938 185 159 939 50 DFFSXL $T=2481600 1864800 1 0 $X=2477300 $Y=1809000
X210 136 137 940 263 941 514 159 942 50 DFFSXL $T=2554200 1562400 0 0 $X=2549900 $Y=1558400
X211 136 387 943 263 944 692 159 945 50 DFFSXL $T=2587200 1764000 1 0 $X=2582900 $Y=1708200
X212 136 154 946 263 947 144 159 948 50 DFFSXL $T=2640000 1663200 0 0 $X=2635700 $Y=1659200
X213 136 522 949 263 950 517 159 951 50 DFFSXL $T=2666400 1663200 1 0 $X=2662100 $Y=1607400
X214 136 525 952 263 953 516 159 954 50 DFFSXL $T=2686200 1562400 1 0 $X=2681900 $Y=1506600
X215 136 526 955 263 956 523 159 957 50 DFFSXL $T=2692800 1864800 0 0 $X=2688500 $Y=1860800
X216 136 527 958 263 959 520 159 960 50 DFFSXL $T=2699400 1864800 1 0 $X=2695100 $Y=1809000
X217 136 528 961 263 962 530 159 963 50 DFFSXL $T=2712600 1965600 1 0 $X=2708300 $Y=1909800
X218 142 332 964 263 965 267 159 261 50 DFFSXL $T=2719200 1461600 0 0 $X=2714900 $Y=1457600
X219 153 698 966 263 967 536 159 545 50 DFFSXL $T=2890800 1663200 1 0 $X=2886500 $Y=1607400
X220 153 549 968 263 969 270 159 970 50 DFFSXL $T=2910600 1965600 1 0 $X=2906300 $Y=1909800
X221 153 553 971 263 972 542 159 973 50 DFFSXL $T=2950200 1764000 1 0 $X=2945900 $Y=1708200
X222 153 557 974 50 975 555 159 976 50 DFFSXL $T=3049200 1965600 0 0 $X=3044900 $Y=1961600
X223 153 561 977 263 978 534 159 574 50 DFFSXL $T=3082200 1663200 0 0 $X=3077900 $Y=1659200
X224 181 584 979 285 980 276 159 706 50 DFFSXL $T=3260400 1562400 1 0 $X=3256100 $Y=1506600
X225 181 577 981 285 982 188 159 399 50 DFFSXL $T=3267000 1663200 1 0 $X=3262700 $Y=1607400
X226 181 393 983 50 984 580 159 595 50 DFFSXL $T=3273600 1864800 1 0 $X=3269300 $Y=1809000
X227 181 585 985 50 986 578 159 400 50 DFFSXL $T=3273600 1864800 0 0 $X=3269300 $Y=1860800
X228 181 345 987 50 988 573 159 737 50 DFFSXL $T=3286800 1965600 0 0 $X=3282500 $Y=1961600
X229 282 619 989 50 990 624 159 991 50 DFFSXL $T=3550800 1965600 0 0 $X=3546500 $Y=1961600
X230 282 404 992 50 993 626 159 994 50 DFFSXL $T=3564000 1864800 0 0 $X=3559700 $Y=1860800
X231 282 618 995 50 996 631 159 997 50 DFFSXL $T=3682800 1965600 1 0 $X=3678500 $Y=1909800
X232 204 619 998 50 999 635 159 1000 50 DFFSXL $T=3689400 1864800 1 0 $X=3685100 $Y=1809000
X233 282 283 1001 50 1002 632 159 1003 50 DFFSXL $T=3795000 1965600 0 0 $X=3790700 $Y=1961600
X234 67 159 237 50 INVX2 $T=1353000 1562400 1 0 $X=1348700 $Y=1506600
X235 483 88 50 478 1004 159 482 AOI21XL $T=1716000 1764000 0 180 $X=1685300 $Y=1708200
X236 318 88 50 485 1005 159 481 AOI21XL $T=1749000 1663200 1 0 $X=1744700 $Y=1607400
X237 539 269 50 694 1006 159 535 AOI21XL $T=2844600 1562400 1 180 $X=2813900 $Y=1558400
X238 546 540 50 696 1007 159 333 AOI21XL $T=2838000 1965600 1 0 $X=2833700 $Y=1909800
X239 563 166 50 565 1008 159 567 AOI21XL $T=3141600 1965600 1 0 $X=3137300 $Y=1909800
X240 274 569 50 341 1009 159 170 AOI21XL $T=3181200 1461600 0 0 $X=3176900 $Y=1457600
X241 180 277 50 344 1010 159 587 AOI21XL $T=3260400 1461600 0 0 $X=3256100 $Y=1457600
X242 586 346 50 588 1011 159 395 AOI21XL $T=3313200 1965600 1 0 $X=3308900 $Y=1909800
X243 593 397 50 705 1012 159 193 AOI21XL $T=3385800 1764000 1 0 $X=3381500 $Y=1708200
X244 594 587 50 597 1013 159 606 AOI21XL $T=3432000 1461600 0 0 $X=3427700 $Y=1457600
X245 604 607 50 608 1014 159 201 AOI21XL $T=3458400 1663200 1 0 $X=3454100 $Y=1607400
X246 710 402 50 615 710 159 614 AOI21XL $T=3498000 1562400 1 0 $X=3493700 $Y=1506600
X247 711 197 50 712 1015 159 738 AOI21XL $T=3511200 1864800 1 0 $X=3506900 $Y=1809000
X248 617 614 50 717 1016 159 620 AOI21XL $T=3583800 1562400 0 0 $X=3579500 $Y=1558400
X249 729 644 50 728 1017 159 647 AOI21XL $T=4065600 1663200 1 180 $X=4034900 $Y=1659200
X250 658 657 50 660 1018 159 656 AOI21XL $T=4144800 1864800 0 0 $X=4140500 $Y=1860800
X251 537 159 543 1019 50 693 NAND2BXL $T=2831400 1764000 0 180 $X=2800700 $Y=1708200
X252 701 159 702 1020 50 571 NAND2BXL $T=3207600 1663200 0 180 $X=3176900 $Y=1607400
X253 394 159 703 1021 50 704 NAND2BXL $T=3306600 1764000 0 180 $X=3275900 $Y=1708200
X254 720 159 623 1022 50 622 NAND2BXL $T=3709200 1562400 1 180 $X=3678500 $Y=1558400
X255 641 159 640 640 50 726 NAND2BXL $T=3986400 1663200 1 0 $X=3982100 $Y=1607400
X256 731 159 654 1023 50 732 NAND2BXL $T=4144800 1764000 0 0 $X=4140500 $Y=1760000
X257 50 546 540 696 159 NOR2XL $T=2890800 1864800 1 180 $X=2866700 $Y=1860800
X258 50 536 548 537 159 NOR2XL $T=2897400 1764000 0 180 $X=2873300 $Y=1708200
X259 50 150 152 552 159 NOR2XL $T=2910600 1965600 0 0 $X=2906300 $Y=1961600
X260 50 532 554 337 159 NOR2XL $T=3055800 1461600 1 180 $X=3031700 $Y=1457600
X261 50 506 276 583 159 NOR2XL $T=3240600 1562400 1 0 $X=3236300 $Y=1506600
X262 50 580 475 701 159 NOR2XL $T=3286800 1562400 1 180 $X=3262700 $Y=1558400
X263 50 509 580 394 159 NOR2XL $T=3280200 1663200 0 0 $X=3275900 $Y=1659200
X264 50 518 590 401 159 NOR2XL $T=3359400 1764000 0 0 $X=3355100 $Y=1760000
X265 50 594 587 597 159 NOR2XL $T=3405600 1461600 0 0 $X=3401300 $Y=1457600
X266 50 192 606 398 159 NOR2XL $T=3405600 1562400 1 0 $X=3401300 $Y=1506600
X267 50 192 590 707 159 NOR2XL $T=3405600 1864800 1 0 $X=3401300 $Y=1809000
X268 50 385 606 601 159 NOR2XL $T=3425400 1562400 1 0 $X=3421100 $Y=1506600
X269 50 192 349 708 159 NOR2XL $T=3451800 1562400 1 0 $X=3447500 $Y=1506600
X270 50 192 596 602 159 NOR2XL $T=3458400 1764000 1 0 $X=3454100 $Y=1708200
X271 50 711 197 712 159 NOR2XL $T=3504600 1764000 0 0 $X=3500300 $Y=1760000
X272 50 617 614 717 159 NOR2XL $T=3557400 1562400 0 0 $X=3553100 $Y=1558400
X273 50 725 627 641 159 NOR2XL $T=3927000 1663200 0 0 $X=3922700 $Y=1659200
X274 50 652 650 731 159 NOR2XL $T=4125000 1864800 1 0 $X=4120700 $Y=1809000
X275 24 421 418 159 1024 41 50 OAI2BB1XL $T=633600 1864800 0 180 $X=596300 $Y=1809000
X276 60 675 674 159 1025 445 50 OAI2BB1XL $T=1128600 1562400 0 180 $X=1091300 $Y=1506600
X277 60 449 374 159 1026 682 50 OAI2BB1XL $T=1399200 1562400 1 0 $X=1394900 $Y=1506600
X278 87 479 685 159 1027 478 50 OAI2BB1XL $T=1676400 1764000 0 180 $X=1639100 $Y=1708200
X279 87 317 480 159 1028 485 50 OAI2BB1XL $T=1755600 1562400 1 180 $X=1718300 $Y=1558400
X280 176 579 575 159 1029 174 50 OAI2BB1XL $T=3234000 1764000 1 180 $X=3196700 $Y=1760000
X281 695 269 159 50 547 XNOR2XL $T=2844600 1461600 0 0 $X=2840300 $Y=1457600
X282 700 279 159 50 558 XNOR2XL $T=3128400 1562400 0 180 $X=3071300 $Y=1506600
X283 592 397 159 50 596 XNOR2XL $T=3399000 1663200 1 0 $X=3394700 $Y=1607400
X284 715 402 159 50 403 XNOR2XL $T=3537600 1562400 1 0 $X=3533300 $Y=1506600
X285 655 657 159 50 646 XNOR2XL $T=4085400 1864800 0 0 $X=4081100 $Y=1860800
X286 448 60 50 248 159 373 455 AOI211XL $T=1161600 1965600 1 0 $X=1157300 $Y=1909800
X287 706 159 50 195 159 398 600 AOI211XL $T=3412200 1562400 0 0 $X=3407900 $Y=1558400
X288 737 159 50 195 159 278 605 AOI211XL $T=3418800 1965600 0 0 $X=3414500 $Y=1961600
X289 400 159 50 195 159 602 616 AOI211XL $T=3425400 1764000 1 0 $X=3421100 $Y=1708200
X290 595 159 50 195 159 707 611 AOI211XL $T=3438600 1864800 1 0 $X=3434300 $Y=1809000
X291 399 159 50 195 159 708 610 AOI211XL $T=3451800 1562400 0 0 $X=3447500 $Y=1558400
X292 693 535 159 50 697 XOR2X1 $T=2811600 1663200 0 0 $X=2807300 $Y=1659200
X293 389 272 159 50 546 XOR2X1 $T=2943600 1864800 1 180 $X=2886500 $Y=1860800
X294 704 395 159 50 590 XOR2X1 $T=3293400 1764000 0 0 $X=3289100 $Y=1760000
X295 10 12 1030 50 405 159 1031 50 11 227 1032 50 1033 406 1034 ICV_1 $T=13200 1864800 1 0 $X=8900 $Y=1809000
X296 10 227 227 50 661 159 1035 50 14 227 1036 50 1037 666 1038 ICV_1 $T=112200 1764000 1 0 $X=107900 $Y=1708200
X297 17 54 1039 50 413 159 1040 50 17 26 1041 50 1042 667 1043 ICV_1 $T=277200 1864800 1 0 $X=272900 $Y=1809000
X298 7 228 1044 50 414 159 1045 50 7 26 1046 38 1047 669 1048 ICV_1 $T=376200 1764000 1 0 $X=371900 $Y=1708200
X299 19 26 1049 50 421 159 1050 50 19 126 1051 50 1052 671 1053 ICV_1 $T=567600 1965600 1 0 $X=563300 $Y=1909800
X300 19 233 1054 38 420 159 1055 50 19 45 1056 50 1057 371 1058 ICV_1 $T=633600 1562400 0 0 $X=629300 $Y=1558400
X301 28 126 1059 50 429 159 1060 50 17 126 126 50 1061 307 1062 ICV_1 $T=726000 1965600 0 0 $X=721700 $Y=1961600
X302 40 126 1063 50 439 159 1064 50 40 54 1065 50 1066 442 1067 ICV_1 $T=871200 1864800 0 0 $X=866900 $Y=1860800
X303 7 36 1068 50 446 159 1069 50 7 59 1070 50 1071 310 1072 ICV_1 $T=996600 1663200 0 0 $X=992300 $Y=1659200
X304 7 85 1073 50 63 159 1074 50 64 233 1075 50 1076 680 1077 ICV_1 $T=1122000 1764000 0 0 $X=1117700 $Y=1760000
X305 11 45 1078 50 447 159 1079 50 64 85 1080 50 1081 68 1082 ICV_1 $T=1128600 1864800 1 0 $X=1124300 $Y=1809000
X306 66 69 1083 50 467 159 1084 50 73 69 1085 50 1086 472 1087 ICV_1 $T=1333200 1562400 0 0 $X=1328900 $Y=1558400
X307 64 69 1088 50 684 159 1089 50 64 71 1090 50 1091 473 1092 ICV_1 $T=1386000 1764000 1 0 $X=1381700 $Y=1708200
X308 66 45 1093 50 471 159 1094 50 73 45 1095 50 1096 474 1097 ICV_1 $T=1386000 1864800 0 0 $X=1381700 $Y=1860800
X309 73 36 1098 50 476 159 1099 50 86 45 1100 50 1101 484 1102 ICV_1 $T=1564200 1663200 0 0 $X=1559900 $Y=1659200
X310 70 85 1103 50 76 159 1104 50 70 36 1105 50 1106 477 1107 ICV_1 $T=1570800 1965600 1 0 $X=1566500 $Y=1909800
X311 73 59 1108 50 380 159 1109 50 86 106 1110 50 1111 252 1112 ICV_1 $T=1577400 1562400 1 0 $X=1573100 $Y=1506600
X312 70 233 1113 50 250 159 1114 50 255 233 1115 50 1116 488 1117 ICV_1 $T=1696200 1965600 0 0 $X=1691900 $Y=1961600
X313 86 71 1118 50 319 159 1119 50 255 71 1120 96 1121 321 1122 ICV_1 $T=1709400 1461600 0 0 $X=1705100 $Y=1457600
X314 113 69 1123 96 489 159 1124 50 113 36 1125 96 1126 496 1127 ICV_1 $T=1953600 1965600 0 0 $X=1949300 $Y=1961600
X315 99 36 1128 96 689 159 1129 50 113 59 1130 96 1131 501 1132 ICV_1 $T=1960200 1864800 0 0 $X=1955900 $Y=1860800
X316 258 502 1133 96 500 159 1134 50 258 504 1135 96 1136 386 1137 ICV_1 $T=2178000 1562400 1 0 $X=2173700 $Y=1506600
X317 159 71 1138 96 385 159 1139 50 159 126 126 263 1140 691 1141 ICV_1 $T=2224200 1864800 1 0 $X=2219900 $Y=1809000
X318 258 512 1142 263 508 159 1143 50 258 519 1144 263 1145 521 1146 ICV_1 $T=2428800 1965600 1 0 $X=2424500 $Y=1909800
X319 136 529 1147 263 524 159 1148 50 153 544 1149 263 1150 389 548 ICV_1 $T=2719200 1764000 0 0 $X=2714900 $Y=1760000
X320 153 550 1151 263 533 159 554 50 153 699 1152 263 1153 532 566 ICV_1 $T=2910600 1562400 0 0 $X=2906300 $Y=1558400
X321 153 551 1154 263 148 159 1155 50 153 559 1156 263 1157 391 1158 ICV_1 $T=2923800 1864800 1 0 $X=2919500 $Y=1809000
X322 204 404 1159 50 625 159 1160 50 204 618 1161 50 1162 634 1163 ICV_1 $T=3557400 1764000 0 0 $X=3553100 $Y=1760000
X323 630 362 50 629 621 159 AOI21X1 $T=3742200 1562400 1 180 $X=3711500 $Y=1558400
X324 545 533 159 50 539 OR2XL $T=2871000 1663200 0 180 $X=2840300 $Y=1607400
X325 566 534 159 50 165 OR2XL $T=3168000 1562400 0 180 $X=3137300 $Y=1506600
X326 390 573 159 50 563 OR2XL $T=3214200 1864800 0 0 $X=3209900 $Y=1860800
X327 188 175 159 50 180 OR2XL $T=3234000 1461600 0 0 $X=3229700 $Y=1457600
X328 573 275 159 50 586 OR2XL $T=3247200 1965600 1 0 $X=3242900 $Y=1909800
X329 576 578 159 50 579 OR2XL $T=3253800 1764000 1 0 $X=3249500 $Y=1708200
X330 578 515 159 50 593 OR2XL $T=3352800 1764000 1 0 $X=3348500 $Y=1708200
X331 596 132 159 50 604 OR2XL $T=3425400 1663200 0 0 $X=3421100 $Y=1659200
X332 349 259 159 50 710 OR2XL $T=3465000 1461600 0 0 $X=3460700 $Y=1457600
X333 633 628 159 50 630 OR2XL $T=3814800 1663200 1 0 $X=3810500 $Y=1607400
X334 651 649 159 50 729 OR2XL $T=4026000 1764000 0 0 $X=4021700 $Y=1760000
X335 653 287 159 50 658 OR2XL $T=4078800 1965600 1 0 $X=4074500 $Y=1909800
X336 28 36 1164 50 425 159 1165 50 DFFSX1 $T=871200 1663200 0 180 $X=741500 $Y=1607400
X337 94 36 1166 96 382 159 1167 50 DFFSX1 $T=1834800 1864800 0 0 $X=1830500 $Y=1860800
X338 118 69 1168 96 509 159 1169 50 DFFSX1 $T=2316600 1663200 1 0 $X=2312300 $Y=1607400
X339 118 36 1170 96 515 159 1171 50 DFFSX1 $T=2336400 1663200 0 0 $X=2332100 $Y=1659200
X340 118 59 1172 263 264 159 1173 50 DFFSX1 $T=2461800 1764000 1 0 $X=2457500 $Y=1708200
X341 138 9 1174 263 531 159 1175 50 DFFSX1 $T=3036000 1864800 0 0 $X=3031700 $Y=1860800
X342 153 560 1176 263 541 159 1177 50 DFFSX1 $T=3062400 1764000 0 0 $X=3058100 $Y=1760000
X343 138 599 1178 50 182 159 1179 50 DFFSX1 $T=3418800 1864800 0 0 $X=3414500 $Y=1860800
X344 138 196 1180 50 189 159 1181 50 DFFSX1 $T=3418800 1965600 1 0 $X=3414500 $Y=1909800
X345 138 352 352 285 209 159 1182 50 DFFSX1 $T=3735600 1461600 0 0 $X=3731300 $Y=1457600
X346 138 636 1183 285 211 159 1184 50 DFFSX1 $T=3814800 1562400 1 0 $X=3810500 $Y=1506600
X347 138 637 1185 50 217 159 1186 50 DFFSX1 $T=3814800 1764000 0 0 $X=3810500 $Y=1760000
X348 138 638 1187 285 212 159 1188 50 DFFSX1 $T=3828000 1562400 0 0 $X=3823700 $Y=1558400
X349 138 639 1189 50 286 159 1190 50 DFFSX1 $T=3847800 1764000 1 0 $X=3843500 $Y=1708200
X350 661 50 21 32 406 363 159 AOI22XL $T=217800 1864800 0 0 $X=213500 $Y=1860800
X351 408 50 46 62 411 664 159 AOI22XL $T=323400 1562400 1 0 $X=319100 $Y=1506600
X352 666 50 232 49 298 665 159 AOI22XL $T=369600 1864800 1 180 $X=332300 $Y=1860800
X353 669 50 15 16 667 418 159 AOI22XL $T=574200 1764000 1 180 $X=536900 $Y=1760000
X354 412 50 32 237 364 668 159 AOI22XL $T=547800 1562400 0 0 $X=543500 $Y=1558400
X355 415 50 237 62 420 238 159 AOI22XL $T=594000 1461600 0 0 $X=589700 $Y=1457600
X356 671 50 62 46 367 428 159 AOI22XL $T=798600 1864800 0 0 $X=794300 $Y=1860800
X357 235 50 53 46 44 368 159 AOI22XL $T=818400 1461600 0 0 $X=814100 $Y=1457600
X358 431 50 62 46 241 302 159 AOI22XL $T=871200 1965600 0 180 $X=833900 $Y=1909800
X359 369 50 242 16 303 672 159 AOI22XL $T=871200 1461600 0 0 $X=866900 $Y=1457600
X360 426 50 46 49 425 434 159 AOI22XL $T=877800 1663200 0 0 $X=873500 $Y=1659200
X361 306 50 53 237 437 440 159 AOI22XL $T=970200 1461600 0 0 $X=965900 $Y=1457600
X362 424 50 49 242 432 379 159 AOI22XL $T=970200 1764000 0 0 $X=965900 $Y=1760000
X363 439 50 53 49 429 673 159 AOI22XL $T=1003200 1965600 0 180 $X=965900 $Y=1909800
X364 436 50 242 16 438 444 159 AOI22XL $T=1036200 1764000 0 0 $X=1031900 $Y=1760000
X365 443 50 16 242 446 674 159 AOI22XL $T=1075800 1663200 1 0 $X=1071500 $Y=1607400
X366 371 50 62 32 447 441 159 AOI22XL $T=1075800 1864800 1 0 $X=1071500 $Y=1809000
X367 243 50 60 32 451 308 159 AOI22XL $T=1122000 1965600 1 0 $X=1117700 $Y=1909800
X368 433 50 62 32 309 450 159 AOI22XL $T=1234200 1764000 0 180 $X=1196900 $Y=1708200
X369 312 50 237 53 676 677 159 AOI22XL $T=1320000 1461600 1 180 $X=1282700 $Y=1457600
X370 734 50 53 237 458 459 159 AOI22XL $T=1287000 1562400 0 0 $X=1282700 $Y=1558400
X371 311 50 242 237 462 375 159 AOI22XL $T=1306800 1965600 1 0 $X=1302500 $Y=1909800
X372 381 50 101 115 489 461 159 AOI22XL $T=1927200 1864800 1 0 $X=1922900 $Y=1809000
X373 382 50 257 101 687 490 159 AOI22XL $T=1933800 1663200 0 0 $X=1929500 $Y=1659200
X374 686 50 101 102 383 491 159 AOI22XL $T=1960200 1663200 1 0 $X=1955900 $Y=1607400
X375 486 50 257 102 492 463 159 AOI22XL $T=1966800 1663200 0 0 $X=1962500 $Y=1659200
X376 689 50 102 115 496 688 159 AOI22XL $T=2032800 1864800 0 180 $X=1995500 $Y=1809000
X377 499 50 257 115 498 105 159 AOI22XL $T=2072400 1663200 0 180 $X=2035100 $Y=1607400
X378 497 50 257 115 495 322 159 AOI22XL $T=2079000 1562400 1 180 $X=2041700 $Y=1558400
X379 487 50 257 115 501 384 159 AOI22XL $T=2125200 1965600 1 0 $X=2120900 $Y=1909800
X380 506 50 117 117 385 256 159 AOI22XL $T=2250600 1562400 1 180 $X=2213300 $Y=1558400
X381 515 50 117 117 132 494 159 AOI22XL $T=2494800 1663200 0 0 $X=2490500 $Y=1659200
X382 264 50 117 117 185 493 159 AOI22XL $T=2626800 1663200 0 180 $X=2589500 $Y=1607400
X383 24 409 50 663 32 21 405 662 159 AOI222XL $T=323400 1864800 1 180 $X=266300 $Y=1860800
X384 32 407 50 416 21 24 234 417 159 AOI222XL $T=481800 1965600 1 0 $X=477500 $Y=1909800
X385 87 467 50 472 80 79 77 77 159 AOI222XL $T=1452000 1562400 1 0 $X=1447700 $Y=1506600
X386 87 249 50 469 80 79 377 314 159 AOI222XL $T=1551000 1461600 1 180 $X=1493900 $Y=1457600
X387 87 471 50 474 80 79 376 683 159 AOI222XL $T=1557600 1864800 0 180 $X=1500500 $Y=1809000
X388 80 476 50 470 87 79 477 685 159 AOI222XL $T=1570800 1764000 0 0 $X=1566500 $Y=1760000
X389 87 378 50 380 80 79 253 480 159 AOI222XL $T=1603800 1562400 0 0 $X=1599500 $Y=1558400
X390 664 159 50 366 BUFXL $T=316800 1562400 1 180 $X=286100 $Y=1558400
X391 417 159 50 35 BUFXL $T=640200 1965600 1 180 $X=609500 $Y=1961600
X392 261 159 50 127 BUFXL $T=2422200 1764000 0 180 $X=2391500 $Y=1708200
X393 662 159 50 297 BUFX1 $T=264000 1965600 1 0 $X=259700 $Y=1909800
X394 690 159 50 259 BUFX1 $T=2323200 1764000 0 0 $X=2318900 $Y=1760000
X395 691 159 50 328 BUFX1 $T=2501400 1965600 0 0 $X=2497100 $Y=1961600
X396 427 159 91 672 435 51 50 NAND4XL $T=910800 1562400 0 0 $X=906500 $Y=1558400
X397 463 159 461 444 460 246 50 NAND4XL $T=1339800 1663200 1 180 $X=1302500 $Y=1659200
X398 679 159 375 468 681 683 50 NAND4XL $T=1419000 1864800 1 0 $X=1414700 $Y=1809000
X399 410 16 50 15 414 31 159 AOI22X1 $T=382800 1965600 0 0 $X=378500 $Y=1961600
X400 30 32 50 232 365 301 159 AOI22X1 $T=627000 1663200 0 0 $X=622700 $Y=1659200
X401 670 15 50 16 370 52 159 AOI22X1 $T=818400 1764000 1 0 $X=814100 $Y=1708200
X402 413 16 50 53 442 58 159 AOI22X1 $T=1023000 1965600 1 0 $X=1018700 $Y=1909800
X403 509 117 50 117 518 465 159 AOI22X1 $T=2607000 1663200 1 180 $X=2569700 $Y=1659200
X404 20 50 50 159 CLKINVX4 $T=521400 1764000 1 180 $X=490700 $Y=1760000
X405 20 50 50 159 CLKINVX4 $T=1821600 1864800 0 180 $X=1790900 $Y=1809000
X406 20 50 50 159 CLKINVX4 $T=3399000 1965600 0 180 $X=3368300 $Y=1909800
X407 67 232 159 50 INVX4 $T=765600 1461600 1 180 $X=734900 $Y=1457600
X408 500 71 159 50 INVX4 $T=2118600 1562400 1 180 $X=2087900 $Y=1558400
X409 260 18 159 50 INVX4 $T=2316600 1965600 1 180 $X=2285900 $Y=1961600
X410 508 36 159 50 INVX4 $T=2415600 1965600 0 180 $X=2384900 $Y=1909800
X411 513 69 159 50 INVX4 $T=2481600 1562400 1 180 $X=2450900 $Y=1558400
X412 521 59 159 50 INVX4 $T=2646600 1864800 1 180 $X=2615900 $Y=1860800
X413 20 159 38 50 CLKINVX8 $T=627000 1461600 0 0 $X=622700 $Y=1457600
X414 20 159 50 50 CLKINVX8 $T=1808400 1562400 1 180 $X=1764500 $Y=1558400
X415 20 159 96 50 CLKINVX8 $T=2125200 1562400 0 0 $X=2120900 $Y=1558400
X416 510 159 48 50 CLKINVX8 $T=2448600 1461600 0 0 $X=2444300 $Y=1457600
X417 150 159 271 50 CLKINVX8 $T=2904000 1965600 1 180 $X=2860100 $Y=1961600
X418 304 50 159 92 CLKBUFX2 $T=924000 1461600 0 0 $X=919700 $Y=1457600
X419 531 50 159 146 CLKBUFX2 $T=2791800 1965600 1 180 $X=2761100 $Y=1961600
X420 459 159 465 50 65 678 NAND3XL $T=1386000 1663200 0 180 $X=1355300 $Y=1607400
X421 384 159 493 50 491 457 NAND3XL $T=2032800 1562400 1 180 $X=2002100 $Y=1558400
X422 688 159 494 50 490 453 NAND3XL $T=2032800 1663200 0 180 $X=2002100 $Y=1607400
X423 379 159 366 251 455 315 50 NAND4X1 $T=1617000 1965600 0 0 $X=1612700 $Y=1961600
X424 247 313 681 372 50 159 390 OR4X1 $T=1399200 1965600 0 0 $X=1394900 $Y=1961600
X425 430 50 435 239 159 NOR2BXL $T=871200 1562400 0 180 $X=840500 $Y=1506600
X426 205 541 350 1191 719 1192 159 50 633 CMPR32X1 $T=3557400 1663200 0 0 $X=3553100 $Y=1659200
X427 386 50 126 159 CLKINVX3 $T=2389200 1764000 1 180 $X=2365100 $Y=1760000
X428 423 11 159 50 BUFX12 $T=693000 1864800 0 0 $X=688700 $Y=1860800
X429 22 50 37 159 733 AND2X2 $T=508200 1965600 0 0 $X=503900 $Y=1961600
X430 103 50 37 159 419 AND2X2 $T=561000 1864800 0 0 $X=556700 $Y=1860800
X431 34 50 37 159 422 AND2X2 $T=627000 1864800 0 0 $X=622700 $Y=1860800
X432 112 50 37 159 423 AND2X2 $T=666600 1864800 0 0 $X=662300 $Y=1860800
X433 388 50 138 159 136 AND2X2 $T=2666400 1965600 0 0 $X=2662100 $Y=1961600
X434 682 50 460 159 678 466 NOR3XL $T=1432200 1663200 0 180 $X=1401500 $Y=1607400
X435 135 50 261 159 89 266 NOR3XL $T=2653200 1461600 0 0 $X=2648900 $Y=1457600
X436 440 50 453 445 452 454 159 NOR4BX1 $T=1161600 1663200 1 0 $X=1157300 $Y=1607400
X437 677 50 457 245 245 456 159 NOR4BX1 $T=1280400 1562400 0 180 $X=1236500 $Y=1506600
X438 634 631 148 628 50 159 627 ADDFHXL $T=3847800 1663200 1 180 $X=3698300 $Y=1659200
X439 284 632 391 725 50 159 651 ADDFHXL $T=3795000 1864800 0 0 $X=3790700 $Y=1860800
X440 625 626 542 649 50 159 650 ADDFHXL $T=3927000 1864800 1 0 $X=3922700 $Y=1809000
X441 635 624 270 652 50 159 653 ADDFHXL $T=3927000 1965600 1 0 $X=3922700 $Y=1909800
X442 733 50 159 10 BUFX8 $T=534600 1965600 0 0 $X=530300 $Y=1961600
X443 419 50 159 28 BUFX8 $T=541200 1864800 1 0 $X=536900 $Y=1809000
X444 422 50 159 19 BUFX8 $T=712800 1864800 0 180 $X=649100 $Y=1809000
X445 101 488 50 102 323 430 159 AOI22X2 $T=2013000 1965600 1 0 $X=2008700 $Y=1909800
X446 50 574 719 720 159 NOR2X1 $T=3669600 1663200 1 0 $X=3665300 $Y=1607400
X447 128 1193 128 1194 388 159 50 TLATNXL $T=2547600 1562400 1 0 $X=2543300 $Y=1506600
X448 138 1195 334 1196 156 159 50 TLATNXL $T=2904000 1461600 0 0 $X=2899700 $Y=1457600
X449 138 1197 157 1198 338 159 50 TLATNXL $T=2989800 1562400 1 0 $X=2985500 $Y=1506600
X450 138 1199 157 1200 216 159 50 TLATNXL $T=3643200 1461600 1 180 $X=3566300 $Y=1457600
X451 665 363 231 159 50 NAND2X2 $T=310200 1965600 1 0 $X=305900 $Y=1909800
X452 456 481 254 159 50 NAND2X2 $T=1676400 1562400 0 0 $X=1672100 $Y=1558400
X453 106 50 159 85 BUFX2 $T=1623600 1864800 0 180 $X=1592900 $Y=1809000
X454 77 159 81 50 466 475 NAND3X1 $T=1524600 1562400 1 0 $X=1520300 $Y=1506600
.ENDS
***************************************
.SUBCKT OAI221XL B1 B0 VSS A0 VDD 6 A1 C0 Y
** N=12 EP=9 IP=0 FDC=10
M0 6 B1 VSS VSS n18 L=1.8e-07 W=6.6e-07 $X=4600 $Y=10200 $D=6
M1 VSS B0 6 VSS n18 L=1.8e-07 W=6.6e-07 $X=11800 $Y=10200 $D=6
M2 6 A0 10 VSS n18 L=1.8e-07 W=6.6e-07 $X=22850 $Y=13750 $D=6
M3 10 A1 6 VSS n18 L=1.8e-07 W=6.6e-07 $X=30050 $Y=13750 $D=6
M4 Y C0 10 VSS n18 L=1.8e-07 W=6.6e-07 $X=36100 $Y=8050 $D=6
M5 11 B1 VDD VDD p18 L=1.8e-07 W=8.4e-07 $X=4600 $Y=31800 $D=10
M6 Y B0 11 VDD p18 L=1.8e-07 W=8.4e-07 $X=10200 $Y=31800 $D=10
M7 12 A0 Y VDD p18 L=1.8e-07 W=8.4e-07 $X=17400 $Y=31800 $D=10
M8 VDD A1 12 VDD p18 L=1.8e-07 W=8.4e-07 $X=23000 $Y=31800 $D=10
M9 Y C0 VDD VDD p18 L=1.8e-07 W=6.4e-07 $X=29000 $Y=33850 $D=10
.ENDS
***************************************
.SUBCKT AND2X1 A B VDD VSS Y
** N=7 EP=5 IP=0 FDC=6
M0 7 A 6 VSS n18 L=1.8e-07 W=3.2e-07 $X=5600 $Y=15050 $D=6
M1 VSS B 7 VSS n18 L=1.8e-07 W=3.2e-07 $X=11200 $Y=15050 $D=6
M2 Y 6 VSS VSS n18 L=1.8e-07 W=6e-07 $X=17300 $Y=12250 $D=6
M3 VDD A 6 VDD p18 L=1.8e-07 W=3.6e-07 $X=4100 $Y=38950 $D=10
M4 VDD B 6 VDD p18 L=1.8e-07 W=3.6e-07 $X=9900 $Y=30350 $D=10
M5 Y 6 VDD VDD p18 L=1.8e-07 W=9e-07 $X=17900 $Y=30350 $D=10
.ENDS
***************************************
.SUBCKT OR3XL A B C VDD VSS Y
** N=9 EP=6 IP=0 FDC=8
M0 VSS A 7 VSS n18 L=1.8e-07 W=3e-07 $X=6600 $Y=15400 $D=6
M1 7 B VSS VSS n18 L=1.8e-07 W=3e-07 $X=12600 $Y=15400 $D=6
M2 VSS C 7 VSS n18 L=1.8e-07 W=3e-07 $X=18600 $Y=15400 $D=6
M3 Y 7 VSS VSS n18 L=1.8e-07 W=4.2e-07 $X=24650 $Y=14200 $D=6
M4 8 A 7 VDD p18 L=1.8e-07 W=6.6e-07 $X=6200 $Y=31650 $D=10
M5 9 B 8 VDD p18 L=1.8e-07 W=6.6e-07 $X=11800 $Y=31650 $D=10
M6 VDD C 9 VDD p18 L=1.8e-07 W=6.6e-07 $X=17400 $Y=31650 $D=10
M7 Y 7 VDD VDD p18 L=1.8e-07 W=6.4e-07 $X=23400 $Y=31650 $D=10
.ENDS
***************************************
.SUBCKT NOR2X2 A B VSS VDD Y
** N=7 EP=5 IP=0 FDC=6
M0 Y A VSS VSS n18 L=1.8e-07 W=1.2e-06 $X=17800 $Y=6400 $D=6
M1 VSS B Y VSS n18 L=1.8e-07 W=1.2e-06 $X=25000 $Y=6400 $D=6
M2 6 B VDD VDD p18 L=1.8e-07 W=1.2e-06 $X=6400 $Y=28000 $D=10
M3 Y A 6 VDD p18 L=1.8e-07 W=1.2e-06 $X=12000 $Y=28000 $D=10
M4 7 A Y VDD p18 L=1.8e-07 W=1.2e-06 $X=19200 $Y=28000 $D=10
M5 VDD B 7 VDD p18 L=1.8e-07 W=1.2e-06 $X=24800 $Y=28000 $D=10
.ENDS
***************************************
.SUBCKT OR2X1 A B VSS VDD Y
** N=7 EP=5 IP=0 FDC=6
M0 6 A VSS VSS n18 L=1.8e-07 W=3e-07 $X=4100 $Y=10450 $D=6
M1 VSS B 6 VSS n18 L=1.8e-07 W=3e-07 $X=12100 $Y=15100 $D=6
M2 Y 6 VSS VSS n18 L=1.8e-07 W=6e-07 $X=18100 $Y=12100 $D=6
M3 7 A 6 VDD p18 L=1.8e-07 W=5.6e-07 $X=6400 $Y=33600 $D=10
M4 VDD B 7 VDD p18 L=1.8e-07 W=5.6e-07 $X=12000 $Y=33600 $D=10
M5 Y 6 VDD VDD p18 L=1.8e-07 W=9e-07 $X=18000 $Y=30200 $D=10
.ENDS
***************************************
.SUBCKT NOR2X4 B VDD VSS A Y
** N=8 EP=5 IP=0 FDC=10
M0 Y B VSS VSS n18 L=1.8e-07 W=1.2e-06 $X=6600 $Y=5700 $D=6
M1 VSS A Y VSS n18 L=1.8e-07 W=1.2e-06 $X=13800 $Y=5700 $D=6
M2 Y A VSS VSS n18 L=1.8e-07 W=1.2e-06 $X=21000 $Y=5700 $D=6
M3 VSS B Y VSS n18 L=1.8e-07 W=1.2e-06 $X=28200 $Y=5700 $D=6
M4 6 B VDD VDD p18 L=1.8e-07 W=1.6e-06 $X=6800 $Y=28700 $D=10
M5 Y A 6 VDD p18 L=1.8e-07 W=1.6e-06 $X=12400 $Y=28700 $D=10
M6 7 A Y VDD p18 L=1.8e-07 W=1.6e-06 $X=19600 $Y=28700 $D=10
M7 VDD B 7 VDD p18 L=1.8e-07 W=1.6e-06 $X=25200 $Y=28700 $D=10
M8 8 B VDD VDD p18 L=1.82333e-07 W=1.55814e-06 $X=32400 $Y=28700 $D=10
M9 Y A 8 VDD p18 L=1.82333e-07 W=1.55814e-06 $X=38000 $Y=28700 $D=10
.ENDS
***************************************
.SUBCKT CLKINVX2 A VSS Y VDD
** N=4 EP=4 IP=0 FDC=3
M0 Y A VSS VSS n18 L=1.8e-07 W=6.4e-07 $X=8450 $Y=10500 $D=6
M1 Y A VDD VDD p18 L=1.8e-07 W=9e-07 $X=4600 $Y=27500 $D=10
M2 VDD A Y VDD p18 L=1.8e-07 W=9e-07 $X=11800 $Y=27500 $D=10
.ENDS
***************************************
.SUBCKT ICV_8 2 3 4 5 6 7 8 9 10 11 12 13 14 15 16 17 18 19 21 24
+ 25 26 27 28 29 30 31 32 33 34 35 36 37 38 39 40 41 42 43 44
+ 45 46 47 48 50 51 52 53 54 55 56 58 59 60 61 62 64 65 66 67
+ 68 69 70 71 72 73 74 75 76 77 78 79 80 81 82 83 84 85 86 87
+ 88 89 90 92 93 94 95 96 97 98 99 100 101 102 103 104 105 106 107 108
+ 109 110 111 112 113 114 115 120 121 122 124 125 127 128 129 130 131 132 133 134
+ 135 136 137 138 139 140 141 142 144 145 150 151 152 153 155 157 158 159 160 161
+ 162 163 164 167 168 169 170 171 172 173 174 175 176 178 179 180 181 182 183 184
+ 185 186 188 189 190 191 192 194 195 196 197 199 202 203 204 205 206 207 208 209
+ 210 211 212 213 214 215 216 217 218 219 220 221 222 223 224 225 226 227 228 229
+ 230 231 232 233 234 235 236 237 238 239 240 241 242 243 244 245 246 247 248 249
+ 250 251 252 253 254 255 256 257 258 259 260 261 262 263 264 265 266 267 268 269
+ 270 272 273 274 275 276 277 278 279 280 281 282 283 284 285 286 287 288 289 290
+ 291 292 293 294 295 296 297 298 299 300 301 302 303 304 305 306 307 308 309 310
+ 311 312 313 314 315 316 317 318 319 320 321 322 323 324 325 326 327 328 329 330
+ 331 332 333 334
*.CALIBRE ICV_CELL 2
** N=935 EP=304 IP=2664 FDC=5441
M0 164 450 587 164 n18 L=1.8e-07 W=6.4e-07 $X=2054100 $Y=1064100 $D=6
M1 233 447 164 164 n18 L=1.8e-07 W=1.2e-06 $X=2061300 $Y=1064100 $D=6
M2 164 456 233 164 n18 L=1.8e-07 W=1.2e-06 $X=2068500 $Y=1064100 $D=6
M3 233 587 164 164 n18 L=1.8e-07 W=1.2e-06 $X=2076500 $Y=1064100 $D=6
M4 164 475 436 164 n18 L=1.8e-07 W=6e-07 $X=2429000 $Y=1342600 $D=6
M5 337 485 164 164 n18 L=1.8e-07 W=1.02e-06 $X=2543200 $Y=1265700 $D=6
M6 164 364 337 164 n18 L=1.8e-07 W=1.02e-06 $X=2550400 $Y=1265700 $D=6
M7 337 483 164 164 n18 L=1.8e-07 W=1.02e-06 $X=2557600 $Y=1265700 $D=6
M8 164 483 337 164 n18 L=1.8e-07 W=1.02e-06 $X=2564800 $Y=1265700 $D=6
M9 337 364 164 164 n18 L=1.8e-07 W=1.02e-06 $X=2572000 $Y=1265700 $D=6
M10 164 485 337 164 n18 L=1.8e-07 W=1.02e-06 $X=2579200 $Y=1265700 $D=6
M11 164 241 588 164 n18 L=1.8e-07 W=4.8e-07 $X=2593500 $Y=969500 $D=6
M12 588 127 164 164 n18 L=1.8e-07 W=4.8e-07 $X=2602600 $Y=969500 $D=6
M13 164 246 588 164 n18 L=1.8e-07 W=4.8e-07 $X=2610300 $Y=969500 $D=6
M14 157 588 164 164 n18 L=1.8e-07 W=1.2e-06 $X=2618400 $Y=963300 $D=6
M15 199 158 164 164 n18 L=1.8e-07 W=3.6e-07 $X=3290200 $Y=967500 $D=6
M16 80 450 587 80 p18 L=1.8e-07 W=9.6e-07 $X=2052200 $Y=1085850 $D=10
M17 924 447 80 80 p18 L=1.8e-07 W=1.4e-06 $X=2060000 $Y=1085850 $D=10
M18 925 456 924 80 p18 L=1.8e-07 W=1.4e-06 $X=2065600 $Y=1085850 $D=10
M19 233 587 925 80 p18 L=1.8e-07 W=1.4e-06 $X=2071600 $Y=1086700 $D=10
M20 926 587 233 80 p18 L=1.8e-07 W=1.4e-06 $X=2078800 $Y=1086700 $D=10
M21 927 456 926 80 p18 L=1.8e-07 W=1.4e-06 $X=2084600 $Y=1086700 $D=10
M22 80 447 927 80 p18 L=1.8e-07 W=1.4e-06 $X=2090200 $Y=1086700 $D=10
M23 80 475 436 80 p18 L=1.8e-07 W=9e-07 $X=2429000 $Y=1324800 $D=10
M24 928 483 337 80 p18 L=1.8e-07 W=1.52e-06 $X=2529900 $Y=1289500 $D=10
M25 929 364 928 80 p18 L=1.8e-07 W=1.52e-06 $X=2535500 $Y=1289500 $D=10
M26 80 485 929 80 p18 L=1.8e-07 W=1.52e-06 $X=2541100 $Y=1289500 $D=10
M27 930 485 80 80 p18 L=1.8e-07 W=1.52e-06 $X=2548300 $Y=1289500 $D=10
M28 931 364 930 80 p18 L=1.8e-07 W=1.52e-06 $X=2553900 $Y=1289500 $D=10
M29 337 483 931 80 p18 L=1.8e-07 W=1.52e-06 $X=2560000 $Y=1286250 $D=10
M30 932 483 337 80 p18 L=1.8e-07 W=1.52e-06 $X=2567200 $Y=1286250 $D=10
M31 933 364 932 80 p18 L=1.8e-07 W=1.52e-06 $X=2573050 $Y=1286250 $D=10
M32 80 485 933 80 p18 L=1.8e-07 W=1.52e-06 $X=2579200 $Y=1287000 $D=10
M33 934 241 588 80 p18 L=1.8e-07 W=1.12e-06 $X=2597600 $Y=987800 $D=10
M34 935 127 934 80 p18 L=1.8e-07 W=1.12e-06 $X=2603600 $Y=987800 $D=10
M35 80 246 935 80 p18 L=1.8e-07 W=1.12e-06 $X=2609200 $Y=987800 $D=10
M36 157 588 80 80 p18 L=1.8e-07 W=1.74e-06 $X=2618400 $Y=984900 $D=10
M37 199 158 80 80 p18 L=1.8e-07 W=9e-07 $X=3288600 $Y=986950 $D=10
X38 425 80 164 430 INVXL $T=1590600 1461600 1 0 $X=1586300 $Y=1405800
X39 429 80 164 506 INVXL $T=1643400 1360800 0 0 $X=1639100 $Y=1356800
X40 343 80 164 549 INVXL $T=1795200 1159200 1 180 $X=1777700 $Y=1155200
X41 346 80 164 348 INVXL $T=1808400 1058400 1 180 $X=1790900 $Y=1054400
X42 351 80 164 441 INVXL $T=1834800 1058400 0 0 $X=1830500 $Y=1054400
X43 353 80 164 554 INVXL $T=1914000 1260000 1 0 $X=1909700 $Y=1204200
X44 40 80 164 448 INVXL $T=2006400 1260000 0 0 $X=2002100 $Y=1256000
X45 38 80 164 404 INVXL $T=2046000 1360800 0 0 $X=2041700 $Y=1356800
X46 110 80 164 461 INVXL $T=2164800 1058400 1 0 $X=2160500 $Y=1002600
X47 365 80 164 437 INVXL $T=2310000 1360800 0 180 $X=2292500 $Y=1305000
X48 362 80 164 458 INVXL $T=2521200 1260000 0 180 $X=2503700 $Y=1204200
X49 466 80 164 484 INVXL $T=2554200 1461600 1 0 $X=2549900 $Y=1405800
X50 134 80 164 482 INVXL $T=2633400 1159200 1 180 $X=2615900 $Y=1155200
X51 480 80 164 490 INVXL $T=2666400 1058400 0 0 $X=2662100 $Y=1054400
X52 344 80 164 13 INVXL $T=2824800 1260000 0 180 $X=2807300 $Y=1204200
X53 499 80 164 371 INVXL $T=2838000 1260000 0 180 $X=2820500 $Y=1204200
X54 358 80 164 358 INVXL $T=2877600 1260000 1 0 $X=2873300 $Y=1204200
X55 464 80 164 590 INVXL $T=3062400 1159200 0 0 $X=3058100 $Y=1155200
X56 250 80 164 591 INVXL $T=3062400 1260000 0 0 $X=3058100 $Y=1256000
X57 363 80 164 508 INVXL $T=3135000 1159200 1 0 $X=3130700 $Y=1103400
X58 327 80 164 260 INVXL $T=3148200 1461600 1 0 $X=3143900 $Y=1405800
X59 439 80 164 592 INVXL $T=3154800 1159200 1 0 $X=3150500 $Y=1103400
X60 337 80 164 568 INVXL $T=3154800 1260000 0 0 $X=3150500 $Y=1256000
X61 569 80 164 572 INVXL $T=3174600 1360800 0 0 $X=3170300 $Y=1356800
X62 472 80 164 574 INVXL $T=3207600 1360800 1 0 $X=3203300 $Y=1305000
X63 489 80 164 376 INVXL $T=3253800 1360800 0 0 $X=3249500 $Y=1356800
X64 510 80 164 329 INVXL $T=3260400 1461600 1 0 $X=3256100 $Y=1405800
X65 467 80 164 593 INVXL $T=3333000 1159200 1 0 $X=3328700 $Y=1103400
X66 336 80 164 594 INVXL $T=3359400 1058400 0 0 $X=3355100 $Y=1054400
X67 517 80 164 595 INVXL $T=3399000 1260000 1 0 $X=3394700 $Y=1204200
X68 365 80 164 523 INVXL $T=3623400 1260000 0 0 $X=3619100 $Y=1256000
X69 463 80 164 583 INVXL $T=3762000 1058400 0 0 $X=3757700 $Y=1054400
X70 462 80 164 596 INVXL $T=3854400 1260000 0 180 $X=3836900 $Y=1204200
X71 267 80 164 515 INVXL $T=4065600 1159200 1 180 $X=4048100 $Y=1155200
X72 268 80 164 525 INVXL $T=4072200 1360800 0 180 $X=4054700 $Y=1305000
X73 270 80 164 520 INVXL $T=4085400 1260000 0 180 $X=4067900 $Y=1204200
X74 269 80 164 266 INVXL $T=4085400 1360800 0 180 $X=4067900 $Y=1305000
X75 552 164 88 92 80 550 OAI21XL $T=1821600 1159200 0 180 $X=1790900 $Y=1103400
X76 114 164 113 142 80 469 OAI21XL $T=2138400 957600 0 0 $X=2134100 $Y=953600
X77 157 164 14 244 80 137 OAI21XL $T=2620200 1058400 0 180 $X=2589500 $Y=1002600
X78 559 164 367 344 80 481 OAI21XL $T=2659800 1058400 1 180 $X=2629100 $Y=1054400
X79 366 164 141 142 80 368 OAI21XL $T=2666400 1058400 1 0 $X=2662100 $Y=1002600
X80 496 164 133 491 80 497 OAI21XL $T=2745600 1159200 0 0 $X=2741300 $Y=1155200
X81 256 164 500 322 80 253 OAI21XL $T=3036000 1461600 0 180 $X=3005300 $Y=1405800
X82 569 164 170 509 80 175 OAI21XL $T=3168000 1461600 1 0 $X=3163700 $Y=1405800
X83 471 164 80 309 CLKBUFXL $T=2382600 1260000 0 0 $X=2378300 $Y=1256000
X84 387 164 80 385 218 NAND2XL $T=726000 1260000 0 0 $X=721700 $Y=1256000
X85 535 164 80 29 342 NAND2XL $T=1075800 1058400 1 180 $X=1051700 $Y=1054400
X86 394 164 80 537 51 NAND2XL $T=1188000 1159200 0 0 $X=1183700 $Y=1155200
X87 538 164 80 386 408 NAND2XL $T=1273800 1260000 1 0 $X=1269500 $Y=1204200
X88 431 164 80 88 70 NAND2XL $T=1623600 1360800 1 180 $X=1599500 $Y=1356800
X89 291 164 80 88 427 NAND2XL $T=1623600 1461600 1 0 $X=1619300 $Y=1405800
X90 433 164 80 432 417 NAND2XL $T=1696200 1058400 1 180 $X=1672100 $Y=1054400
X91 456 164 80 432 412 NAND2XL $T=1709400 1159200 0 180 $X=1685300 $Y=1103400
X92 90 164 80 88 345 NAND2XL $T=1749000 1360800 1 0 $X=1744700 $Y=1305000
X93 435 164 80 548 295 NAND2XL $T=1762200 957600 0 0 $X=1757900 $Y=953600
X94 346 164 80 549 547 NAND2XL $T=1795200 1260000 0 180 $X=1771100 $Y=1204200
X95 441 164 80 456 438 NAND2XL $T=1848000 1159200 0 180 $X=1823900 $Y=1103400
X96 354 164 80 446 343 NAND2XL $T=1874400 1159200 1 180 $X=1850300 $Y=1155200
X97 346 164 80 350 447 NAND2XL $T=1881000 1159200 0 0 $X=1876700 $Y=1155200
X98 445 164 80 228 352 NAND2XL $T=1920600 1058400 0 180 $X=1896500 $Y=1002600
X99 450 164 80 554 351 NAND2XL $T=1927200 1159200 1 180 $X=1903100 $Y=1155200
X100 445 164 80 444 353 NAND2XL $T=1940400 1058400 1 180 $X=1916300 $Y=1054400
X101 229 164 80 92 113 NAND2XL $T=2125200 957600 1 180 $X=2101100 $Y=953600
X102 238 164 80 240 359 NAND2XL $T=2468400 1058400 1 0 $X=2464100 $Y=1002600
X103 359 164 80 142 478 NAND2XL $T=2494800 1461600 1 0 $X=2490500 $Y=1405800
X104 483 164 80 135 487 NAND2XL $T=2600400 1360800 1 0 $X=2596100 $Y=1305000
X105 366 164 80 142 12 NAND2XL $T=2666400 1461600 0 180 $X=2642300 $Y=1405800
X106 372 164 80 249 559 NAND2XL $T=2699400 1260000 0 180 $X=2675300 $Y=1204200
X107 314 164 80 364 496 NAND2XL $T=2752200 1260000 0 0 $X=2747900 $Y=1256000
X108 159 164 80 152 486 NAND2XL $T=2811600 1260000 1 180 $X=2787500 $Y=1256000
X109 159 164 80 153 495 NAND2XL $T=2838000 1260000 1 180 $X=2813900 $Y=1256000
X110 159 164 80 318 562 NAND2XL $T=2844600 1260000 0 0 $X=2840300 $Y=1256000
X111 316 164 80 344 499 NAND2XL $T=2877600 1260000 0 180 $X=2853500 $Y=1204200
X112 319 164 80 14 374 NAND2XL $T=2904000 1260000 1 180 $X=2879900 $Y=1256000
X113 159 164 80 254 251 NAND2XL $T=2904000 1461600 1 0 $X=2899700 $Y=1405800
X114 259 164 80 335 509 NAND2XL $T=3148200 1360800 1 180 $X=3124100 $Y=1356800
X115 258 164 80 506 327 NAND2XL $T=3148200 1461600 0 180 $X=3124100 $Y=1405800
X116 509 164 80 572 575 NAND2XL $T=3194400 1360800 0 0 $X=3190100 $Y=1356800
X117 174 164 80 258 510 NAND2XL $T=3201000 1461600 1 0 $X=3196700 $Y=1405800
X118 510 164 80 179 514 NAND2XL $T=3293400 1461600 1 0 $X=3289100 $Y=1405800
X119 234 164 80 332 331 NAND2XL $T=3438600 1461600 1 0 $X=3434300 $Y=1405800
X120 17 209 597 18 598 35 164 599 80 DFFSXL $T=178200 1461600 1 0 $X=173900 $Y=1405800
X121 17 21 600 18 601 378 164 602 80 DFFSXL $T=191400 1360800 0 0 $X=187100 $Y=1356800
X122 17 210 603 18 604 379 164 605 80 DFFSXL $T=244200 1260000 0 0 $X=239900 $Y=1256000
X123 17 272 606 18 607 526 164 608 80 DFFSXL $T=270600 1260000 1 0 $X=266300 $Y=1204200
X124 19 210 609 18 610 380 164 611 80 DFFSXL $T=323400 1360800 0 0 $X=319100 $Y=1356800
X125 17 37 612 18 613 381 164 614 80 DFFSXL $T=336600 1159200 0 0 $X=332300 $Y=1155200
X126 19 37 615 18 616 382 164 617 80 DFFSXL $T=376200 1260000 0 0 $X=371900 $Y=1256000
X127 3 209 618 18 619 274 164 620 80 DFFSXL $T=448800 1461600 1 0 $X=444500 $Y=1405800
X128 3 21 621 18 622 275 164 623 80 DFFSXL $T=455400 1360800 0 0 $X=451100 $Y=1356800
X129 19 212 624 18 625 27 164 626 80 DFFSXL $T=468600 1159200 1 0 $X=464300 $Y=1103400
X130 17 61 627 18 628 383 164 629 80 DFFSXL $T=468600 1159200 0 0 $X=464300 $Y=1155200
X131 19 61 630 18 631 384 164 632 80 DFFSXL $T=475200 1260000 1 0 $X=470900 $Y=1204200
X132 25 37 633 18 634 527 164 635 80 DFFSXL $T=567600 1058400 1 0 $X=563300 $Y=1002600
X133 3 30 636 18 637 215 164 638 80 DFFSXL $T=580800 1360800 0 0 $X=576500 $Y=1356800
X134 19 21 639 18 640 388 164 641 80 DFFSXL $T=600600 1058400 0 0 $X=596300 $Y=1054400
X135 5 21 21 18 642 338 164 643 80 DFFSXL $T=607200 1260000 1 0 $X=602900 $Y=1204200
X136 5 214 644 18 645 390 164 646 80 DFFSXL $T=673200 1360800 1 0 $X=668900 $Y=1305000
X137 3 214 647 18 648 530 164 649 80 DFFSXL $T=706200 1360800 0 0 $X=701900 $Y=1356800
X138 17 214 650 52 651 391 164 652 80 DFFSXL $T=712800 1159200 1 0 $X=708500 $Y=1103400
X139 25 210 653 52 654 389 164 655 80 DFFSXL $T=726000 1058400 1 0 $X=721700 $Y=1002600
X140 25 214 214 52 656 339 164 657 80 DFFSXL $T=732600 1058400 0 0 $X=728300 $Y=1054400
X141 17 448 448 52 658 659 164 584 80 DFFSXL $T=732600 1260000 1 0 $X=728300 $Y=1204200
X142 25 61 660 52 661 531 164 662 80 DFFSXL $T=811800 1260000 0 0 $X=807500 $Y=1256000
X143 5 61 663 18 664 340 164 665 80 DFFSXL $T=811800 1360800 1 0 $X=807500 $Y=1305000
X144 36 38 666 52 667 533 164 668 80 DFFSXL $T=844800 957600 0 0 $X=840500 $Y=953600
X145 19 40 669 52 670 393 164 671 80 DFFSXL $T=864600 1058400 0 0 $X=860300 $Y=1054400
X146 17 38 672 52 673 534 164 674 80 DFFSXL $T=864600 1159200 0 0 $X=860300 $Y=1155200
X147 5 37 675 18 676 396 164 677 80 DFFSXL $T=871200 1461600 1 0 $X=866900 $Y=1405800
X148 43 21 678 52 679 219 164 680 80 DFFSXL $T=943800 1360800 1 0 $X=939500 $Y=1305000
X149 43 61 681 52 682 397 164 683 80 DFFSXL $T=970200 1260000 0 0 $X=965900 $Y=1256000
X150 36 214 684 52 685 535 164 686 80 DFFSXL $T=976800 957600 0 0 $X=972500 $Y=953600
X151 19 214 687 52 688 398 164 689 80 DFFSXL $T=990000 1159200 1 0 $X=985700 $Y=1103400
X152 17 220 690 52 691 399 164 692 80 DFFSXL $T=996600 1260000 1 0 $X=992300 $Y=1204200
X153 43 37 693 52 694 536 164 695 80 DFFSXL $T=1003200 1360800 0 0 $X=998900 $Y=1356800
X154 43 214 696 52 697 585 164 698 80 DFFSXL $T=1075800 1360800 1 0 $X=1071500 $Y=1305000
X155 36 61 699 52 700 402 164 701 80 DFFSXL $T=1095600 1058400 0 0 $X=1091300 $Y=1054400
X156 36 220 702 52 703 403 164 704 80 DFFSXL $T=1102200 957600 0 0 $X=1097900 $Y=953600
X157 25 220 705 52 706 405 164 707 80 DFFSXL $T=1102200 1260000 0 0 $X=1097900 $Y=1256000
X158 19 220 708 52 709 341 164 710 80 DFFSXL $T=1128600 1159200 1 0 $X=1124300 $Y=1103400
X159 3 61 711 80 712 407 164 713 80 DFFSXL $T=1174800 1360800 0 0 $X=1170500 $Y=1356800
X160 19 404 714 52 715 716 164 401 80 DFFSXL $T=1207800 1159200 0 0 $X=1203500 $Y=1155200
X161 55 37 717 52 718 284 164 719 80 DFFSXL $T=1240800 1461600 1 0 $X=1236500 $Y=1405800
X162 55 214 720 52 721 540 164 722 80 DFFSXL $T=1287000 1260000 0 0 $X=1282700 $Y=1256000
X163 55 61 723 52 724 416 164 725 80 DFFSXL $T=1300200 1360800 0 0 $X=1295900 $Y=1356800
X164 60 285 285 52 726 286 164 287 80 DFFSXL $T=1359600 957600 0 0 $X=1355300 $Y=953600
X165 221 61 727 80 728 288 164 729 80 DFFSXL $T=1392600 1461600 1 0 $X=1388300 $Y=1405800
X166 60 223 730 80 731 72 164 732 80 DFFSXL $T=1465200 1058400 0 0 $X=1460900 $Y=1054400
X167 221 214 733 80 734 428 164 735 80 DFFSXL $T=1478400 1360800 0 0 $X=1474100 $Y=1356800
X168 79 220 220 80 736 431 164 737 80 DFFSXL $T=1610400 1260000 0 0 $X=1606100 $Y=1256000
X169 79 37 738 80 739 294 164 740 80 DFFSXL $T=1617000 1360800 1 0 $X=1612700 $Y=1305000
X170 60 226 741 80 742 227 164 743 80 DFFSXL $T=1643400 1058400 1 0 $X=1639100 $Y=1002600
X171 347 551 744 80 745 445 164 451 80 DFFSXL $T=1808400 957600 0 0 $X=1804100 $Y=953600
X172 296 297 746 299 747 556 164 748 80 DFFSXL $T=1834800 1461600 1 0 $X=1830500 $Y=1405800
X173 347 230 749 80 750 444 164 228 80 DFFSXL $T=1940400 957600 0 0 $X=1936100 $Y=953600
X174 347 355 751 80 752 450 164 349 80 DFFSXL $T=1960200 1058400 1 0 $X=1955900 $Y=1002600
X175 104 61 753 80 754 452 164 755 80 DFFSXL $T=2026200 1461600 1 0 $X=2021900 $Y=1405800
X176 145 368 756 237 757 372 164 369 80 DFFSXL $T=2699400 1360800 1 0 $X=2695100 $Y=1305000
X177 145 562 758 80 759 564 164 760 80 DFFSXL $T=2831400 1360800 1 0 $X=2827100 $Y=1305000
X178 377 563 761 80 762 567 164 763 80 DFFSXL $T=2930400 1159200 0 0 $X=2926100 $Y=1155200
X179 377 504 764 80 765 573 164 766 80 DFFSXL $T=3055800 1058400 0 0 $X=3051500 $Y=1054400
X180 377 505 767 80 768 570 164 769 80 DFFSXL $T=3055800 1260000 1 0 $X=3051500 $Y=1204200
X181 377 576 770 80 771 512 164 772 80 DFFSXL $T=3214200 1260000 1 0 $X=3209900 $Y=1204200
X182 539 164 46 80 INVX2 $T=1372800 1260000 0 180 $X=1348700 $Y=1204200
X183 411 164 50 80 INVX2 $T=1379400 1058400 0 0 $X=1375100 $Y=1054400
X184 542 164 68 80 INVX2 $T=1551000 1159200 1 180 $X=1526900 $Y=1155200
X185 442 164 93 80 INVX2 $T=1854600 1260000 0 0 $X=1850300 $Y=1256000
X186 443 164 98 80 INVX2 $T=1920600 1360800 0 0 $X=1916300 $Y=1356800
X187 225 69 80 420 773 164 543 AOI21XL $T=1551000 1260000 1 180 $X=1520300 $Y=1256000
X188 496 133 80 13 774 164 491 AOI21XL $T=2739000 1159200 1 180 $X=2708300 $Y=1155200
X189 324 257 80 323 775 164 500 AOI21XL $T=3082200 1461600 0 180 $X=3051500 $Y=1405800
X190 575 170 80 577 776 164 176 AOI21XL $T=3214200 1360800 0 0 $X=3209900 $Y=1356800
X191 487 164 139 777 80 367 NAND2BXL $T=2640000 1260000 1 0 $X=2635700 $Y=1204200
X192 256 164 322 778 80 566 NAND2BXL $T=3022800 1360800 1 180 $X=2992100 $Y=1356800
X193 80 350 349 432 164 NOR2XL $T=1755600 1058400 1 180 $X=1731500 $Y=1054400
X194 80 445 444 346 164 NOR2XL $T=1867800 1058400 1 180 $X=1843700 $Y=1054400
X195 80 456 450 446 164 NOR2XL $T=1920600 1159200 1 0 $X=1916300 $Y=1103400
X196 80 354 446 229 164 NOR2XL $T=1927200 1058400 1 0 $X=1922900 $Y=1002600
X197 80 229 232 303 164 NOR2XL $T=2098800 957600 1 180 $X=2074700 $Y=953600
X198 80 240 470 128 164 NOR2XL $T=2448600 957600 1 180 $X=2424500 $Y=953600
X199 80 360 558 465 164 NOR2XL $T=2494800 1260000 0 0 $X=2490500 $Y=1256000
X200 80 131 239 242 164 NOR2XL $T=2508000 957600 0 0 $X=2503700 $Y=953600
X201 80 13 139 488 164 NOR2XL $T=2600400 1159200 0 0 $X=2596100 $Y=1155200
X202 80 246 470 243 164 NOR2XL $T=2666400 957600 1 180 $X=2642300 $Y=953600
X203 80 559 13 134 164 NOR2XL $T=2673000 1159200 1 180 $X=2648900 $Y=1155200
X204 80 474 367 250 164 NOR2XL $T=2712600 1260000 0 0 $X=2708300 $Y=1256000
X205 80 259 335 569 164 NOR2XL $T=3154800 1360800 0 0 $X=3150500 $Y=1356800
X206 80 575 170 577 164 NOR2XL $T=3220800 1360800 1 0 $X=3216500 $Y=1305000
X207 41 531 532 164 779 395 80 OAI2BB1XL $T=924000 1260000 1 0 $X=919700 $Y=1204200
X208 7 536 400 164 780 218 80 OAI2BB1XL $T=1128600 1461600 1 0 $X=1124300 $Y=1405800
X209 222 540 406 164 781 413 80 OAI2BB1XL $T=1432200 1360800 0 180 $X=1394900 $Y=1305000
X210 28 398 419 164 782 420 80 OAI2BB1XL $T=1425600 1260000 1 0 $X=1421300 $Y=1204200
X211 514 330 164 80 332 XNOR2XL $T=3326400 1461600 1 0 $X=3322100 $Y=1405800
X212 366 140 164 142 80 136 OAI21X1 $T=2659800 1058400 0 180 $X=2622500 $Y=1002600
X213 566 500 164 80 321 XOR2X1 $T=2983200 1360800 1 180 $X=2926100 $Y=1356800
X214 438 80 354 552 164 NOR2BX1 $T=1848000 1159200 1 180 $X=1817300 $Y=1155200
X215 440 353 164 80 409 OR2XL $T=1359600 1159200 1 180 $X=1328900 $Y=1155200
X216 412 348 164 80 410 OR2XL $T=1399200 1058400 0 180 $X=1368500 $Y=1002600
X217 417 348 164 80 414 OR2XL $T=1425600 1058400 1 180 $X=1394900 $Y=1054400
X218 417 415 164 80 411 OR2XL $T=1425600 1159200 0 180 $X=1394900 $Y=1103400
X219 440 415 164 80 539 OR2XL $T=1425600 1159200 1 180 $X=1394900 $Y=1155200
X220 343 415 164 80 418 OR2XL $T=1452000 1159200 1 180 $X=1421300 $Y=1155200
X221 412 352 164 80 410 OR2XL $T=1518000 1159200 0 180 $X=1487300 $Y=1103400
X222 417 352 164 80 542 OR2XL $T=1557600 1159200 0 180 $X=1526900 $Y=1103400
X223 438 350 164 80 546 OR2XL $T=1782000 1159200 0 180 $X=1751300 $Y=1103400
X224 440 348 164 80 442 OR2XL $T=1808400 1260000 0 0 $X=1804100 $Y=1256000
X225 440 352 164 80 443 OR2XL $T=1841400 1260000 1 0 $X=1837100 $Y=1204200
X226 353 354 164 80 555 OR2XL $T=1907400 1260000 0 0 $X=1903100 $Y=1256000
X227 479 477 164 80 362 OR2XL $T=2481600 1159200 1 180 $X=2450900 $Y=1155200
X228 361 360 164 80 475 OR2XL $T=2494800 1260000 1 180 $X=2464100 $Y=1256000
X229 506 258 164 80 326 OR2XL $T=3088800 1461600 1 0 $X=3084500 $Y=1405800
X230 53 281 783 52 283 164 784 80 DFFSX1 $T=1227600 957600 0 0 $X=1223300 $Y=953600
X231 60 289 785 80 74 164 81 80 DFFSX1 $T=1518000 1058400 1 0 $X=1513700 $Y=1002600
X232 347 550 786 80 350 164 354 80 DFFSX1 $T=1768800 1058400 1 0 $X=1764500 $Y=1002600
X233 347 449 449 80 456 164 433 80 DFFSX1 $T=1980000 1159200 1 0 $X=1975700 $Y=1103400
X234 78 235 787 80 127 164 470 80 DFFSX1 $T=2204400 1058400 1 0 $X=2200100 $Y=1002600
X235 78 236 788 80 239 164 310 80 DFFSX1 $T=2290200 957600 0 0 $X=2285900 $Y=953600
X236 12 13 789 237 468 164 790 80 DFFSX1 $T=2395800 1360800 0 0 $X=2391500 $Y=1356800
X237 12 565 791 80 502 164 792 80 DFFSX1 $T=2970000 1360800 1 0 $X=2965700 $Y=1305000
X238 78 261 793 80 375 164 794 80 DFFSX1 $T=3293400 1058400 1 0 $X=3289100 $Y=1002600
X239 377 501 795 188 516 164 796 80 DFFSX1 $T=3306600 1159200 0 0 $X=3302300 $Y=1155200
X240 185 515 797 188 186 164 798 80 DFFSX1 $T=3333000 1360800 1 0 $X=3328700 $Y=1305000
X241 185 520 799 188 189 164 800 80 DFFSX1 $T=3491400 1360800 1 180 $X=3361700 $Y=1356800
X242 377 513 801 188 580 164 802 80 DFFSX1 $T=3471600 1360800 1 0 $X=3467300 $Y=1305000
X243 185 525 803 188 197 164 804 80 DFFSX1 $T=3755400 1461600 1 0 $X=3751100 $Y=1405800
X244 381 80 50 28 382 385 164 AOI22XL $T=554400 1260000 0 0 $X=550100 $Y=1256000
X245 383 80 50 28 384 386 164 AOI22XL $T=594000 1260000 0 0 $X=589700 $Y=1256000
X246 527 80 41 29 213 387 164 AOI22XL $T=653400 1159200 0 180 $X=616100 $Y=1103400
X247 378 80 50 42 338 528 164 AOI22XL $T=653400 1461600 1 0 $X=649100 $Y=1405800
X248 276 80 41 28 388 529 164 AOI22XL $T=660000 1159200 0 0 $X=655700 $Y=1155200
X249 390 80 42 8 530 392 164 AOI22XL $T=805200 1461600 1 0 $X=800900 $Y=1405800
X250 584 80 34 28 393 32 164 AOI22XL $T=871200 1260000 1 0 $X=866900 $Y=1204200
X251 39 80 46 42 340 532 164 AOI22XL $T=904200 1360800 0 0 $X=899900 $Y=1356800
X252 279 80 41 216 533 394 164 AOI22XL $T=924000 1058400 1 0 $X=919700 $Y=1002600
X253 396 80 42 46 48 400 164 AOI22XL $T=1056000 1461600 1 0 $X=1051700 $Y=1405800
X254 534 80 34 28 401 537 164 AOI22XL $T=1135200 1159200 0 0 $X=1130900 $Y=1155200
X255 341 80 28 50 399 280 164 AOI22XL $T=1201200 1260000 0 180 $X=1163900 $Y=1204200
X256 397 80 7 29 402 538 164 AOI22XL $T=1214400 1260000 1 0 $X=1210100 $Y=1204200
X257 585 80 7 46 54 406 164 AOI22XL $T=1221000 1360800 1 0 $X=1216700 $Y=1305000
X258 403 80 29 41 405 56 164 AOI22XL $T=1247400 1058400 0 0 $X=1243100 $Y=1054400
X259 62 80 7 222 64 423 164 AOI22XL $T=1438800 1058400 1 0 $X=1434500 $Y=1002600
X260 416 80 222 8 407 541 164 AOI22XL $T=1445400 1360800 1 0 $X=1441100 $Y=1305000
X261 66 80 68 50 391 419 164 AOI22XL $T=1498200 1260000 0 180 $X=1460900 $Y=1204200
X262 428 80 88 83 59 425 164 AOI22XL $T=1564200 1461600 0 180 $X=1526900 $Y=1405800
X263 75 80 46 8 76 544 164 AOI22XL $T=1570800 1159200 1 0 $X=1566500 $Y=1103400
X264 292 80 69 28 86 435 164 AOI22XL $T=1702800 1058400 0 0 $X=1698500 $Y=1054400
X265 85 80 29 50 293 548 164 AOI22XL $T=1709400 957600 0 0 $X=1705100 $Y=953600
X266 452 80 98 93 300 586 164 AOI22XL $T=1993200 1360800 1 180 $X=1955900 $Y=1356800
X267 231 80 98 93 556 356 164 AOI22XL $T=1999800 1461600 0 180 $X=1962500 $Y=1405800
X268 488 80 369 139 134 560 164 AOI22XL $T=2640000 1159200 1 0 $X=2635700 $Y=1103400
X269 488 80 249 139 371 370 164 AOI22XL $T=2679600 1159200 1 0 $X=2675300 $Y=1103400
X270 502 80 373 498 344 565 164 AOI22XL $T=3036000 1260000 1 180 $X=2998700 $Y=1256000
X271 216 33 80 389 41 34 379 217 164 AOI222XL $T=739200 1461600 1 0 $X=734900 $Y=1405800
X272 41 339 80 174 107 107 234 557 164 AOI222XL $T=2092200 1360800 0 0 $X=2087900 $Y=1356800
X273 453 9 164 80 CLKBUFX3 $T=2039400 1260000 0 180 $X=2008700 $Y=1204200
X274 457 2 164 80 CLKBUFX3 $T=2112000 1159200 1 180 $X=2081300 $Y=1155200
X275 460 4 164 80 CLKBUFX3 $T=2158200 1058400 1 180 $X=2127500 $Y=1054400
X276 459 6 164 80 CLKBUFX3 $T=2158200 1360800 0 180 $X=2127500 $Y=1305000
X277 125 101 164 80 CLKBUFX3 $T=2356200 1058400 1 180 $X=2325500 $Y=1054400
X278 564 498 164 80 CLKBUFX3 $T=2950200 1260000 0 0 $X=2945900 $Y=1256000
X279 357 164 80 102 BUFXL $T=2230800 1260000 1 0 $X=2226500 $Y=1204200
X280 545 164 80 47 BUFX1 $T=1689600 1159200 0 0 $X=1685300 $Y=1155200
X281 553 164 80 24 BUFX1 $T=1841400 1360800 0 0 $X=1837100 $Y=1356800
X282 454 164 80 106 BUFX1 $T=2065800 1360800 0 180 $X=2035100 $Y=1305000
X283 455 164 80 109 BUFX1 $T=2079000 1260000 0 180 $X=2048300 $Y=1204200
X284 465 164 80 167 BUFX1 $T=2461800 1360800 1 0 $X=2457500 $Y=1305000
X285 372 164 80 247 BUFX1 $T=2732400 1461600 0 180 $X=2701700 $Y=1405800
X286 78 164 80 12 BUFX1 $T=2956800 1159200 1 0 $X=2952500 $Y=1103400
X287 541 164 67 224 421 345 80 NAND4XL $T=1491600 1360800 1 0 $X=1487300 $Y=1305000
X288 103 164 356 342 434 557 80 NAND4XL $T=1986600 1360800 0 180 $X=1949300 $Y=1305000
X289 374 164 245 481 129 244 80 NAND4XL $T=2580600 1058400 0 180 $X=2543300 $Y=1002600
X290 477 164 248 144 492 560 80 NAND4XL $T=2725800 1058400 1 180 $X=2688500 $Y=1054400
X291 526 50 80 29 273 211 164 AOI22X1 $T=376200 1461600 0 180 $X=338900 $Y=1405800
X292 31 80 80 164 CLKINVX4 $T=2349600 1058400 1 0 $X=2345300 $Y=1002600
X293 31 188 80 164 CLKINVX4 $T=3418800 957600 0 0 $X=3414500 $Y=953600
X294 410 216 164 80 INVX4 $T=1293600 1058400 0 180 $X=1262900 $Y=1002600
X295 411 34 164 80 INVX4 $T=1359600 1159200 0 180 $X=1328900 $Y=1103400
X296 539 282 164 80 INVX4 $T=1372800 1360800 0 180 $X=1342100 $Y=1305000
X297 424 42 164 80 INVX4 $T=1531200 1159200 1 180 $X=1500500 $Y=1155200
X298 542 73 164 80 INVX4 $T=1537800 1260000 0 180 $X=1507100 $Y=1204200
X299 92 232 164 80 INVX4 $T=2105400 1058400 1 0 $X=2101100 $Y=1002600
X300 308 38 164 80 INVX4 $T=2303400 1461600 1 0 $X=2299100 $Y=1405800
X301 359 313 164 80 INVX4 $T=2514600 1461600 1 0 $X=2510300 $Y=1405800
X302 366 159 164 80 INVX4 $T=2666400 1461600 1 0 $X=2662100 $Y=1405800
X303 317 164 164 80 INVX4 $T=2943600 1058400 0 0 $X=2939300 $Y=1054400
X304 31 164 52 80 CLKINVX8 $T=1273800 1159200 1 0 $X=1269500 $Y=1103400
X305 409 164 7 80 CLKINVX8 $T=1359600 1159200 0 0 $X=1355300 $Y=1155200
X306 410 164 41 80 CLKINVX8 $T=1399200 1058400 1 0 $X=1394900 $Y=1002600
X307 414 164 28 80 CLKINVX8 $T=1425600 1058400 0 0 $X=1421300 $Y=1054400
X308 418 164 8 80 CLKINVX8 $T=1452000 1159200 0 0 $X=1447700 $Y=1155200
X309 547 164 88 80 CLKINVX8 $T=1768800 1260000 0 180 $X=1724900 $Y=1204200
X310 546 164 88 80 CLKINVX8 $T=1755600 1058400 0 0 $X=1751300 $Y=1054400
X311 31 164 237 80 CLKINVX8 $T=2336400 1360800 0 0 $X=2332100 $Y=1356800
X312 589 164 130 80 CLKINVX8 $T=2877600 957600 0 0 $X=2873300 $Y=953600
X313 468 80 164 122 CLKBUFX2 $T=2290200 1461600 0 180 $X=2259500 $Y=1405800
X314 255 80 164 15 CLKBUFX2 $T=2943600 957600 1 180 $X=2912900 $Y=953600
X315 567 80 164 191 CLKBUFX2 $T=3042600 1260000 0 180 $X=3011900 $Y=1204200
X316 325 80 164 16 CLKBUFX2 $T=3121800 957600 1 180 $X=3091100 $Y=953600
X317 375 80 164 168 CLKBUFX2 $T=3154800 1360800 0 180 $X=3124100 $Y=1305000
X318 573 80 164 178 CLKBUFX2 $T=3220800 1058400 0 0 $X=3216500 $Y=1054400
X319 182 80 164 169 CLKBUFX2 $T=3280200 1360800 0 180 $X=3249500 $Y=1305000
X320 183 80 164 180 CLKBUFX2 $T=3306600 1360800 1 180 $X=3275900 $Y=1356800
X321 516 80 164 196 CLKBUFX2 $T=3372600 1260000 0 180 $X=3341900 $Y=1204200
X322 353 164 348 80 92 551 NAND3XL $T=1808400 1058400 0 0 $X=1804100 $Y=1054400
X323 456 164 354 80 349 440 NAND3XL $T=1834800 1260000 0 180 $X=1804100 $Y=1204200
X324 302 164 301 80 586 422 NAND3XL $T=1999800 1360800 0 0 $X=1995500 $Y=1356800
X325 470 164 240 80 239 476 NAND3XL $T=2442000 1058400 1 0 $X=2437700 $Y=1002600
X326 359 164 366 80 374 132 NAND3XL $T=2508000 1058400 1 0 $X=2503700 $Y=1002600
X327 133 164 364 80 139 558 NAND3XL $T=2574000 1360800 0 180 $X=2543300 $Y=1305000
X328 135 164 133 80 134 473 NAND3XL $T=2587200 1260000 0 180 $X=2556500 $Y=1204200
X329 133 164 134 80 364 361 NAND3XL $T=2593800 1159200 1 180 $X=2563100 $Y=1155200
X330 135 164 133 80 139 479 NAND3XL $T=2593800 1260000 1 0 $X=2589500 $Y=1204200
X331 246 164 470 80 242 248 NAND3XL $T=2706000 957600 1 180 $X=2675300 $Y=953600
X332 249 164 369 80 344 360 NAND3XL $T=2706000 1159200 1 180 $X=2675300 $Y=1155200
X333 248 164 144 80 370 493 NAND3XL $T=2758800 1058400 0 180 $X=2728100 $Y=1002600
X334 481 164 142 80 373 494 NAND3XL $T=2758800 1058400 1 180 $X=2728100 $Y=1054400
X335 157 164 142 80 158 162 NAND3XL $T=2871000 1360800 0 0 $X=2866700 $Y=1356800
X336 380 164 28 80 26 NAND2X1 $T=620400 1461600 1 0 $X=616100 $Y=1405800
X337 451 164 444 80 415 NAND2X1 $T=1986600 1058400 1 180 $X=1962500 $Y=1054400
X338 134 164 134 80 485 NAND2X1 $T=2633400 1159200 0 0 $X=2629100 $Y=1155200
X339 372 164 371 80 474 NAND2X1 $T=2745600 1260000 0 180 $X=2721500 $Y=1204200
X340 369 164 371 80 477 NAND2X1 $T=2752200 1159200 0 180 $X=2728100 $Y=1103400
X341 277 528 529 278 164 80 45 AND4XL $T=693000 1461600 1 0 $X=688700 $Y=1405800
X342 426 392 543 427 164 80 429 AND4XL $T=1537800 1360800 1 0 $X=1533500 $Y=1305000
X343 305 80 233 307 164 NOR2BXL $T=2217600 957600 0 0 $X=2213300 $Y=953600
X344 245 248 164 80 373 AND2X4 $T=2712600 957600 0 0 $X=2708300 $Y=953600
X345 503 185 164 80 377 AND2X4 $T=3339600 1260000 0 0 $X=3335300 $Y=1256000
X346 89 424 164 544 80 423 82 OAI211XL $T=1603800 1058400 0 0 $X=1599500 $Y=1054400
X347 441 456 164 438 80 92 449 OAI211XL $T=1881000 1159200 1 0 $X=1876700 $Y=1103400
X348 554 450 164 351 80 92 355 OAI211XL $T=1940400 1159200 0 0 $X=1936100 $Y=1155200
X349 314 364 164 496 80 344 561 OAI211XL $T=2758800 1260000 1 0 $X=2754500 $Y=1204200
X350 410 80 29 164 CLKINVX3 $T=1372800 1058400 0 180 $X=1348700 $Y=1002600
X351 77 80 69 164 CLKINVX3 $T=1610400 1159200 0 0 $X=1606100 $Y=1155200
X352 442 80 298 164 CLKINVX3 $T=1887600 1360800 1 0 $X=1883300 $Y=1305000
X353 443 80 95 164 CLKINVX3 $T=1907400 1360800 1 180 $X=1883300 $Y=1356800
X354 555 80 97 164 CLKINVX3 $T=1940400 1260000 0 0 $X=1936100 $Y=1256000
X355 111 80 107 164 CLKINVX3 $T=2072400 1260000 0 0 $X=2068100 $Y=1256000
X356 304 80 107 164 CLKINVX3 $T=2079000 1360800 1 0 $X=2074700 $Y=1305000
X357 290 80 78 164 60 AND2X2 $T=1544400 957600 0 0 $X=1540100 $Y=953600
X358 96 80 78 164 347 AND2X2 $T=1881000 1058400 0 0 $X=1876700 $Y=1054400
X359 317 80 254 164 163 AND2X2 $T=2943600 957600 0 0 $X=2939300 $Y=953600
X360 413 80 430 164 434 426 NOR3XL $T=1696200 1360800 0 0 $X=1691900 $Y=1356800
X361 239 80 127 164 311 238 NOR3XL $T=2435400 1058400 0 180 $X=2404700 $Y=1002600
X362 447 164 80 105 INVX3 $T=2019600 1260000 0 0 $X=2015300 $Y=1256000
X363 145 486 806 805 237 483 80 164 133 DFFSX2 $T=2574000 1360800 0 0 $X=2569700 $Y=1356800
X364 145 495 808 807 237 364 80 164 135 DFFSX2 $T=2719200 1360800 0 0 $X=2714900 $Y=1356800
X365 377 492 810 809 80 141 80 164 320 DFFSX2 $T=2778600 1058400 1 0 $X=2774300 $Y=1002600
X366 377 493 812 811 80 140 80 164 10 DFFSX2 $T=2785200 1058400 0 0 $X=2780900 $Y=1054400
X367 377 561 814 813 80 153 80 164 155 DFFSX2 $T=2791800 1159200 0 0 $X=2787500 $Y=1155200
X368 377 497 816 815 80 152 80 164 160 DFFSX2 $T=2805000 1159200 1 0 $X=2800700 $Y=1103400
X369 377 499 818 817 80 254 80 164 11 DFFSX2 $T=2930400 1058400 1 0 $X=2926100 $Y=1002600
X370 377 507 820 819 80 173 80 164 821 DFFSX2 $T=3082200 1058400 1 0 $X=3077900 $Y=1002600
X371 377 571 823 822 80 181 80 164 824 DFFSX2 $T=3168000 1159200 0 0 $X=3163700 $Y=1155200
X372 377 578 826 825 188 203 80 164 827 DFFSX2 $T=3445200 1058400 1 0 $X=3440900 $Y=1002600
X373 377 511 829 828 188 207 80 164 830 DFFSX2 $T=3451800 1159200 1 0 $X=3447500 $Y=1103400
X374 377 519 832 831 188 262 80 164 833 DFFSX2 $T=3458400 1159200 0 0 $X=3454100 $Y=1155200
X375 377 579 835 834 188 263 80 164 836 DFFSX2 $T=3465000 1260000 0 0 $X=3460700 $Y=1256000
X376 377 522 838 837 188 206 80 164 839 DFFSX2 $T=3590400 1058400 1 0 $X=3586100 $Y=1002600
X377 377 581 841 840 188 265 80 164 842 DFFSX2 $T=3597000 1058400 0 0 $X=3592700 $Y=1054400
X378 377 582 844 843 188 264 80 164 845 DFFSX2 $T=3603600 1159200 0 0 $X=3599300 $Y=1155200
X379 377 521 847 846 188 202 80 164 848 DFFSX2 $T=3603600 1461600 1 0 $X=3599300 $Y=1405800
X380 377 377 849 377 188 205 80 164 850 DFFSX2 $T=3768600 1260000 0 180 $X=3625700 $Y=1204200
X381 377 518 518 851 188 204 80 164 852 DFFSX2 $T=3768600 1360800 0 180 $X=3625700 $Y=1305000
X382 377 524 524 853 188 208 80 164 854 DFFSX2 $T=3768600 1360800 1 180 $X=3625700 $Y=1356800
X383 408 395 422 164 421 80 335 OR4X2 $T=1432200 1260000 0 0 $X=1427900 $Y=1256000
X384 80 360 473 480 164 NOR2X1 $T=2508000 1159200 1 0 $X=2503700 $Y=1103400
X385 80 360 479 358 164 NOR2X1 $T=2527800 1159200 1 180 $X=2503700 $Y=1155200
X386 80 479 482 517 164 NOR2X1 $T=2554200 1159200 1 180 $X=2530100 $Y=1155200
X387 80 558 482 363 164 NOR2X1 $T=2547600 1159200 1 0 $X=2543300 $Y=1103400
X388 80 482 367 151 164 NOR2X1 $T=2620200 1159200 0 180 $X=2596100 $Y=1103400
X389 80 485 487 472 164 NOR2X1 $T=2673000 1260000 0 0 $X=2668700 $Y=1256000
X390 78 855 337 856 44 164 80 TLATNXL $T=1544400 1260000 1 0 $X=1540100 $Y=1204200
X391 78 857 344 858 71 164 80 TLATNXL $T=1617000 1159200 1 0 $X=1612700 $Y=1103400
X392 78 859 344 860 545 164 80 TLATNXL $T=1617000 1260000 1 0 $X=1612700 $Y=1204200
X393 78 861 436 862 84 164 80 TLATNXL $T=1709400 1461600 1 0 $X=1705100 $Y=1405800
X394 78 863 437 864 553 164 80 TLATNXL $T=1755600 1360800 0 0 $X=1751300 $Y=1356800
X395 78 865 439 866 87 164 80 TLATNXL $T=1768800 1360800 1 0 $X=1764500 $Y=1305000
X396 78 867 458 868 455 164 80 TLATNXL $T=2085600 1260000 1 0 $X=2081300 $Y=1204200
X397 78 869 463 870 460 164 80 TLATNXL $T=2158200 1058400 0 0 $X=2153900 $Y=1054400
X398 78 871 462 872 100 164 80 TLATNXL $T=2158200 1260000 1 0 $X=2153900 $Y=1204200
X399 78 873 464 874 120 164 80 TLATNXL $T=2158200 1260000 0 0 $X=2153900 $Y=1256000
X400 78 875 465 876 306 164 80 TLATNXL $T=2158200 1360800 1 0 $X=2153900 $Y=1305000
X401 78 877 336 878 357 164 80 TLATNXL $T=2164800 1159200 0 0 $X=2160500 $Y=1155200
X402 78 879 466 880 108 164 80 TLATNXL $T=2164800 1360800 0 0 $X=2160500 $Y=1356800
X403 78 881 461 882 471 164 80 TLATNXL $T=2230800 1058400 0 0 $X=2226500 $Y=1054400
X404 78 883 467 884 112 164 80 TLATNXL $T=2237400 1159200 0 0 $X=2233100 $Y=1155200
X405 78 885 358 886 454 164 80 TLATNXL $T=2237400 1260000 0 0 $X=2233100 $Y=1256000
X406 78 887 376 888 121 164 80 TLATNXL $T=2244000 1360800 0 0 $X=2239700 $Y=1356800
X407 78 889 480 890 457 164 80 TLATNXL $T=2270400 1159200 1 0 $X=2266100 $Y=1103400
X408 78 891 517 892 459 164 80 TLATNXL $T=2303400 1260000 1 0 $X=2299100 $Y=1204200
X409 78 893 151 894 115 164 80 TLATNXL $T=2389200 1159200 1 180 $X=2312300 $Y=1155200
X410 78 895 472 896 124 164 80 TLATNXL $T=2389200 1360800 0 180 $X=2312300 $Y=1305000
X411 78 897 363 898 453 164 80 TLATNXL $T=2389200 1159200 1 0 $X=2384900 $Y=1103400
X412 12 899 478 900 312 164 80 TLATNXL $T=2494800 1461600 0 180 $X=2417900 $Y=1405800
X413 12 12 12 12 138 164 80 TLATNXL $T=2646600 1461600 0 180 $X=2569700 $Y=1405800
X414 78 901 494 902 503 164 80 TLATNXL $T=2989800 1159200 1 0 $X=2985500 $Y=1103400
X415 78 903 469 904 195 164 80 TLATNXL $T=3003000 957600 0 0 $X=2998700 $Y=953600
X416 243 241 142 164 80 NAND2X2 $T=2541000 957600 0 0 $X=2536700 $Y=953600
X417 502 80 164 171 BUFX2 $T=3082200 1360800 0 0 $X=3077900 $Y=1356800
X418 328 80 164 161 BUFX2 $T=3174600 957600 1 180 $X=3143900 $Y=953600
X419 570 80 164 172 BUFX2 $T=3187800 1260000 0 0 $X=3183500 $Y=1256000
X420 252 80 164 192 BUFX2 $T=3253800 957600 0 0 $X=3249500 $Y=953600
X421 512 80 164 184 BUFX2 $T=3313200 1260000 1 180 $X=3282500 $Y=1256000
X422 334 80 164 190 BUFX2 $T=3498000 957600 1 180 $X=3467300 $Y=953600
X423 580 80 164 194 BUFX2 $T=3590400 1360800 1 180 $X=3559700 $Y=1356800
X424 498 315 164 151 80 905 252 373 150 OAI221XL $T=2805000 957600 1 180 $X=2754500 $Y=953600
X425 498 358 164 358 80 906 191 373 563 OAI221XL $T=2897400 1260000 1 0 $X=2893100 $Y=1204200
X426 498 362 164 458 80 907 196 373 501 OAI221XL $T=2956800 1260000 1 0 $X=2952500 $Y=1204200
X427 498 590 164 464 80 908 178 373 504 OAI221XL $T=3082200 1159200 0 0 $X=3077900 $Y=1155200
X428 498 591 164 250 80 909 172 373 505 OAI221XL $T=3095400 1260000 0 0 $X=3091100 $Y=1256000
X429 498 568 164 337 80 910 181 373 571 OAI221XL $T=3154800 1360800 1 0 $X=3150500 $Y=1305000
X430 498 592 164 439 80 911 173 373 507 OAI221XL $T=3181200 1159200 1 0 $X=3176900 $Y=1103400
X431 498 574 164 472 80 184 184 373 576 OAI221XL $T=3227400 1260000 0 0 $X=3223100 $Y=1256000
X432 498 490 164 480 80 912 207 373 511 OAI221XL $T=3247200 1159200 1 0 $X=3242900 $Y=1103400
X433 498 489 164 376 80 913 194 373 513 OAI221XL $T=3280200 1360800 1 0 $X=3275900 $Y=1305000
X434 498 508 164 363 80 914 206 373 522 OAI221XL $T=3300000 1058400 0 0 $X=3295700 $Y=1054400
X435 498 593 164 467 80 915 262 373 519 OAI221XL $T=3359400 1159200 1 0 $X=3355100 $Y=1103400
X436 498 475 164 436 80 916 204 373 518 OAI221XL $T=3385800 1260000 0 0 $X=3381500 $Y=1256000
X437 498 594 164 336 80 917 203 373 578 OAI221XL $T=3405600 1058400 0 0 $X=3401300 $Y=1054400
X438 498 595 164 517 80 918 263 373 579 OAI221XL $T=3432000 1260000 1 0 $X=3427700 $Y=1204200
X439 498 333 164 167 80 919 202 373 521 OAI221XL $T=3471600 1461600 1 0 $X=3467300 $Y=1405800
X440 498 484 164 466 80 920 208 373 524 OAI221XL $T=3524400 1461600 1 0 $X=3520100 $Y=1405800
X441 498 365 164 523 80 921 264 373 582 OAI221XL $T=3557400 1260000 1 0 $X=3553100 $Y=1204200
X442 498 583 164 463 80 922 265 373 581 OAI221XL $T=3788400 1159200 0 180 $X=3737900 $Y=1103400
X443 498 596 164 462 80 923 205 373 377 OAI221XL $T=3821400 1260000 0 180 $X=3770900 $Y=1204200
X444 317 11 80 164 589 AND2X1 $T=2851200 957600 0 0 $X=2846900 $Y=953600
X445 351 456 350 80 164 424 OR3XL $T=1749000 1159200 0 180 $X=1711700 $Y=1103400
X446 483 135 485 80 164 365 OR3XL $T=2593800 1260000 0 0 $X=2589500 $Y=1256000
X447 139 487 474 80 164 489 OR3XL $T=2633400 1360800 1 0 $X=2629100 $Y=1305000
X448 473 477 164 80 467 NOR2X2 $T=2442000 1159200 1 180 $X=2404700 $Y=1155200
X449 311 476 164 80 344 NOR2X2 $T=2448600 1058400 1 180 $X=2411300 $Y=1054400
X450 474 473 164 80 439 NOR2X2 $T=2448600 1260000 0 180 $X=2411300 $Y=1204200
X451 474 361 164 80 462 NOR2X2 $T=2468400 1260000 1 180 $X=2431100 $Y=1256000
X452 474 479 164 80 464 NOR2X2 $T=2488200 1260000 0 180 $X=2450900 $Y=1204200
X453 474 558 164 80 466 NOR2X2 $T=2514600 1360800 1 0 $X=2510300 $Y=1305000
X454 477 558 164 80 463 NOR2X2 $T=2554200 1058400 1 180 $X=2516900 $Y=1054400
X455 343 353 164 80 58 OR2X1 $T=1392600 1159200 0 180 $X=1361900 $Y=1103400
X456 343 352 164 80 77 OR2X1 $T=1570800 1159200 0 0 $X=1566500 $Y=1155200
X457 352 354 164 80 111 OR2X1 $T=1881000 1260000 1 0 $X=1876700 $Y=1204200
X458 415 354 164 80 304 OR2X1 $T=1933800 1260000 1 0 $X=1929500 $Y=1204200
X459 476 131 164 80 366 OR2X1 $T=2475000 1058400 0 0 $X=2470700 $Y=1054400
X460 415 80 164 412 65 NOR2X4 $T=1432200 1159200 1 0 $X=1427900 $Y=1103400
X461 361 80 164 477 336 NOR2X4 $T=2508000 1159200 0 180 $X=2457500 $Y=1103400
X462 31 164 80 80 CLKINVX2 $T=1630200 957600 0 0 $X=1625900 $Y=953600
X463 555 164 94 80 CLKINVX2 $T=1940400 1360800 0 180 $X=1916300 $Y=1305000
X464 447 164 99 80 CLKINVX2 $T=2006400 1159200 0 0 $X=2002100 $Y=1155200
.ENDS
***************************************
.SUBCKT MXI2XL S0 B 3 Y A VSS VDD
** N=9 EP=7 IP=0 FDC=10
M0 VSS S0 3 VSS n18 L=1.8e-07 W=3e-07 $X=7600 $Y=12600 $D=6
M1 8 B VSS VSS n18 L=1.8e-07 W=3e-07 $X=15800 $Y=12600 $D=6
M2 Y S0 8 VSS n18 L=1.8e-07 W=5.6e-07 $X=23600 $Y=10000 $D=6
M3 9 3 Y VSS n18 L=1.8e-07 W=5.6e-07 $X=31200 $Y=10000 $D=6
M4 VSS A 9 VSS n18 L=1.8e-07 W=4.2e-07 $X=39400 $Y=11400 $D=6
M5 VDD S0 3 VDD p18 L=1.8e-07 W=4.2e-07 $X=6600 $Y=32300 $D=10
M6 8 B VDD VDD p18 L=1.8e-07 W=4.2e-07 $X=15600 $Y=32300 $D=10
M7 Y 3 8 VDD p18 L=1.8e-07 W=8.4e-07 $X=23400 $Y=28100 $D=10
M8 9 S0 Y VDD p18 L=1.8e-07 W=8.4e-07 $X=31400 $Y=28100 $D=10
M9 VDD A 9 VDD p18 L=1.8e-07 W=6.4e-07 $X=39400 $Y=30100 $D=10
.ENDS
***************************************
.SUBCKT AOI2BB2XL A1N A0N B1 VDD B0 Y VSS
** N=11 EP=7 IP=0 FDC=10
M0 9 A1N VSS VSS n18 L=1.8e-07 W=3e-07 $X=6600 $Y=10150 $D=6
M1 VSS A0N 9 VSS n18 L=1.8e-07 W=3e-07 $X=14600 $Y=10150 $D=6
M2 10 B1 VSS VSS n18 L=1.8e-07 W=5.6e-07 $X=20600 $Y=10400 $D=6
M3 Y B0 10 VSS n18 L=1.8e-07 W=5.6e-07 $X=27200 $Y=10400 $D=6
M4 VSS 9 Y VSS n18 L=1.8e-07 W=4.2e-07 $X=36400 $Y=11800 $D=6
M5 11 A1N VDD VDD p18 L=1.8e-07 W=5.6e-07 $X=4600 $Y=34600 $D=10
M6 9 A0N 11 VDD p18 L=1.8e-07 W=5.6e-07 $X=10200 $Y=34600 $D=10
M7 VDD B1 8 VDD p18 L=1.8e-07 W=8.4e-07 $X=23200 $Y=31750 $D=10
M8 8 B0 VDD VDD p18 L=1.8e-07 W=8.4e-07 $X=29200 $Y=31750 $D=10
M9 Y 9 8 VDD p18 L=1.8e-07 W=8.4e-07 $X=36400 $Y=31750 $D=10
.ENDS
***************************************
.SUBCKT OAI22XL B1 B0 VSS A0 A1 Y VDD
** N=10 EP=7 IP=0 FDC=8
M0 VSS B1 8 VSS n18 L=1.8e-07 W=5.6e-07 $X=6200 $Y=10150 $D=6
M1 8 B0 VSS VSS n18 L=1.8e-07 W=5.6e-07 $X=14200 $Y=10150 $D=6
M2 Y A0 8 VSS n18 L=1.8e-07 W=5.6e-07 $X=21400 $Y=10150 $D=6
M3 8 A1 Y VSS n18 L=1.8e-07 W=5.6e-07 $X=28600 $Y=10150 $D=6
M4 9 B1 VDD VDD p18 L=1.8e-07 W=8.4e-07 $X=6600 $Y=31250 $D=10
M5 Y B0 9 VDD p18 L=1.8e-07 W=8.4e-07 $X=12200 $Y=31250 $D=10
M6 10 A0 Y VDD p18 L=1.8e-07 W=8.4e-07 $X=19400 $Y=31250 $D=10
M7 VDD A1 10 VDD p18 L=1.8e-07 W=8.4e-07 $X=25000 $Y=31250 $D=10
.ENDS
***************************************
.SUBCKT AOI31XL A2 A1 A0 VDD B0 VSS Y
** N=10 EP=7 IP=0 FDC=8
M0 9 A2 VSS VSS n18 L=1.8e-07 W=6.6e-07 $X=6200 $Y=8950 $D=6
M1 10 A1 9 VSS n18 L=1.8e-07 W=6.6e-07 $X=11800 $Y=8950 $D=6
M2 Y A0 10 VSS n18 L=1.8e-07 W=6.6e-07 $X=17400 $Y=8950 $D=6
M3 VSS B0 Y VSS n18 L=1.8e-07 W=4.2e-07 $X=25000 $Y=11350 $D=6
M4 8 A2 VDD VDD p18 L=1.8e-07 W=8.4e-07 $X=4600 $Y=29400 $D=10
M5 VDD A1 8 VDD p18 L=1.8e-07 W=8.4e-07 $X=11800 $Y=29400 $D=10
M6 8 A0 VDD VDD p18 L=1.8e-07 W=8.4e-07 $X=17800 $Y=29400 $D=10
M7 Y B0 8 VDD p18 L=1.8e-07 W=8.4e-07 $X=25000 $Y=29400 $D=10
.ENDS
***************************************
.SUBCKT AOI32XL A2 A1 A0 VDD B0 B1 VSS Y
** N=12 EP=8 IP=0 FDC=10
M0 10 A2 VSS VSS n18 L=1.8e-07 W=6.6e-07 $X=6200 $Y=8950 $D=6
M1 11 A1 10 VSS n18 L=1.8e-07 W=6.6e-07 $X=11800 $Y=8950 $D=6
M2 Y A0 11 VSS n18 L=1.8e-07 W=6.6e-07 $X=17400 $Y=8950 $D=6
M3 12 B0 Y VSS n18 L=1.8e-07 W=5.6e-07 $X=24600 $Y=8950 $D=6
M4 VSS B1 12 VSS n18 L=1.8e-07 W=5.6e-07 $X=30200 $Y=8950 $D=6
M5 9 A2 VDD VDD p18 L=1.8e-07 W=8.4e-07 $X=6200 $Y=33050 $D=10
M6 VDD A1 9 VDD p18 L=1.8e-07 W=8.4e-07 $X=13400 $Y=33050 $D=10
M7 9 A0 VDD VDD p18 L=1.8e-07 W=8.4e-07 $X=20600 $Y=33050 $D=10
M8 Y B0 9 VDD p18 L=1.8e-07 W=8.4e-07 $X=27800 $Y=33050 $D=10
M9 9 B1 Y VDD p18 L=1.8e-07 W=8.4e-07 $X=35000 $Y=33050 $D=10
.ENDS
***************************************
.SUBCKT AOI2BB1XL A0N A1N VSS B0 VDD Y
** N=9 EP=6 IP=0 FDC=8
M0 7 A0N VSS VSS n18 L=1.8e-07 W=3e-07 $X=4100 $Y=8600 $D=6
M1 VSS A1N 7 VSS n18 L=1.8e-07 W=3e-07 $X=9300 $Y=15400 $D=6
M2 Y B0 VSS VSS n18 L=1.8e-07 W=4.6e-07 $X=15300 $Y=13800 $D=6
M3 VSS 7 Y VSS n18 L=1.8e-07 W=4.6e-07 $X=22600 $Y=13800 $D=6
M4 8 A0N 7 VDD p18 L=1.8e-07 W=5.6e-07 $X=6200 $Y=34600 $D=10
M5 VDD A1N 8 VDD p18 L=1.8e-07 W=5.6e-07 $X=11800 $Y=34600 $D=10
M6 9 B0 VDD VDD p18 L=1.8e-07 W=8.4e-07 $X=17800 $Y=33050 $D=10
M7 Y 7 9 VDD p18 L=1.8e-07 W=8.4e-07 $X=23400 $Y=33050 $D=10
.ENDS
***************************************
.SUBCKT ICV_9 2 3 4 5 6 7 8 9 10 11 12 13 14 18 19 20 21 22 23 24
+ 25 26 27 28 29 32 33 34 35 36 37 38 39 41 44 46 47 48 49 50
+ 51 52 53 54 55 56 57 58 59 60 61 62 63 64 65 66 67 68 69 70
+ 72 74 76 77 78 79 80 81 82 83 84 85 86 87 88 90 91 92 93 94
+ 95 96 97 98 100 101 102 103 104 105 106 107 108 109 110 111 113 114 115 116
+ 117 118 119 124 125 126 127 128 129 130 131 132 133 134 135 136 137 138 139 140
+ 141 142 143 144 145 146 147 148 149 150 151 152 153 154 155 156 157 158 159 160
+ 161 162 163 164 165 166 167 168 169 170 171 172 173 174 175 176 177 178 179 180
+ 181 182 183 184 185 186 187 188 189 190 191 192 193 194 195 196 197 198 199 200
+ 201 202 203 204 205 206 207 208 209 210 211 212 213 214 215 216 217 218 219 220
+ 221 222 223 224 225 226 227 228 229 230 231 232 233 234 235 236 237 238 239
*.CALIBRE ICV_CELL 2
** N=491 EP=219 IP=1302 FDC=2516
M0 484 244 182 182 n18 L=1.8e-07 W=1.04e-06 $X=1465350 $Y=761700 $D=6
M1 485 22 484 182 n18 L=1.8e-07 W=1.04e-06 $X=1470950 $Y=761700 $D=6
M2 486 130 485 182 n18 L=1.8e-07 W=1.04e-06 $X=1476550 $Y=761700 $D=6
M3 18 365 486 182 n18 L=1.8e-07 W=1.04e-06 $X=1482150 $Y=761700 $D=6
M4 182 18 365 182 n18 L=1.8e-07 W=3e-07 $X=1496750 $Y=768650 $D=6
M5 182 372 271 182 n18 L=1.8e-07 W=4.2e-07 $X=2019650 $Y=841400 $D=6
M6 487 53 182 182 n18 L=1.8e-07 W=5e-07 $X=2025800 $Y=660900 $D=6
M7 371 303 182 182 n18 L=1.8e-07 W=3e-07 $X=2026950 $Y=841400 $D=6
M8 238 199 487 182 n18 L=1.8e-07 W=5e-07 $X=2031400 $Y=660900 $D=6
M9 372 374 371 182 n18 L=1.8e-07 W=5.6e-07 $X=2034550 $Y=841400 $D=6
M10 182 64 238 182 n18 L=1.8e-07 W=3.8e-07 $X=2039400 $Y=665950 $D=6
M11 373 304 372 182 n18 L=1.8e-07 W=5.6e-07 $X=2041750 $Y=841400 $D=6
M12 238 59 182 182 n18 L=1.8e-07 W=3.8e-07 $X=2045400 $Y=665950 $D=6
M13 182 305 373 182 n18 L=1.8e-07 W=3e-07 $X=2049350 $Y=841400 $D=6
M14 374 304 182 182 n18 L=1.8e-07 W=3e-07 $X=2057350 $Y=841400 $D=6
M15 182 238 239 182 n18 L=1.8e-07 W=9.6e-07 $X=2060000 $Y=660900 $D=6
M16 253 239 182 182 n18 L=1.8e-07 W=1.2e-06 $X=2067200 $Y=660900 $D=6
M17 182 239 253 182 n18 L=1.8e-07 W=1.2e-06 $X=2074400 $Y=660900 $D=6
M18 375 68 182 182 n18 L=1.8e-07 W=8e-07 $X=2124800 $Y=739050 $D=6
M19 182 67 375 182 n18 L=1.8e-07 W=8e-07 $X=2132000 $Y=739050 $D=6
M20 375 107 182 182 n18 L=1.8e-07 W=8e-07 $X=2140000 $Y=739050 $D=6
M21 138 62 375 182 n18 L=1.8e-07 W=8e-07 $X=2147200 $Y=739050 $D=6
M22 141 376 182 182 n18 L=1.83022e-07 W=1.20314e-06 $X=2181800 $Y=940200 $D=6
M23 182 376 141 182 n18 L=1.83022e-07 W=1.20314e-06 $X=2188200 $Y=945900 $D=6
M24 376 144 182 182 n18 L=1.8e-07 W=9.4e-07 $X=2195800 $Y=939200 $D=6
M25 182 66 376 182 n18 L=1.8e-07 W=9.4e-07 $X=2203000 $Y=939200 $D=6
M26 182 254 377 182 n18 L=1.8e-07 W=9.6e-07 $X=3101600 $Y=863800 $D=6
M27 8 377 182 182 n18 L=1.8e-07 W=1.2e-06 $X=3109600 $Y=862500 $D=6
M28 182 377 8 182 n18 L=1.8e-07 W=1.2e-06 $X=3116800 $Y=862500 $D=6
M29 182 236 169 182 n18 L=1.8e-07 W=2.8e-07 $X=4137800 $Y=744300 $D=6
M30 18 244 35 35 p18 L=1.84272e-07 W=9.57279e-07 $X=1465200 $Y=786550 $D=10
M31 35 22 18 35 p18 L=1.84272e-07 W=9.57279e-07 $X=1471700 $Y=791350 $D=10
M32 18 130 35 35 p18 L=1.84272e-07 W=9.57279e-07 $X=1478800 $Y=786550 $D=10
M33 35 365 18 35 p18 L=1.84272e-07 W=9.57279e-07 $X=1485300 $Y=791350 $D=10
M34 365 18 35 35 p18 L=1.8e-07 W=4.4e-07 $X=1492750 $Y=786550 $D=10
M35 35 372 271 35 p18 L=1.8e-07 W=6.4e-07 $X=2021600 $Y=819800 $D=10
M36 35 53 370 35 p18 L=1.8e-07 W=8.8e-07 $X=2025800 $Y=684300 $D=10
M37 371 303 35 35 p18 L=1.8e-07 W=4.2e-07 $X=2027650 $Y=822000 $D=10
M38 370 199 35 35 p18 L=1.8e-07 W=8.8e-07 $X=2031900 $Y=684300 $D=10
M39 372 304 371 35 p18 L=1.8e-07 W=8.4e-07 $X=2034850 $Y=817800 $D=10
M40 488 64 370 35 p18 L=1.8e-07 W=8.8e-07 $X=2039100 $Y=684300 $D=10
M41 373 374 372 35 p18 L=1.8e-07 W=8.4e-07 $X=2043000 $Y=817800 $D=10
M42 238 59 488 35 p18 L=1.8e-07 W=8.8e-07 $X=2044700 $Y=684300 $D=10
M43 35 305 373 35 p18 L=1.8e-07 W=4.2e-07 $X=2050600 $Y=819900 $D=10
M44 374 304 35 35 p18 L=1.8e-07 W=4.2e-07 $X=2057800 $Y=819900 $D=10
M45 35 238 239 35 p18 L=1.8e-07 W=1.44e-06 $X=2058950 $Y=682200 $D=10
M46 253 239 35 35 p18 L=1.82016e-07 W=1.80314e-06 $X=2065350 $Y=682200 $D=10
M47 35 239 253 35 p18 L=1.82016e-07 W=1.80314e-06 $X=2071750 $Y=689900 $D=10
M48 489 68 35 35 p18 L=1.8e-07 W=1.4e-06 $X=2124800 $Y=714550 $D=10
M49 490 67 489 35 p18 L=1.8e-07 W=1.4e-06 $X=2130400 $Y=714550 $D=10
M50 138 107 490 35 p18 L=1.8e-07 W=1.4e-06 $X=2136400 $Y=714550 $D=10
M51 35 62 138 35 p18 L=1.8e-07 W=9e-07 $X=2143600 $Y=719550 $D=10
M52 141 376 35 35 p18 L=1.82016e-07 W=1.80314e-06 $X=2183000 $Y=922500 $D=10
M53 35 376 141 35 p18 L=1.82016e-07 W=1.80314e-06 $X=2189400 $Y=912900 $D=10
M54 491 144 35 35 p18 L=1.8e-07 W=1.7e-06 $X=2197400 $Y=912900 $D=10
M55 376 66 491 35 p18 L=1.8e-07 W=1.7e-06 $X=2203000 $Y=912900 $D=10
M56 35 254 377 35 p18 L=1.8e-07 W=1.44e-06 $X=3101600 $Y=883800 $D=10
M57 8 377 35 35 p18 L=1.8e-07 W=1.76e-06 $X=3109600 $Y=883800 $D=10
M58 35 377 8 35 p18 L=1.8e-07 W=1.76e-06 $X=3116800 $Y=883800 $D=10
M59 35 236 169 35 p18 L=1.8e-07 W=7e-07 $X=4141200 $Y=718200 $D=10
X60 260 35 182 261 INVXL $T=1359600 756000 0 0 $X=1355300 $Y=752000
X61 294 35 182 242 INVXL $T=1432200 756000 1 180 $X=1414700 $Y=752000
X62 26 35 182 248 INVXL $T=1524600 756000 0 180 $X=1507100 $Y=700200
X63 240 35 182 250 INVXL $T=1590600 856800 1 180 $X=1573100 $Y=852800
X64 275 35 182 355 INVXL $T=1663200 856800 0 0 $X=1658900 $Y=852800
X65 279 35 182 367 INVXL $T=1689600 856800 0 180 $X=1672100 $Y=801000
X66 287 35 182 195 INVXL $T=1722600 856800 1 180 $X=1705100 $Y=852800
X67 299 35 182 294 INVXL $T=1927200 856800 0 180 $X=1909700 $Y=801000
X68 291 35 182 309 INVXL $T=2224200 957600 1 0 $X=2219900 $Y=901800
X69 87 35 182 314 INVXL $T=2343000 856800 0 180 $X=2325500 $Y=801000
X70 310 35 182 313 INVXL $T=2343000 856800 1 0 $X=2338700 $Y=801000
X71 318 35 182 316 INVXL $T=2475000 856800 1 180 $X=2457500 $Y=852800
X72 149 35 182 320 INVXL $T=2475000 856800 0 0 $X=2470700 $Y=852800
X73 214 35 182 94 INVXL $T=2541000 957600 0 180 $X=2523500 $Y=901800
X74 218 35 182 101 INVXL $T=2646600 957600 1 0 $X=2642300 $Y=901800
X75 105 35 182 148 INVXL $T=2739000 957600 1 0 $X=2734700 $Y=901800
X76 329 35 182 330 INVXL $T=2950200 856800 0 180 $X=2932700 $Y=801000
X77 330 35 182 331 INVXL $T=3075600 856800 0 0 $X=3071300 $Y=852800
X78 181 35 182 342 INVXL $T=4045800 957600 0 180 $X=4028300 $Y=901800
X79 179 35 182 341 INVXL $T=4059000 856800 0 180 $X=4041500 $Y=801000
X80 180 35 182 234 INVXL $T=4072200 856800 0 180 $X=4054700 $Y=801000
X81 235 35 182 336 INVXL $T=4098600 756000 1 180 $X=4081100 $Y=752000
X82 169 35 182 344 INVXL $T=4131600 756000 0 180 $X=4114100 $Y=700200
X83 237 35 182 328 INVXL $T=4191000 655200 1 180 $X=4173500 $Y=651200
X84 265 182 263 353 35 352 OAI21XL $T=1412400 856800 0 180 $X=1381700 $Y=801000
X85 22 182 245 269 35 366 OAI21XL $T=1511400 856800 0 0 $X=1507100 $Y=852800
X86 277 182 25 281 35 282 OAI21XL $T=1656600 756000 1 0 $X=1652300 $Y=700200
X87 280 182 285 356 35 286 OAI21XL $T=1702800 856800 1 0 $X=1698500 $Y=801000
X88 278 182 134 368 35 290 OAI21XL $T=1768800 655200 0 0 $X=1764500 $Y=651200
X89 274 182 53 284 35 297 OAI21XL $T=1887600 756000 1 0 $X=1883300 $Y=700200
X90 240 182 291 136 35 302 OAI21XL $T=1999800 856800 1 180 $X=1969100 $Y=852800
X91 109 182 142 307 35 272 OAI21XL $T=2118600 856800 0 180 $X=2087900 $Y=801000
X92 92 182 320 90 35 321 OAI21XL $T=2494800 957600 1 0 $X=2490500 $Y=901800
X93 361 182 95 148 35 311 OAI21XL $T=2574000 856800 1 180 $X=2543300 $Y=852800
X94 90 182 95 321 35 317 OAI21XL $T=2574000 957600 0 180 $X=2543300 $Y=901800
X95 253 182 160 106 35 326 OAI21XL $T=2818200 957600 1 0 $X=2813900 $Y=901800
X96 378 182 114 156 35 340 OAI21XL $T=3313200 756000 1 180 $X=3282500 $Y=752000
X97 257 182 35 243 258 NAND2XL $T=1201200 756000 1 0 $X=1196900 $Y=700200
X98 266 182 35 270 267 NAND2XL $T=1412400 756000 1 0 $X=1408100 $Y=700200
X99 22 182 35 245 269 NAND2XL $T=1498200 856800 1 0 $X=1493900 $Y=801000
X100 27 182 35 28 21 NAND2XL $T=1551000 756000 0 0 $X=1546700 $Y=752000
X101 33 182 35 27 32 NAND2XL $T=1597200 756000 1 0 $X=1592900 $Y=700200
X102 261 182 35 275 276 NAND2XL $T=1623600 856800 0 0 $X=1619300 $Y=852800
X103 279 182 35 246 291 NAND2XL $T=1749000 856800 1 0 $X=1744700 $Y=801000
X104 49 182 35 48 296 NAND2XL $T=1874400 856800 0 180 $X=1850300 $Y=801000
X105 201 182 35 141 202 NAND2XL $T=2052600 957600 1 0 $X=2048300 $Y=901800
X106 109 182 35 142 307 NAND2XL $T=2158200 856800 0 180 $X=2134100 $Y=801000
X107 218 182 35 214 361 NAND2XL $T=2600400 957600 0 180 $X=2576300 $Y=901800
X108 325 182 35 318 106 NAND2XL $T=2765400 957600 1 0 $X=2761100 $Y=901800
X109 338 182 35 337 156 NAND2XL $T=3234000 756000 1 180 $X=3209900 $Y=752000
X110 171 182 35 256 170 NAND2XL $T=3326400 655200 1 180 $X=3302300 $Y=651200
X111 10 183 380 184 381 125 182 382 35 DFFSXL $T=587400 957600 1 0 $X=583100 $Y=901800
X112 10 185 383 12 384 126 182 385 35 DFFSXL $T=726000 957600 1 0 $X=721700 $Y=901800
X113 11 186 186 12 386 187 182 387 35 DFFSXL $T=858000 957600 1 0 $X=853700 $Y=901800
X114 13 352 388 35 389 265 182 390 35 DFFSXL $T=1366200 856800 0 0 $X=1361900 $Y=852800
X115 13 286 391 35 392 285 182 72 35 DFFSXL $T=1742400 756000 0 0 $X=1738100 $Y=752000
X116 13 198 393 35 394 41 182 57 35 DFFSXL $T=1848000 655200 0 0 $X=1843700 $Y=651200
X117 219 220 395 215 396 315 182 397 35 DFFSXL $T=2620200 655200 0 0 $X=2615900 $Y=651200
X118 156 182 164 35 INVX2 $T=2943600 756000 0 180 $X=2919500 $Y=700200
X119 258 350 35 242 398 182 241 AOI21XL $T=1240800 756000 1 0 $X=1236500 $Y=700200
X120 263 265 35 261 399 182 353 AOI21XL $T=1379400 756000 0 0 $X=1375100 $Y=752000
X121 266 248 35 245 400 182 268 AOI21XL $T=1458600 856800 1 0 $X=1454300 $Y=801000
X122 271 246 35 25 401 182 18 AOI21XL $T=1537800 756000 1 180 $X=1507100 $Y=752000
X123 21 248 35 240 402 182 354 AOI21XL $T=1577400 856800 1 0 $X=1573100 $Y=801000
X124 249 251 35 354 403 182 192 AOI21XL $T=1617000 856800 1 180 $X=1586300 $Y=852800
X125 39 280 35 133 404 182 356 AOI21XL $T=1656600 756000 0 0 $X=1652300 $Y=752000
X126 39 193 35 133 405 182 194 AOI21XL $T=1683000 655200 0 0 $X=1678700 $Y=651200
X127 130 269 35 279 406 182 283 AOI21XL $T=1683000 856800 0 0 $X=1678700 $Y=852800
X128 277 47 35 133 407 182 281 AOI21XL $T=1689600 756000 1 0 $X=1685300 $Y=700200
X129 39 274 35 133 408 182 284 AOI21XL $T=1689600 756000 0 0 $X=1685300 $Y=752000
X130 39 278 35 133 409 182 368 AOI21XL $T=1716000 655200 0 0 $X=1711700 $Y=651200
X131 300 137 35 302 410 182 200 AOI21XL $T=2006400 957600 1 0 $X=2002100 $Y=901800
X132 312 149 35 314 411 182 359 AOI21XL $T=2336400 957600 0 180 $X=2305700 $Y=901800
X133 334 331 35 164 412 182 363 AOI21XL $T=3062400 756000 0 180 $X=3031700 $Y=700200
X134 170 254 35 225 413 182 332 AOI21XL $T=3240600 655200 1 180 $X=3209900 $Y=651200
X135 172 119 35 340 414 182 343 AOI21XL $T=3339600 756000 1 0 $X=3335300 $Y=700200
X136 265 182 263 415 35 262 NAND2BXL $T=1359600 756000 1 180 $X=1328900 $Y=752000
X137 35 259 262 243 182 NOR2XL $T=1320000 756000 1 180 $X=1295900 $Y=752000
X138 35 127 264 263 182 NOR2XL $T=1359600 856800 0 180 $X=1335500 $Y=801000
X139 35 246 240 260 182 NOR2XL $T=1399200 756000 0 180 $X=1375100 $Y=700200
X140 35 129 267 19 182 NOR2XL $T=1419000 655200 0 0 $X=1414700 $Y=651200
X141 35 266 248 245 182 NOR2XL $T=1432200 756000 0 0 $X=1427900 $Y=752000
X142 35 267 22 189 182 NOR2XL $T=1458600 655200 0 0 $X=1454300 $Y=651200
X143 35 24 248 20 182 NOR2XL $T=1518000 655200 1 180 $X=1493900 $Y=651200
X144 35 130 18 270 182 NOR2XL $T=1544400 756000 0 180 $X=1520300 $Y=700200
X145 35 33 27 191 182 NOR2XL $T=1551000 655200 1 180 $X=1526900 $Y=651200
X146 35 27 28 26 182 NOR2XL $T=1551000 756000 1 0 $X=1546700 $Y=700200
X147 35 23 248 274 182 NOR2XL $T=1570800 756000 1 0 $X=1566500 $Y=700200
X148 35 18 21 280 182 NOR2XL $T=1597200 756000 0 0 $X=1592900 $Y=752000
X149 35 130 269 279 182 NOR2XL $T=1603800 856800 1 0 $X=1599500 $Y=801000
X150 35 24 32 278 182 NOR2XL $T=1650000 655200 0 0 $X=1645700 $Y=651200
X151 35 107 111 204 182 NOR2XL $T=2171400 655200 0 0 $X=2167100 $Y=651200
X152 35 140 145 205 182 NOR2XL $T=2191200 655200 0 0 $X=2186900 $Y=651200
X153 35 86 85 312 182 NOR2XL $T=2369400 957600 0 180 $X=2345300 $Y=901800
X154 35 92 86 318 182 NOR2XL $T=2494800 957600 0 180 $X=2470700 $Y=901800
X155 35 154 90 325 182 NOR2XL $T=2719200 957600 1 0 $X=2714900 $Y=901800
X156 35 118 119 338 182 NOR2XL $T=3227400 756000 1 0 $X=3223100 $Y=700200
X157 35 171 337 172 182 NOR2XL $T=3339600 655200 0 0 $X=3335300 $Y=651200
X158 291 303 35 80 182 208 209 AOI211XL $T=2257200 957600 1 0 $X=2252900 $Y=901800
X159 303 309 35 359 182 311 211 AOI211XL $T=2263800 856800 0 0 $X=2259500 $Y=852800
X160 305 309 35 88 182 360 212 AOI211XL $T=2415600 957600 1 0 $X=2411300 $Y=901800
X161 144 149 35 93 182 311 322 AOI211XL $T=2501400 856800 0 0 $X=2497100 $Y=852800
X162 101 318 35 97 182 305 319 AOI211XL $T=2620200 856800 1 180 $X=2582900 $Y=852800
X163 114 338 35 255 182 115 339 AOI211XL $T=3247200 756000 0 0 $X=3242900 $Y=752000
X164 103 119 35 118 182 256 255 AOI211XL $T=3333000 756000 0 180 $X=3295700 $Y=700200
X165 310 35 86 303 182 NOR2BX1 $T=2257200 856800 1 180 $X=2226500 $Y=852800
X166 66 203 136 182 308 35 OAI2BB1X1 $T=2085600 957600 1 0 $X=2081300 $Y=901800
X167 361 98 35 182 323 AND2XL $T=2600400 856800 1 0 $X=2596100 $Y=801000
X168 127 261 182 35 188 OR2XL $T=1280400 856800 1 180 $X=1249700 $Y=852800
X169 18 248 182 35 277 OR2XL $T=1623600 756000 1 0 $X=1619300 $Y=700200
X170 137 302 182 35 298 OR2XL $T=1999800 957600 0 180 $X=1969100 $Y=901800
X171 13 241 416 12 257 182 417 35 DFFSX1 $T=1247400 856800 0 180 $X=1117700 $Y=801000
X172 13 349 418 12 259 182 419 35 DFFSX1 $T=1128600 957600 1 0 $X=1124300 $Y=901800
X173 13 351 420 35 264 182 421 35 DFFSX1 $T=1260600 957600 1 0 $X=1256300 $Y=901800
X174 14 247 422 12 266 182 244 35 DFFSX1 $T=1392600 957600 1 0 $X=1388300 $Y=901800
X175 13 282 423 35 58 182 47 35 DFFSX1 $T=1867800 756000 0 180 $X=1738100 $Y=700200
X176 13 290 424 35 134 182 61 35 DFFSX1 $T=1966800 756000 1 0 $X=1962500 $Y=700200
X177 34 306 425 35 304 182 426 35 DFFSX1 $T=2072400 856800 0 0 $X=2068100 $Y=852800
X178 34 143 427 35 428 182 306 35 DFFSX1 $T=2158200 756000 0 0 $X=2153900 $Y=752000
X179 34 148 429 35 153 182 430 35 DFFSX1 $T=2290200 756000 0 0 $X=2285900 $Y=752000
X180 34 297 431 35 53 182 91 35 DFFSX1 $T=2395800 756000 1 0 $X=2391500 $Y=700200
X181 34 319 432 215 92 182 85 35 DFFSX1 $T=2468400 856800 1 0 $X=2464100 $Y=801000
X182 34 156 433 215 82 182 434 35 DFFSX1 $T=2587200 756000 0 0 $X=2582900 $Y=752000
X183 34 322 435 35 154 182 158 35 DFFSX1 $T=2640000 856800 0 0 $X=2635700 $Y=852800
X184 252 104 436 35 223 182 437 35 DFFSX1 $T=2725800 856800 1 0 $X=2721500 $Y=801000
X185 252 323 438 215 161 182 439 35 DFFSX1 $T=2752200 655200 0 0 $X=2747900 $Y=651200
X186 252 106 440 35 163 182 441 35 DFFSX1 $T=2778600 756000 1 0 $X=2774300 $Y=700200
X187 34 326 442 35 160 182 443 35 DFFSX1 $T=2798400 856800 0 0 $X=2794100 $Y=852800
X188 34 162 162 35 327 182 444 35 DFFSX1 $T=2857800 756000 0 0 $X=2853500 $Y=752000
X189 34 328 445 35 224 182 446 35 DFFSX1 $T=2943600 856800 0 0 $X=2939300 $Y=852800
X190 34 363 363 35 329 182 447 35 DFFSX1 $T=2983200 856800 1 0 $X=2978900 $Y=801000
X191 34 332 448 35 254 182 449 35 DFFSX1 $T=3055800 756000 0 0 $X=3051500 $Y=752000
X192 34 333 450 35 364 182 451 35 DFFSX1 $T=3069000 655200 0 0 $X=3064700 $Y=651200
X193 34 168 452 35 167 182 453 35 DFFSX1 $T=3161400 856800 1 0 $X=3157100 $Y=801000
X194 34 169 454 35 335 182 455 35 DFFSX1 $T=3161400 856800 0 0 $X=3157100 $Y=852800
X195 34 336 456 35 166 182 457 35 DFFSX1 $T=3174600 957600 1 0 $X=3170300 $Y=901800
X196 34 341 458 177 116 182 459 35 DFFSX1 $T=3293400 856800 0 0 $X=3289100 $Y=852800
X197 34 342 460 177 117 182 461 35 DFFSX1 $T=3306600 957600 1 0 $X=3302300 $Y=901800
X198 34 173 462 35 226 182 175 35 DFFSX1 $T=3379200 655200 0 0 $X=3374900 $Y=651200
X199 34 339 463 35 119 182 176 35 DFFSX1 $T=3392400 756000 1 0 $X=3388100 $Y=700200
X200 34 343 464 177 337 182 256 35 DFFSX1 $T=3392400 756000 0 0 $X=3388100 $Y=752000
X201 34 344 465 177 227 182 466 35 DFFSX1 $T=3432000 856800 0 0 $X=3427700 $Y=852800
X202 34 345 467 177 379 182 230 35 DFFSX1 $T=3517800 856800 1 0 $X=3513500 $Y=801000
X203 34 346 468 35 469 182 229 35 DFFSX1 $T=3524400 756000 1 0 $X=3520100 $Y=700200
X204 34 228 470 35 174 182 471 35 DFFSX1 $T=3636600 655200 0 0 $X=3632300 $Y=651200
X205 124 233 472 35 348 182 178 35 DFFSX1 $T=4012800 655200 0 0 $X=4008500 $Y=651200
X206 366 35 250 249 272 128 182 AOI22XL $T=1544400 856800 0 0 $X=1540100 $Y=852800
X207 250 35 33 249 36 190 182 AOI22XL $T=1623600 957600 0 180 $X=1586300 $Y=901800
X208 44 35 38 132 46 289 182 AOI22XL $T=1749000 957600 1 0 $X=1744700 $Y=901800
X209 135 35 51 197 50 292 182 AOI22XL $T=1834800 957600 1 0 $X=1830500 $Y=901800
X210 285 35 52 48 53 369 182 AOI22XL $T=1874400 856800 0 0 $X=1870100 $Y=852800
X211 134 35 55 56 58 358 182 AOI22XL $T=1927200 756000 0 0 $X=1922900 $Y=752000
X212 63 35 60 60 140 301 182 AOI22XL $T=2079000 756000 1 180 $X=2041700 $Y=752000
X213 142 35 65 62 307 295 182 AOI22XL $T=2118600 756000 1 180 $X=2081300 $Y=752000
X214 36 35 68 69 9 251 182 AOI22XL $T=2164800 957600 0 180 $X=2127500 $Y=901800
X215 232 35 348 231 178 346 182 AOI22XL $T=3993000 655200 1 180 $X=3955700 $Y=651200
X216 364 102 182 35 CLKBUFX3 $T=3148200 756000 0 180 $X=3117500 $Y=700200
X217 296 182 301 358 300 293 35 NAND4XL $T=1960200 856800 1 180 $X=1922900 $Y=852800
X218 148 182 222 101 362 106 35 NAND4XL $T=2673000 957600 1 0 $X=2668700 $Y=901800
X219 145 182 77 35 CLKINVX8 $T=2686200 756000 1 0 $X=2681900 $Y=700200
X220 330 182 108 35 CLKINVX8 $T=2963400 957600 0 180 $X=2919500 $Y=901800
X221 83 182 35 35 CLKINVX8 $T=2983200 756000 1 0 $X=2978900 $Y=700200
X222 70 35 182 139 CLKBUFX2 $T=2118600 655200 1 180 $X=2087900 $Y=651200
X223 146 35 182 74 CLKBUFX2 $T=2230800 756000 0 180 $X=2200100 $Y=700200
X224 159 35 182 100 CLKBUFX2 $T=2745600 756000 1 180 $X=2714900 $Y=752000
X225 335 35 182 113 CLKBUFX2 $T=3154800 957600 0 180 $X=3124100 $Y=901800
X226 244 182 270 35 129 24 NAND3XL $T=1465200 756000 0 180 $X=1434500 $Y=700200
X227 244 182 22 35 270 23 NAND3XL $T=1471800 756000 1 0 $X=1467500 $Y=700200
X228 369 182 292 35 289 357 NAND3XL $T=1821600 856800 1 180 $X=1790900 $Y=852800
X229 95 182 218 35 214 157 NAND3XL $T=2613600 957600 1 0 $X=2609300 $Y=901800
X230 150 3 182 35 CLKBUFX4 $T=2356200 655200 1 180 $X=2318900 $Y=651200
X231 155 6 182 35 CLKBUFX4 $T=2488200 655200 1 180 $X=2450900 $Y=651200
X232 213 5 182 35 CLKBUFX4 $T=2541000 655200 1 180 $X=2503700 $Y=651200
X233 216 2 182 35 CLKBUFX4 $T=2567400 756000 0 180 $X=2530100 $Y=700200
X234 217 4 182 35 CLKBUFX4 $T=2607000 655200 1 180 $X=2569700 $Y=651200
X235 221 7 182 35 CLKBUFX4 $T=2653200 756000 0 180 $X=2615900 $Y=700200
X236 243 35 257 246 182 NOR2BXL $T=1287000 756000 1 0 $X=1282700 $Y=700200
X237 114 35 102 347 182 NOR2BXL $T=3326400 856800 1 0 $X=3322100 $Y=801000
X238 256 103 182 171 35 119 334 OAI211XL $T=3293400 655200 1 180 $X=3249500 $Y=651200
X239 83 35 215 182 CLKINVX3 $T=2541000 756000 0 0 $X=2536700 $Y=752000
X240 273 13 182 35 BUFX12 $T=1584000 655200 0 0 $X=1579700 $Y=651200
X241 288 35 34 182 273 AND2X2 $T=1557600 655200 0 0 $X=1553300 $Y=651200
X242 87 35 312 182 144 AND2X2 $T=2336400 856800 0 0 $X=2332100 $Y=852800
X243 324 35 34 182 252 AND2X2 $T=2765400 756000 0 0 $X=2761100 $Y=752000
X244 196 35 357 182 37 293 NOR3XL $T=1782000 957600 1 0 $X=1777700 $Y=901800
X245 154 35 90 182 85 310 NOR3XL $T=2409000 957600 0 180 $X=2378300 $Y=901800
X246 317 35 154 182 152 360 NOR3XL $T=2475000 957600 0 180 $X=2444300 $Y=901800
X247 152 182 85 314 305 35 NOR3X2 $T=2409000 856800 0 0 $X=2404700 $Y=852800
X248 96 182 79 35 CLKBUFX8 $T=2323200 655200 1 180 $X=2272700 $Y=651200
X249 151 182 81 35 CLKBUFX8 $T=2369400 756000 0 180 $X=2318900 $Y=700200
X250 315 182 84 35 CLKBUFX8 $T=2409000 655200 1 180 $X=2358500 $Y=651200
X251 35 62 107 65 182 NOR2X1 $T=2164800 655200 1 180 $X=2140700 $Y=651200
X252 35 94 314 66 182 NOR2X1 $T=2283600 856800 0 180 $X=2259500 $Y=801000
X253 34 473 355 474 131 182 35 TLATNXL $T=1643400 957600 1 0 $X=1639100 $Y=901800
X254 34 475 276 476 288 182 35 TLATNXL $T=1722600 856800 0 0 $X=1718300 $Y=852800
X255 34 477 298 478 54 182 35 TLATNXL $T=1894200 957600 1 0 $X=1889900 $Y=901800
X256 34 479 362 480 324 182 35 TLATNXL $T=2646600 856800 1 0 $X=2642300 $Y=801000
X257 34 481 308 482 165 182 35 TLATNXL $T=3042600 957600 1 0 $X=3038300 $Y=901800
X258 294 136 133 182 35 NAND2X2 $T=1914000 856800 0 180 $X=1876700 $Y=801000
X259 207 35 182 76 BUFX2 $T=2244000 655200 1 180 $X=2213300 $Y=651200
X260 210 35 182 78 BUFX2 $T=2283600 756000 0 180 $X=2252900 $Y=700200
X261 327 35 182 110 BUFX2 $T=2871000 957600 0 180 $X=2840300 $Y=901800
X262 138 299 35 182 249 AND2X1 $T=1993200 856800 0 180 $X=1962500 $Y=801000
X263 87 94 35 182 147 AND2X1 $T=2316600 856800 0 180 $X=2285900 $Y=801000
X264 103 256 118 35 182 378 OR3XL $T=3359400 756000 1 180 $X=3322100 $Y=752000
X265 240 258 182 35 25 NOR2X2 $T=1339800 655200 0 0 $X=1335500 $Y=651200
X266 303 305 182 35 240 NOR2X2 $T=2065800 856800 1 180 $X=2028500 $Y=852800
X267 66 310 182 35 206 OR2X1 $T=2244000 856800 0 180 $X=2213300 $Y=801000
X268 25 182 39 35 CLKINVX2 $T=1392600 655200 0 0 $X=1388300 $Y=651200
X269 347 230 483 345 379 182 35 MXI2XL $T=3696000 856800 0 180 $X=3645500 $Y=801000
X270 268 240 29 35 249 247 182 AOI2BB2XL $T=1524600 856800 1 0 $X=1520300 $Y=801000
X271 338 337 118 35 102 333 182 AOI2BB2XL $T=3220800 756000 0 180 $X=3170300 $Y=700200
X272 295 294 182 240 283 287 35 OAI22XL $T=1854600 856800 0 180 $X=1810700 $Y=801000
X273 316 314 182 313 152 299 35 OAI22XL $T=2409000 856800 0 180 $X=2365100 $Y=801000
X274 246 367 250 35 133 182 275 AOI31XL $T=1663200 856800 0 180 $X=1625900 $Y=801000
X275 262 260 259 35 243 260 182 349 AOI32XL $T=1293600 756000 1 180 $X=1243100 $Y=752000
X276 127 260 264 35 263 260 182 351 AOI32XL $T=1333200 856800 0 180 $X=1282700 $Y=801000
X277 243 257 182 240 35 350 AOI2BB1XL $T=1287000 655200 1 180 $X=1249700 $Y=651200
.ENDS
***************************************
.SUBCKT MXI2X1 S0 B Y A VSS VDD
** N=9 EP=6 IP=0 FDC=10
M0 VSS S0 8 VSS n18 L=1.8e-07 W=3e-07 $X=7600 $Y=13400 $D=6
M1 7 B VSS VSS n18 L=1.8e-07 W=6.6e-07 $X=15900 $Y=9800 $D=6
M2 Y S0 7 VSS n18 L=1.8e-07 W=6.6e-07 $X=23600 $Y=9300 $D=6
M3 9 8 Y VSS n18 L=1.8e-07 W=6.6e-07 $X=31200 $Y=9300 $D=6
M4 VSS A 9 VSS n18 L=1.8e-07 W=6.6e-07 $X=39400 $Y=10500 $D=6
M5 VDD S0 8 VDD p18 L=1.8e-07 W=4.6e-07 $X=6600 $Y=30300 $D=10
M6 7 B VDD VDD p18 L=1.8e-07 W=1e-06 $X=15800 $Y=27700 $D=10
M7 Y 8 7 VDD p18 L=1.8e-07 W=1e-06 $X=23400 $Y=27700 $D=10
M8 9 S0 Y VDD p18 L=1.8e-07 W=1e-06 $X=31400 $Y=27700 $D=10
M9 VDD A 9 VDD p18 L=1.8e-07 W=1e-06 $X=39400 $Y=27700 $D=10
.ENDS
***************************************
.SUBCKT OAI2BB2XL A0N A1N B1 B0 VSS VDD Y
** N=11 EP=7 IP=0 FDC=10
M0 10 A0N VSS VSS n18 L=1.8e-07 W=3.6e-07 $X=4600 $Y=12600 $D=6
M1 9 A1N 10 VSS n18 L=1.8e-07 W=3.6e-07 $X=10200 $Y=12600 $D=6
M2 VSS B1 8 VSS n18 L=1.8e-07 W=5.6e-07 $X=23200 $Y=7500 $D=6
M3 8 B0 VSS VSS n18 L=1.8e-07 W=5.6e-07 $X=30400 $Y=7500 $D=6
M4 Y 9 8 VSS n18 L=1.8e-07 W=5.6e-07 $X=37600 $Y=7500 $D=6
M5 9 A0N VDD VDD p18 L=1.8e-07 W=4.2e-07 $X=6400 $Y=30000 $D=10
M6 VDD A1N 9 VDD p18 L=1.8e-07 W=4.2e-07 $X=14400 $Y=30000 $D=10
M7 11 B1 VDD VDD p18 L=1.8e-07 W=8.4e-07 $X=20400 $Y=28800 $D=10
M8 Y B0 11 VDD p18 L=1.8e-07 W=8.4e-07 $X=26000 $Y=28800 $D=10
M9 VDD 9 Y VDD p18 L=1.8e-07 W=6.4e-07 $X=33200 $Y=30350 $D=10
.ENDS
***************************************
.SUBCKT NAND4BXL D C B Y AN VDD VSS
** N=11 EP=7 IP=0 FDC=10
M0 9 D VSS VSS n18 L=1.8e-07 W=7.2e-07 $X=4600 $Y=10200 $D=6
M1 10 C 9 VSS n18 L=1.8e-07 W=7.2e-07 $X=10200 $Y=10200 $D=6
M2 11 B 10 VSS n18 L=1.8e-07 W=7.2e-07 $X=15800 $Y=10200 $D=6
M3 Y 8 11 VSS n18 L=1.8e-07 W=7.2e-07 $X=21400 $Y=10200 $D=6
M4 8 AN VSS VSS n18 L=1.8e-07 W=3e-07 $X=31850 $Y=10250 $D=6
M5 Y D VDD VDD p18 L=1.8e-07 W=6.4e-07 $X=4600 $Y=33450 $D=10
M6 VDD C Y VDD p18 L=1.8e-07 W=6.4e-07 $X=11800 $Y=33450 $D=10
M7 Y B VDD VDD p18 L=1.8e-07 W=6.4e-07 $X=17850 $Y=33450 $D=10
M8 VDD 8 Y VDD p18 L=1.8e-07 W=6.4e-07 $X=25050 $Y=33450 $D=10
M9 8 AN VDD VDD p18 L=1.8e-07 W=4.2e-07 $X=31150 $Y=33450 $D=10
.ENDS
***************************************
.SUBCKT AND3X1 A B C VSS VDD Y
** N=9 EP=6 IP=0 FDC=8
M0 8 A 7 VSS n18 L=1.8e-07 W=3.8e-07 $X=6600 $Y=10400 $D=6
M1 9 B 8 VSS n18 L=1.8e-07 W=3.8e-07 $X=12200 $Y=10400 $D=6
M2 VSS C 9 VSS n18 L=1.8e-07 W=3.8e-07 $X=17800 $Y=10400 $D=6
M3 Y 7 VSS VSS n18 L=1.8e-07 W=5.6e-07 $X=24100 $Y=10400 $D=6
M4 VDD A 7 VDD p18 L=1.8e-07 W=3.6e-07 $X=6600 $Y=39800 $D=10
M5 VDD B 7 VDD p18 L=1.8e-07 W=3.6e-07 $X=11700 $Y=32650 $D=10
M6 VDD C 7 VDD p18 L=1.8e-07 W=3.6e-07 $X=20300 $Y=27250 $D=10
M7 Y 7 VDD VDD p18 L=1.8e-07 W=9e-07 $X=25000 $Y=35300 $D=10
.ENDS
***************************************
.SUBCKT ICV_10 2 3 4 5 6 7 8 9 10 11 12 13 14 15 17 18 19 20 21 22
+ 24 25 26 27 29 30 31 32 33 34 35 36 37 38 39 40 41 42 43 44
+ 45 46 47 48 49 50 51 52 53 54 55 56 57 58 59 60 61 62 63 64
+ 65 66 67 68 69 70 71 72 73 75 77 79 82 84 85 86 88 89 90 91
+ 92 93 94 95 96 97 98 99 100 101 102 103 104 105 106 107 108 109 110 111
+ 112 113 114 115 116 117 118 119 120 121 122 123 124 125 126 127 128 129 130 131
+ 132 133 134 135 136 137 138 139 140 141 142 143 144 145 146 147 148 149 150 151
+ 152 153 154 155 156 157 158 162 163 164 165 166 167 168 169 170 171 172 173 174
+ 175 176 177 180 183 185 186 187 188 189 190 191 192 193 194 195 196 197 198 199
+ 200 201 202 203 204 205 206 207 208 210 211 212 213 214 217
*.CALIBRE ICV_CELL 11
** N=509 EP=195 IP=1425 FDC=2960
X0 113 18 51 225 INVXL $T=1485000 655200 1 0 $X=1480700 $Y=599400
X1 114 18 51 245 INVXL $T=1511400 554400 1 180 $X=1493900 $Y=550400
X2 8 18 51 247 INVXL $T=1551000 554400 0 0 $X=1546700 $Y=550400
X3 267 18 51 229 INVXL $T=1920600 453600 0 0 $X=1916300 $Y=449600
X4 37 18 51 344 INVXL $T=1947000 453600 1 0 $X=1942700 $Y=397800
X5 60 18 51 270 INVXL $T=2039400 352800 1 180 $X=2021900 $Y=348800
X6 67 18 51 175 INVXL $T=2079000 453600 0 180 $X=2061500 $Y=397800
X7 345 18 51 65 INVXL $T=2125200 554400 1 180 $X=2107700 $Y=550400
X8 66 18 51 346 INVXL $T=2138400 655200 0 180 $X=2120900 $Y=599400
X9 18 18 51 232 INVXL $T=3220800 554400 0 180 $X=3203300 $Y=498600
X10 156 18 51 319 INVXL $T=3847800 352800 1 180 $X=3830300 $Y=348800
X11 157 18 51 104 INVXL $T=3946800 453600 0 0 $X=3942500 $Y=449600
X12 217 18 51 293 INVXL $T=4224000 453600 0 180 $X=4206500 $Y=397800
X13 240 51 109 241 18 237 OAI21XL $T=1372800 655200 1 0 $X=1368500 $Y=599400
X14 221 51 62 242 18 239 OAI21XL $T=1412400 554400 1 180 $X=1381700 $Y=550400
X15 335 51 6 352 18 162 OAI21XL $T=1445400 352800 1 180 $X=1414700 $Y=348800
X16 244 51 5 333 18 238 OAI21XL $T=1445400 453600 1 180 $X=1414700 $Y=449600
X17 9 51 112 334 18 243 OAI21XL $T=1478400 453600 1 180 $X=1447700 $Y=449600
X18 224 51 14 222 18 223 OAI21XL $T=1531200 655200 0 180 $X=1500500 $Y=599400
X19 336 51 14 249 18 118 OAI21XL $T=1603800 453600 1 180 $X=1573100 $Y=449600
X20 252 51 14 337 18 255 OAI21XL $T=1636800 655200 1 0 $X=1632500 $Y=599400
X21 248 51 21 251 18 338 OAI21XL $T=1643400 554400 1 0 $X=1639100 $Y=498600
X22 14 51 253 256 18 254 OAI21XL $T=1656600 453600 0 0 $X=1652300 $Y=449600
X23 246 51 15 353 18 258 OAI21XL $T=1696200 554400 0 0 $X=1691900 $Y=550400
X24 119 51 22 167 18 121 OAI21XL $T=1716000 655200 1 0 $X=1711700 $Y=599400
X25 250 51 25 339 18 257 OAI21XL $T=1749000 554400 0 180 $X=1718300 $Y=498600
X26 26 51 262 263 18 340 OAI21XL $T=1881000 453600 0 0 $X=1876700 $Y=449600
X27 19 51 262 354 18 266 OAI21XL $T=1914000 453600 1 0 $X=1909700 $Y=397800
X28 270 51 69 40 18 264 OAI21XL $T=1980000 352800 1 180 $X=1949300 $Y=348800
X29 45 51 42 262 18 267 OAI21XL $T=1993200 453600 0 180 $X=1962500 $Y=397800
X30 270 51 53 229 18 269 OAI21XL $T=1999800 453600 0 0 $X=1995500 $Y=449600
X31 45 51 48 262 18 227 OAI21XL $T=1999800 554400 1 0 $X=1995500 $Y=498600
X32 53 51 48 125 18 228 OAI21XL $T=2046000 655200 0 180 $X=2015300 $Y=599400
X33 270 51 53 229 18 230 OAI21XL $T=2046000 554400 1 0 $X=2041700 $Y=498600
X34 201 51 96 91 18 291 OAI21XL $T=3227400 554400 1 180 $X=3196700 $Y=550400
X35 201 51 96 148 18 18 OAI21XL $T=3247200 554400 0 0 $X=3242900 $Y=550400
X36 323 51 316 350 18 326 OAI21XL $T=3900600 554400 0 0 $X=3896300 $Y=550400
X37 321 51 317 322 18 351 OAI21XL $T=3927000 453600 1 0 $X=3922700 $Y=397800
X38 330 51 235 328 18 325 OAI21XL $T=3986400 453600 1 180 $X=3955700 $Y=449600
X39 113 51 18 114 224 NAND2XL $T=1557600 655200 0 180 $X=1533500 $Y=599400
X40 113 51 18 165 252 NAND2XL $T=1590600 655200 1 0 $X=1586300 $Y=599400
X41 8 51 18 165 336 NAND2XL $T=1623600 554400 1 180 $X=1599500 $Y=550400
X42 114 51 18 8 253 NAND2XL $T=1630200 554400 0 0 $X=1625900 $Y=550400
X43 229 51 18 53 51 NAND2XL $T=2046000 554400 0 180 $X=2021900 $Y=498600
X44 59 51 18 174 271 NAND2XL $T=2072400 655200 0 180 $X=2048300 $Y=599400
X45 65 51 18 61 57 NAND2XL $T=2085600 453600 1 180 $X=2061500 $Y=449600
X46 124 51 18 64 345 NAND2XL $T=2092200 554400 1 0 $X=2087900 $Y=498600
X47 185 51 18 134 280 NAND2XL $T=2587200 352800 1 180 $X=2563100 $Y=348800
X48 187 51 18 134 347 NAND2XL $T=2620200 352800 1 180 $X=2596100 $Y=348800
X49 189 51 18 134 281 NAND2XL $T=2666400 352800 1 180 $X=2642300 $Y=348800
X50 190 51 18 134 278 NAND2XL $T=2692800 352800 1 180 $X=2668700 $Y=348800
X51 140 51 18 134 137 NAND2XL $T=2719200 352800 1 180 $X=2695100 $Y=348800
X52 139 51 18 134 277 NAND2XL $T=2745600 453600 0 0 $X=2741300 $Y=449600
X53 141 51 18 134 283 NAND2XL $T=2785200 352800 1 180 $X=2761100 $Y=348800
X54 85 51 18 134 279 NAND2XL $T=2805000 453600 1 180 $X=2780900 $Y=449600
X55 142 51 18 134 231 NAND2XL $T=2811600 352800 1 180 $X=2787500 $Y=348800
X56 289 51 18 134 285 NAND2XL $T=2871000 453600 0 180 $X=2846900 $Y=397800
X57 290 51 18 134 286 NAND2XL $T=2904000 554400 0 180 $X=2879900 $Y=498600
X58 295 51 18 134 287 NAND2XL $T=3003000 453600 1 180 $X=2978900 $Y=449600
X59 88 51 18 134 284 NAND2XL $T=3003000 554400 0 180 $X=2978900 $Y=498600
X60 96 51 18 151 148 NAND2XL $T=3306600 554400 1 180 $X=3282500 $Y=550400
X61 311 51 18 310 301 NAND2XL $T=3498000 453600 0 180 $X=3473900 $Y=397800
X62 321 51 18 317 322 NAND2XL $T=3880800 453600 0 0 $X=3876500 $Y=449600
X63 103 51 18 234 323 NAND2XL $T=3986400 554400 1 180 $X=3962300 $Y=550400
X64 329 51 18 104 213 NAND2XL $T=3999600 453600 0 0 $X=3995300 $Y=449600
X65 330 51 18 235 328 NAND2XL $T=4045800 453600 0 180 $X=4021700 $Y=397800
X66 144 348 51 18 89 XOR2XL $T=3082200 554400 1 0 $X=3077900 $Y=498600
X67 89 233 51 18 296 XOR2XL $T=3194400 554400 0 180 $X=3137300 $Y=498600
X68 288 309 51 18 144 XOR2XL $T=3491400 554400 0 180 $X=3434300 $Y=498600
X69 4 237 355 18 356 109 51 357 18 DFFSXL $T=1247400 554400 0 0 $X=1243100 $Y=550400
X70 4 239 358 18 359 62 51 360 18 DFFSXL $T=1260600 554400 1 0 $X=1256300 $Y=498600
X71 77 127 361 132 362 276 51 363 18 DFFSXL $T=2217600 453600 0 0 $X=2213300 $Y=449600
X72 77 126 364 132 365 273 51 366 18 DFFSXL $T=2224200 453600 1 0 $X=2219900 $Y=397800
X73 77 130 367 132 368 183 51 369 18 DFFSXL $T=2224200 655200 1 0 $X=2219900 $Y=599400
X74 77 180 180 132 370 275 51 371 18 DFFSXL $T=2230800 352800 0 0 $X=2226500 $Y=348800
X75 77 128 372 132 373 274 51 374 18 DFFSXL $T=2250600 554400 0 0 $X=2246300 $Y=550400
X76 77 133 375 132 376 272 51 377 18 DFFSXL $T=2343000 453600 0 0 $X=2338700 $Y=449600
X77 77 277 378 132 379 129 51 380 18 DFFSXL $T=2349600 655200 1 0 $X=2345300 $Y=599400
X78 77 280 381 132 382 79 51 383 18 DFFSXL $T=2435400 352800 0 0 $X=2431100 $Y=348800
X79 77 278 384 132 385 186 51 386 18 DFFSXL $T=2468400 453600 0 0 $X=2464100 $Y=449600
X80 77 279 387 132 388 84 51 389 18 DFFSXL $T=2468400 554400 1 0 $X=2464100 $Y=498600
X81 77 281 390 132 391 131 51 392 18 DFFSXL $T=2475000 655200 1 0 $X=2470700 $Y=599400
X82 77 347 393 132 394 188 51 395 18 DFFSXL $T=2567400 453600 1 0 $X=2563100 $Y=397800
X83 77 283 396 132 397 135 51 398 18 DFFSXL $T=2600400 453600 0 0 $X=2596100 $Y=449600
X84 77 231 399 132 400 191 51 401 18 DFFSXL $T=2600400 554400 1 0 $X=2596100 $Y=498600
X85 77 284 284 132 402 192 51 403 18 DFFSXL $T=2607000 554400 0 0 $X=2602700 $Y=550400
X86 77 285 404 18 405 82 51 406 18 DFFSXL $T=2706000 453600 1 0 $X=2701700 $Y=397800
X87 77 287 287 132 407 138 51 408 18 DFFSXL $T=2732400 554400 1 0 $X=2728100 $Y=498600
X88 77 286 409 132 410 136 51 411 18 DFFSXL $T=2739000 655200 1 0 $X=2734700 $Y=599400
X89 86 143 412 18 413 140 51 414 18 DFFSXL $T=2818200 352800 0 0 $X=2813900 $Y=348800
X90 86 292 415 18 416 290 51 417 18 DFFSXL $T=2923800 453600 1 0 $X=2919500 $Y=397800
X91 86 195 418 18 419 289 51 420 18 DFFSXL $T=2943600 352800 0 0 $X=2939300 $Y=348800
X92 86 297 421 18 422 295 51 423 18 DFFSXL $T=3069000 453600 1 0 $X=3064700 $Y=397800
X93 110 240 18 111 424 51 241 AOI21XL $T=1432200 655200 0 180 $X=1401500 $Y=599400
X94 110 221 18 111 425 51 242 AOI21XL $T=1445400 554400 1 180 $X=1414700 $Y=550400
X95 110 244 18 111 426 51 333 AOI21XL $T=1458600 554400 0 180 $X=1427900 $Y=498600
X96 110 9 18 111 427 51 334 AOI21XL $T=1491600 554400 0 180 $X=1460900 $Y=498600
X97 110 335 18 111 428 51 352 AOI21XL $T=1498200 352800 1 180 $X=1467500 $Y=348800
X98 110 116 18 111 429 51 163 AOI21XL $T=1518000 352800 0 0 $X=1513700 $Y=348800
X99 224 19 18 111 430 51 222 AOI21XL $T=1551000 554400 0 180 $X=1520300 $Y=498600
X100 110 13 18 111 431 51 164 AOI21XL $T=1557600 352800 0 0 $X=1553300 $Y=348800
X101 110 117 18 111 432 51 166 AOI21XL $T=1597200 352800 0 0 $X=1592900 $Y=348800
X102 110 248 18 111 433 51 251 AOI21XL $T=1630200 554400 0 180 $X=1599500 $Y=498600
X103 336 20 18 111 434 51 249 AOI21XL $T=1617000 453600 0 0 $X=1612700 $Y=449600
X104 110 246 18 111 435 51 353 AOI21XL $T=1656600 554400 0 0 $X=1652300 $Y=550400
X105 110 250 18 111 436 51 339 AOI21XL $T=1683000 554400 1 0 $X=1678700 $Y=498600
X106 252 34 18 111 437 51 337 AOI21XL $T=1709400 655200 0 180 $X=1678700 $Y=599400
X107 253 120 18 111 438 51 256 AOI21XL $T=1722600 453600 1 180 $X=1691900 $Y=449600
X108 60 123 18 51 439 51 50 AOI21XL $T=1999800 352800 0 0 $X=1995500 $Y=348800
X109 97 324 18 319 440 51 320 AOI21XL $T=3808200 453600 0 0 $X=3803900 $Y=449600
X110 211 155 18 157 441 51 100 AOI21XL $T=3874200 352800 0 0 $X=3869900 $Y=348800
X111 323 316 18 157 442 51 350 AOI21XL $T=3894000 554400 1 0 $X=3889700 $Y=498600
X112 212 328 18 234 443 51 329 AOI21XL $T=3927000 554400 1 0 $X=3922700 $Y=498600
X113 349 51 308 308 18 304 NAND2BXL $T=3385800 554400 0 180 $X=3355100 $Y=498600
X114 330 51 104 444 18 331 NAND2BXL $T=3993000 453600 1 0 $X=3988700 $Y=397800
X115 18 7 17 240 51 NOR2XL $T=1458600 655200 0 180 $X=1434500 $Y=599400
X116 18 7 245 221 51 NOR2XL $T=1465200 655200 1 0 $X=1460900 $Y=599400
X117 18 12 10 244 51 NOR2XL $T=1491600 554400 1 180 $X=1467500 $Y=550400
X118 18 11 10 335 51 NOR2XL $T=1518000 453600 1 180 $X=1493900 $Y=449600
X119 18 11 245 13 51 NOR2XL $T=1504800 554400 1 0 $X=1500500 $Y=498600
X120 18 12 245 246 51 NOR2XL $T=1511400 554400 0 0 $X=1507100 $Y=550400
X121 18 225 10 116 51 NOR2XL $T=1531200 453600 0 0 $X=1526900 $Y=449600
X122 18 10 247 117 51 NOR2XL $T=1551000 453600 0 0 $X=1546700 $Y=449600
X123 18 225 17 119 51 NOR2XL $T=1557600 655200 1 0 $X=1553300 $Y=599400
X124 18 11 17 248 51 NOR2XL $T=1570800 554400 1 0 $X=1566500 $Y=498600
X125 18 17 247 250 51 NOR2XL $T=1577400 554400 0 0 $X=1573100 $Y=550400
X126 18 42 70 55 51 NOR2XL $T=2059200 453600 1 180 $X=2035100 $Y=449600
X127 18 70 66 124 51 NOR2XL $T=2085600 453600 0 0 $X=2081300 $Y=449600
X128 18 62 68 68 51 NOR2XL $T=2118600 554400 1 0 $X=2114300 $Y=498600
X129 18 212 328 234 51 NOR2XL $T=3946800 554400 0 0 $X=3942500 $Y=550400
X130 227 34 268 51 445 261 18 OAI2BB1XL $T=1960200 554400 1 180 $X=1922900 $Y=550400
X131 311 310 51 301 18 205 OAI21X1 $T=3465000 352800 1 180 $X=3427700 $Y=348800
X132 27 51 18 261 51 340 260 AOI211XL $T=1867800 554400 1 0 $X=1863500 $Y=498600
X133 97 319 51 18 321 OR2XL $T=3795000 352800 0 0 $X=3790700 $Y=348800
X134 325 157 51 18 327 OR2XL $T=3913800 453600 0 0 $X=3909500 $Y=449600
X135 4 238 446 18 5 51 33 18 DFFSX1 $T=1260600 453600 0 0 $X=1256300 $Y=449600
X136 4 243 447 18 112 51 115 18 DFFSX1 $T=1392600 453600 1 0 $X=1388300 $Y=397800
X137 4 223 448 18 26 51 19 18 DFFSX1 $T=1524600 453600 1 0 $X=1520300 $Y=397800
X138 4 254 449 18 24 51 120 18 DFFSX1 $T=1643400 352800 0 0 $X=1639100 $Y=348800
X139 4 338 450 18 21 51 39 18 DFFSX1 $T=1663200 453600 1 0 $X=1658900 $Y=397800
X140 4 257 451 18 25 51 30 18 DFFSX1 $T=1867800 453600 1 180 $X=1738100 $Y=449600
X141 4 258 452 18 15 51 27 18 DFFSX1 $T=1867800 554400 1 180 $X=1738100 $Y=550400
X142 4 255 453 18 32 51 34 18 DFFSX1 $T=1755600 655200 1 0 $X=1751300 $Y=599400
X143 86 288 454 18 85 51 455 18 DFFSX1 $T=2824800 453600 0 0 $X=2820500 $Y=449600
X144 145 293 456 18 193 51 457 18 DFFSX1 $T=2996400 655200 0 180 $X=2866700 $Y=599400
X145 145 294 458 18 348 51 459 18 DFFSX1 $T=2963400 554400 0 0 $X=2959100 $Y=550400
X146 86 296 460 18 139 51 461 18 DFFSX1 $T=3029400 453600 0 0 $X=3025100 $Y=449600
X147 145 299 462 18 463 51 294 18 DFFSX1 $T=3082200 655200 1 0 $X=3077900 $Y=599400
X148 145 232 464 18 202 51 203 18 DFFSX1 $T=3207600 655200 1 0 $X=3203300 $Y=599400
X149 90 149 465 18 150 51 466 18 DFFSX1 $T=3214200 352800 0 0 $X=3209900 $Y=348800
X150 90 302 467 18 307 51 468 18 DFFSX1 $T=3253800 453600 0 0 $X=3249500 $Y=449600
X151 90 305 469 18 349 51 470 18 DFFSX1 $T=3339600 453600 1 0 $X=3335300 $Y=397800
X152 90 204 471 18 208 51 472 18 DFFSX1 $T=3392400 453600 0 0 $X=3388100 $Y=449600
X153 145 312 473 18 233 51 474 18 DFFSX1 $T=3504600 554400 0 0 $X=3500300 $Y=550400
X154 145 152 475 18 309 51 476 18 DFFSX1 $T=3504600 655200 1 0 $X=3500300 $Y=599400
X155 145 313 477 18 306 51 478 18 DFFSX1 $T=3511200 554400 1 0 $X=3506900 $Y=498600
X156 145 314 479 18 310 51 292 18 DFFSX1 $T=3524400 352800 0 0 $X=3520100 $Y=348800
X157 145 315 480 18 311 51 481 18 DFFSX1 $T=3524400 453600 1 0 $X=3520100 $Y=397800
X158 145 316 482 18 483 51 210 18 DFFSX1 $T=3636600 554400 0 0 $X=3632300 $Y=550400
X159 145 155 484 18 485 51 314 18 DFFSX1 $T=3656400 352800 0 0 $X=3652100 $Y=348800
X160 145 154 486 18 487 51 315 18 DFFSX1 $T=3656400 453600 1 0 $X=3652100 $Y=397800
X161 145 317 488 18 489 51 313 18 DFFSX1 $T=3656400 453600 0 0 $X=3652100 $Y=449600
X162 145 325 490 18 491 51 312 18 DFFSX1 $T=3762000 554400 0 0 $X=3757700 $Y=550400
X163 145 318 492 18 493 51 153 18 DFFSX1 $T=3768600 655200 1 0 $X=3764300 $Y=599400
X164 98 320 494 18 324 51 495 18 DFFSX1 $T=3795000 453600 1 0 $X=3790700 $Y=397800
X165 98 351 496 18 497 51 317 18 DFFSX1 $T=3933600 352800 0 0 $X=3929300 $Y=348800
X166 105 326 498 18 236 51 316 18 DFFSX1 $T=4019400 655200 1 0 $X=4015100 $Y=599400
X167 105 327 499 18 235 51 500 18 DFFSX1 $T=4045800 453600 0 0 $X=4041500 $Y=449600
X168 105 332 501 18 103 51 158 18 DFFSX1 $T=4045800 554400 1 0 $X=4041500 $Y=498600
X169 105 331 502 18 330 51 503 18 DFFSX1 $T=4059000 352800 0 0 $X=4054700 $Y=348800
X170 31 18 58 21 264 354 51 AOI22XL $T=1874400 453600 1 0 $X=1870100 $Y=397800
X171 267 18 5 15 51 341 51 AOI22XL $T=1920600 554400 1 180 $X=1883300 $Y=550400
X172 38 18 58 39 264 259 51 AOI22XL $T=1933800 352800 1 180 $X=1896500 $Y=348800
X173 228 18 22 32 227 342 51 AOI22XL $T=1966800 655200 0 180 $X=1929500 $Y=599400
X174 33 18 267 49 269 263 51 AOI22XL $T=1947000 453600 0 0 $X=1942700 $Y=449600
X175 271 18 29 228 41 268 51 AOI22XL $T=1999800 554400 1 180 $X=1962500 $Y=550400
X176 230 18 173 44 271 265 51 AOI22XL $T=1999800 655200 0 180 $X=1962500 $Y=599400
X177 96 18 307 93 306 302 51 AOI22XL $T=3366000 554400 1 180 $X=3328700 $Y=550400
X178 316 18 103 236 158 318 51 AOI22XL $T=3986400 655200 0 180 $X=3949100 $Y=599400
X179 272 3 51 18 CLKBUFX3 $T=2171400 554400 0 180 $X=2140700 $Y=498600
X180 71 102 51 18 CLKBUFX3 $T=2158200 453600 1 0 $X=2153900 $Y=397800
X181 46 101 51 18 CLKBUFX3 $T=2158200 453600 0 0 $X=2153900 $Y=449600
X182 274 2 51 18 CLKBUFX3 $T=2204400 655200 0 180 $X=2173700 $Y=599400
X183 177 94 51 18 CLKBUFX3 $T=2217600 554400 1 0 $X=2213300 $Y=498600
X184 259 51 172 260 47 122 18 NAND4XL $T=1861200 352800 0 0 $X=1856900 $Y=348800
X185 95 18 18 51 CLKINVX4 $T=3418800 655200 0 180 $X=3388100 $Y=599400
X186 273 18 51 108 CLKBUFX2 $T=2204400 554400 0 180 $X=2173700 $Y=498600
X187 275 18 51 107 CLKBUFX2 $T=2217600 352800 1 180 $X=2186900 $Y=348800
X188 276 18 51 75 CLKBUFX2 $T=2217600 554400 1 180 $X=2186900 $Y=550400
X189 194 18 51 146 CLKBUFX2 $T=2943600 554400 1 0 $X=2939300 $Y=498600
X190 196 18 51 197 CLKBUFX2 $T=3022800 554400 1 0 $X=3018500 $Y=498600
X191 341 51 342 18 265 226 NAND3XL $T=1894200 655200 1 0 $X=1889900 $Y=599400
X192 64 51 61 18 60 59 NAND3XL $T=2112000 453600 0 180 $X=2081300 $Y=397800
X193 63 51 64 18 125 45 NAND3XL $T=2118600 655200 0 180 $X=2087900 $Y=599400
X194 63 51 125 18 72 73 NAND3XL $T=2145000 655200 1 0 $X=2140700 $Y=599400
X195 66 51 70 18 48 NAND2X1 $T=2145000 554400 1 180 $X=2120900 $Y=550400
X196 150 18 148 147 51 NOR2BXL $T=3234000 453600 0 180 $X=3203300 $Y=397800
X197 282 145 51 18 77 AND2X4 $T=2567400 554400 0 0 $X=2563100 $Y=550400
X198 64 42 51 345 18 48 54 OAI211XL $T=2105400 554400 1 180 $X=2061500 $Y=550400
X199 308 151 51 304 18 96 305 OAI211XL $T=3352800 554400 0 180 $X=3308900 $Y=498600
X200 234 103 51 323 18 104 332 OAI211XL $T=3953400 554400 1 0 $X=3949100 $Y=498600
X201 298 18 145 51 86 AND2X2 $T=3069000 352800 0 0 $X=3064700 $Y=348800
X202 303 18 145 51 90 AND2X2 $T=3379200 352800 0 0 $X=3374900 $Y=348800
X203 226 18 266 51 36 343 NOR3XL $T=1907400 554400 1 0 $X=1903100 $Y=498600
X204 300 18 301 51 198 297 NOR3XL $T=3115200 352800 0 0 $X=3110900 $Y=348800
X205 18 66 175 40 51 NOR2X1 $T=2079000 352800 1 180 $X=2054900 $Y=348800
X206 18 66 56 60 51 NOR2X1 $T=2125200 352800 1 180 $X=2101100 $Y=348800
X207 145 504 291 505 282 51 18 TLATNXL $T=2890800 554400 0 0 $X=2886500 $Y=550400
X208 145 506 92 507 298 51 18 TLATNXL $T=3174600 453600 0 0 $X=3170300 $Y=449600
X209 145 508 18 509 303 51 18 TLATNXL $T=3227400 554400 1 0 $X=3223100 $Y=498600
X210 72 67 69 51 18 NAND2X2 $T=2112000 453600 0 0 $X=2107700 $Y=449600
X211 67 64 176 51 18 NAND2X2 $T=2118600 453600 1 0 $X=2114300 $Y=397800
X212 324 51 99 18 156 157 NAND3X1 $T=3874200 453600 1 180 $X=3843500 $Y=449600
X213 214 106 18 51 105 AND2X1 $T=4045800 554400 0 0 $X=4041500 $Y=550400
X214 235 212 212 18 235 299 51 AOI2BB2XL $T=3946800 655200 0 180 $X=3896300 $Y=599400
X215 171 24 51 25 170 169 18 OAI22XL $T=1848000 352800 1 180 $X=1804100 $Y=348800
X216 50 112 51 40 6 168 18 OAI22XL $T=1848000 453600 0 180 $X=1804100 $Y=397800
X217 343 35 344 18 43 51 52 AOI31XL $T=1953600 554400 1 0 $X=1949300 $Y=498600
X218 42 53 51 58 18 262 AOI2BB1XL $T=2059200 453600 0 180 $X=2021900 $Y=397800
X219 304 150 51 148 18 92 AOI2BB1XL $T=3313200 453600 0 180 $X=3275900 $Y=397800
X220 206 143 288 207 51 18 MXI2X1 $T=3425400 655200 1 0 $X=3421100 $Y=599400
X221 306 307 306 307 51 18 308 OAI2BB2XL $T=3432000 554400 1 180 $X=3381500 $Y=550400
X222 304 199 200 300 147 18 51 NAND4BXL $T=3201000 352800 1 180 $X=3157100 $Y=348800
X223 346 61 72 51 18 68 AND3X1 $T=2151600 554400 0 0 $X=2147300 $Y=550400
.ENDS
***************************************
.SUBCKT AOI2BB2X1 A1N A0N B1 B0 VDD VSS Y
** N=11 EP=7 IP=0 FDC=10
M0 9 A1N VSS VSS n18 L=1.8e-07 W=3e-07 $X=4600 $Y=13950 $D=6
M1 VSS A0N 9 VSS n18 L=1.8e-07 W=3e-07 $X=12600 $Y=13950 $D=6
M2 10 B1 VSS VSS n18 L=1.8e-07 W=8e-07 $X=18600 $Y=8950 $D=6
M3 Y B0 10 VSS n18 L=1.8e-07 W=8e-07 $X=24200 $Y=8950 $D=6
M4 VSS 9 Y VSS n18 L=1.8e-07 W=6e-07 $X=31400 $Y=8950 $D=6
M5 11 A1N VDD VDD p18 L=1.8e-07 W=5.6e-07 $X=4600 $Y=30400 $D=10
M6 9 A0N 11 VDD p18 L=1.8e-07 W=5.6e-07 $X=10200 $Y=30400 $D=10
M7 VDD B1 8 VDD p18 L=1.83034e-07 W=1.19814e-06 $X=22800 $Y=38450 $D=10
M8 8 B0 VDD VDD p18 L=1.83034e-07 W=1.19814e-06 $X=29200 $Y=33050 $D=10
M9 Y 9 8 VDD p18 L=1.83034e-07 W=1.19814e-06 $X=35600 $Y=38450 $D=10
.ENDS
***************************************
.SUBCKT OAI22X2 B1 VSS B0 A1 VDD A0 Y
** N=12 EP=7 IP=0 FDC=16
M0 VSS B0 8 VSS n18 L=1.8e-07 W=7.8e-07 $X=6200 $Y=10550 $D=6
M1 8 B1 VSS VSS n18 L=1.8e-07 W=7.8e-07 $X=12200 $Y=10550 $D=6
M2 VSS B1 8 VSS n18 L=1.8e-07 W=7.8e-07 $X=19400 $Y=10550 $D=6
M3 8 B0 VSS VSS n18 L=1.8e-07 W=7.8e-07 $X=25400 $Y=10550 $D=6
M4 Y A0 8 VSS n18 L=1.8e-07 W=7.8e-07 $X=32600 $Y=10550 $D=6
M5 8 A1 Y VSS n18 L=1.8e-07 W=7.8e-07 $X=39800 $Y=10550 $D=6
M6 Y A1 8 VSS n18 L=1.8e-07 W=7.8e-07 $X=45800 $Y=10550 $D=6
M7 8 A0 Y VSS n18 L=1.8e-07 W=7.8e-07 $X=53000 $Y=10550 $D=6
M8 9 B0 Y VDD p18 L=1.8e-07 W=1.2e-06 $X=6200 $Y=29450 $D=10
M9 VDD B1 9 VDD p18 L=1.8e-07 W=1.2e-06 $X=12200 $Y=29450 $D=10
M10 10 B1 VDD VDD p18 L=1.8e-07 W=1.2e-06 $X=19400 $Y=29450 $D=10
M11 Y B0 10 VDD p18 L=1.8e-07 W=1.2e-06 $X=25100 $Y=29450 $D=10
M12 11 A0 Y VDD p18 L=1.8e-07 W=1.2e-06 $X=32300 $Y=29450 $D=10
M13 VDD A1 11 VDD p18 L=1.8e-07 W=1.2e-06 $X=37900 $Y=29450 $D=10
M14 12 A1 VDD VDD p18 L=1.8e-07 W=1.2e-06 $X=45100 $Y=29450 $D=10
M15 Y A0 12 VDD p18 L=1.8e-07 W=1.2e-06 $X=50700 $Y=29450 $D=10
.ENDS
***************************************
.SUBCKT ICV_11 2 3 4 5 6 7 8 9 10 11 12 13 14 15 16 17 18 19 20 21
+ 22 23 24 25 26 27 28 29 30 31 32 33 34 35 36 37 38 39 40 41
+ 42 43 44 45 46 47 48 49 50 51 52 53 54 55 56 57 58 59 60 61
+ 62 63 64 65 66 67 68 69 70 71 72 73 74 75 76 77 78 79 80 81
+ 82 83 84 85 86 87 88 89 90 91 92 93 94 95 96 97 98 99 100 101
+ 102 103 104 105 106 107 108 109 110 111 112 114 115 116 117 118 120 121 122 123
+ 124 125 126 127 128 129 130 132 134 135 136 137 138 139 140 141 142 143 144 145
+ 146 147 148 149 150 151 152 153 154 155 156 157 158 159 160 161 162 163 164 165
+ 166 168 169 170 171
*.CALIBRE ICV_CELL 2
** N=434 EP=165 IP=1490 FDC=2430
M0 93 345 135 135 n18 L=1.8e-07 W=5.8e-07 $X=1959450 $Y=336500 $D=6
M1 135 90 93 135 n18 L=1.8e-07 W=5.8e-07 $X=1966700 $Y=336500 $D=6
M2 345 148 135 135 n18 L=1.8e-07 W=3e-07 $X=1972700 $Y=336500 $D=6
M3 135 49 345 135 n18 L=1.8e-07 W=3e-07 $X=1979500 $Y=341700 $D=6
M4 135 229 346 135 n18 L=1.8e-07 W=8e-07 $X=2098400 $Y=59350 $D=6
M5 346 44 135 135 n18 L=1.8e-07 W=8e-07 $X=2106400 $Y=59350 $D=6
M6 174 190 346 135 n18 L=1.8e-07 W=8e-07 $X=2113600 $Y=59350 $D=6
M7 346 48 174 135 n18 L=1.8e-07 W=8e-07 $X=2120800 $Y=59350 $D=6
M8 348 330 253 135 n18 L=1.8e-07 W=5.6e-07 $X=2679200 $Y=135400 $D=6
M9 135 11 348 135 n18 L=1.8e-07 W=5.6e-07 $X=2686400 $Y=135400 $D=6
M10 348 270 135 135 n18 L=1.8e-07 W=5.6e-07 $X=2692400 $Y=135400 $D=6
M11 135 263 348 135 n18 L=1.8e-07 W=5.6e-07 $X=2699600 $Y=135400 $D=6
M12 66 350 135 135 n18 L=1.8567e-07 W=1.20213e-06 $X=3504350 $Y=62100 $D=6
M13 135 350 66 135 n18 L=1.8567e-07 W=1.20213e-06 $X=3511450 $Y=57200 $D=6
M14 66 350 135 135 n18 L=1.8567e-07 W=1.20213e-06 $X=3518550 $Y=62100 $D=6
M15 135 350 66 135 n18 L=1.8567e-07 W=1.20213e-06 $X=3525750 $Y=57200 $D=6
M16 66 350 135 135 n18 L=1.8567e-07 W=1.20213e-06 $X=3532850 $Y=62100 $D=6
M17 135 350 66 135 n18 L=1.8567e-07 W=1.20213e-06 $X=3539950 $Y=57200 $D=6
M18 66 350 135 135 n18 L=1.8567e-07 W=1.20213e-06 $X=3547050 $Y=62100 $D=6
M19 135 350 66 135 n18 L=1.8567e-07 W=1.20213e-06 $X=3554150 $Y=57200 $D=6
M20 135 351 350 135 n18 L=1.85401e-07 W=1.26213e-06 $X=3568350 $Y=56600 $D=6
M21 350 351 135 135 n18 L=1.85401e-07 W=1.26213e-06 $X=3575450 $Y=62800 $D=6
M22 135 351 350 135 n18 L=1.85401e-07 W=1.26213e-06 $X=3582550 $Y=56600 $D=6
M23 351 84 135 135 n18 L=1.86081e-07 W=1.27042e-06 $X=3589650 $Y=62800 $D=6
M24 135 84 351 135 n18 L=1.8e-07 W=2.3e-07 $X=3597350 $Y=66300 $D=6
M25 429 345 93 84 p18 L=1.8e-07 W=1.18e-06 $X=1961350 $Y=308100 $D=10
M26 84 90 429 84 p18 L=1.8e-07 W=1.18e-06 $X=1967000 $Y=308100 $D=10
M27 430 148 84 84 p18 L=1.8e-07 W=5.6e-07 $X=1973000 $Y=314300 $D=10
M28 345 49 430 84 p18 L=1.8e-07 W=5.6e-07 $X=1978600 $Y=314300 $D=10
M29 431 229 84 84 p18 L=1.8e-07 W=1.2e-06 $X=2098800 $Y=79850 $D=10
M30 174 44 431 84 p18 L=1.8e-07 W=1.2e-06 $X=2104400 $Y=79850 $D=10
M31 432 190 174 84 p18 L=1.8e-07 W=1.2e-06 $X=2111600 $Y=79850 $D=10
M32 84 48 432 84 p18 L=1.8e-07 W=1.2e-06 $X=2117200 $Y=79850 $D=10
M33 253 330 84 84 p18 L=1.8e-07 W=6.4e-07 $X=2681200 $Y=114400 $D=10
M34 433 11 253 84 p18 L=1.8e-07 W=9.8e-07 $X=2688400 $Y=111000 $D=10
M35 434 270 433 84 p18 L=1.8e-07 W=9.8e-07 $X=2694000 $Y=111000 $D=10
M36 84 263 434 84 p18 L=1.8e-07 W=9.8e-07 $X=2699600 $Y=111000 $D=10
M37 66 350 84 84 p18 L=1.83793e-07 W=1.79713e-06 $X=3504350 $Y=77600 $D=10
M38 84 350 66 84 p18 L=1.83793e-07 W=1.79713e-06 $X=3511450 $Y=90300 $D=10
M39 66 350 84 84 p18 L=1.83793e-07 W=1.79713e-06 $X=3518550 $Y=77600 $D=10
M40 84 350 66 84 p18 L=1.83793e-07 W=1.79713e-06 $X=3525750 $Y=90300 $D=10
M41 66 350 84 84 p18 L=1.83793e-07 W=1.79713e-06 $X=3532850 $Y=77600 $D=10
M42 84 350 66 84 p18 L=1.83793e-07 W=1.79713e-06 $X=3539950 $Y=90300 $D=10
M43 66 350 84 84 p18 L=1.83793e-07 W=1.79713e-06 $X=3547050 $Y=77600 $D=10
M44 84 350 66 84 p18 L=1.83793e-07 W=1.79713e-06 $X=3554150 $Y=90300 $D=10
M45 84 351 350 84 p18 L=1.83825e-07 W=1.78213e-06 $X=3568350 $Y=90350 $D=10
M46 350 351 84 84 p18 L=1.83825e-07 W=1.78213e-06 $X=3575450 $Y=77600 $D=10
M47 84 351 350 84 p18 L=1.83825e-07 W=1.78213e-06 $X=3582550 $Y=90400 $D=10
M48 351 84 84 84 p18 L=1.83761e-07 W=1.81213e-06 $X=3589650 $Y=77600 $D=10
M49 84 84 351 84 p18 L=1.8e-07 W=3.9e-07 $X=3597350 $Y=80500 $D=10
X50 181 84 135 179 INVXL $T=1828200 151200 0 180 $X=1810700 $Y=95400
X51 37 84 135 228 INVXL $T=2006400 252000 0 0 $X=2002100 $Y=248000
X52 34 84 135 149 INVXL $T=2019600 352800 1 0 $X=2015300 $Y=297000
X53 105 84 135 154 INVXL $T=2296800 252000 0 180 $X=2279300 $Y=196200
X54 239 84 135 240 INVXL $T=2422200 50400 1 180 $X=2404700 $Y=46400
X55 256 84 135 328 INVXL $T=2567400 50400 1 180 $X=2549900 $Y=46400
X56 195 84 135 254 INVXL $T=2593800 151200 1 180 $X=2576300 $Y=147200
X57 175 84 135 329 INVXL $T=2613600 50400 0 180 $X=2596100 $Y=-5400
X58 198 84 135 257 INVXL $T=2646600 252000 1 180 $X=2629100 $Y=248000
X59 196 84 135 198 INVXL $T=2725800 252000 0 180 $X=2708300 $Y=196200
X60 200 84 135 265 INVXL $T=2745600 50400 0 180 $X=2728100 $Y=-5400
X61 332 84 135 270 INVXL $T=2772000 50400 0 180 $X=2754500 $Y=-5400
X62 114 84 135 267 INVXL $T=2772000 151200 1 0 $X=2767700 $Y=95400
X63 273 84 135 272 INVXL $T=2791800 151200 0 0 $X=2787500 $Y=147200
X64 166 84 135 277 INVXL $T=3319800 252000 0 0 $X=3315500 $Y=248000
X65 282 84 135 202 INVXL $T=3346200 151200 1 180 $X=3328700 $Y=147200
X66 283 84 135 279 INVXL $T=3352800 252000 0 180 $X=3335300 $Y=196200
X67 280 84 135 284 INVXL $T=3352800 50400 0 0 $X=3348500 $Y=46400
X68 289 84 135 291 INVXL $T=3537600 252000 1 0 $X=3533300 $Y=196200
X69 337 84 135 288 INVXL $T=3610200 151200 1 0 $X=3605900 $Y=95400
X70 130 84 135 170 INVXL $T=4177800 352800 0 180 $X=4160300 $Y=297000
X71 132 84 135 171 INVXL $T=4217400 352800 0 180 $X=4199900 $Y=297000
X72 140 135 85 139 84 208 OAI21XL $T=1570800 352800 0 180 $X=1540100 $Y=297000
X73 142 135 14 141 84 314 OAI21XL $T=1597200 252000 1 180 $X=1566500 $Y=248000
X74 143 135 215 144 84 316 OAI21XL $T=1597200 352800 1 0 $X=1592900 $Y=297000
X75 242 135 240 322 84 321 OAI21XL $T=2376000 50400 0 0 $X=2371700 $Y=46400
X76 259 135 261 347 84 161 OAI21XL $T=2620200 352800 1 0 $X=2615900 $Y=297000
X77 195 135 271 175 84 331 OAI21XL $T=2666400 151200 0 0 $X=2662100 $Y=147200
X78 267 135 271 256 84 330 OAI21XL $T=2699400 50400 1 180 $X=2668700 $Y=46400
X79 274 135 61 60 84 332 OAI21XL $T=2811600 252000 0 180 $X=2780900 $Y=196200
X80 279 135 122 334 84 165 OAI21XL $T=3339600 352800 0 180 $X=3308900 $Y=297000
X81 301 135 307 304 84 295 OAI21XL $T=3821400 151200 0 0 $X=3817100 $Y=147200
X82 128 135 127 69 84 340 OAI21XL $T=3854400 352800 0 180 $X=3823700 $Y=297000
X83 172 135 84 137 CLKBUFXL $T=1346400 50400 0 180 $X=1315700 $Y=-5400
X84 14 135 84 221 180 NAND2XL $T=1808400 252000 0 0 $X=1804100 $Y=248000
X85 93 135 84 37 218 NAND2XL $T=1841400 352800 0 180 $X=1817300 $Y=297000
X86 49 135 84 22 221 NAND2XL $T=1867800 252000 0 180 $X=1843700 $Y=196200
X87 33 135 84 228 216 NAND2XL $T=1980000 252000 0 180 $X=1955900 $Y=196200
X88 42 135 84 33 219 NAND2XL $T=1999800 252000 1 180 $X=1975700 $Y=248000
X89 96 135 84 228 227 NAND2XL $T=1999800 252000 1 0 $X=1995500 $Y=196200
X90 42 135 84 149 185 NAND2XL $T=2052600 252000 1 180 $X=2028500 $Y=248000
X91 45 135 84 96 224 NAND2XL $T=2059200 252000 0 180 $X=2035100 $Y=196200
X92 96 135 84 97 183 NAND2XL $T=2059200 352800 0 180 $X=2035100 $Y=297000
X93 97 135 84 33 177 NAND2XL $T=2072400 352800 1 0 $X=2068100 $Y=297000
X94 45 135 84 33 182 NAND2XL $T=2098800 252000 1 180 $X=2074700 $Y=248000
X95 319 135 84 106 155 NAND2XL $T=2316600 151200 1 180 $X=2292500 $Y=147200
X96 320 135 84 106 153 NAND2XL $T=2336400 252000 0 180 $X=2312300 $Y=196200
X97 321 135 84 106 156 NAND2XL $T=2369400 252000 0 180 $X=2345300 $Y=196200
X98 323 135 84 106 157 NAND2XL $T=2402400 252000 0 180 $X=2378300 $Y=196200
X99 242 135 84 240 322 NAND2XL $T=2409000 50400 0 180 $X=2384900 $Y=-5400
X100 245 135 84 106 238 NAND2XL $T=2435400 252000 0 180 $X=2411300 $Y=196200
X101 325 135 84 106 160 NAND2XL $T=2461800 252000 1 180 $X=2437700 $Y=248000
X102 246 135 84 106 159 NAND2XL $T=2475000 252000 0 180 $X=2450900 $Y=196200
X103 251 135 84 250 242 NAND2XL $T=2501400 50400 0 180 $X=2477300 $Y=-5400
X104 326 135 84 106 247 NAND2XL $T=2534400 252000 1 180 $X=2510300 $Y=248000
X105 254 135 84 248 327 NAND2XL $T=2580600 151200 1 180 $X=2556500 $Y=147200
X106 259 135 84 261 347 NAND2XL $T=2580600 352800 1 0 $X=2576300 $Y=297000
X107 260 135 84 265 250 NAND2XL $T=2620200 50400 1 0 $X=2615900 $Y=-5400
X108 195 135 84 271 199 NAND2XL $T=2640000 151200 0 0 $X=2635700 $Y=147200
X109 199 135 84 114 264 NAND2XL $T=2699400 151200 0 0 $X=2695100 $Y=147200
X110 11 135 84 268 269 NAND2XL $T=2732400 252000 1 180 $X=2708300 $Y=248000
X111 271 135 84 114 263 NAND2XL $T=2752200 151200 1 0 $X=2747900 $Y=95400
X112 267 135 84 272 266 NAND2XL $T=2798400 151200 1 0 $X=2794100 $Y=95400
X113 114 135 84 11 349 NAND2XL $T=2824800 352800 0 180 $X=2800700 $Y=297000
X114 335 135 84 202 280 NAND2XL $T=3333000 50400 0 0 $X=3328700 $Y=46400
X115 284 135 84 285 283 NAND2XL $T=3392400 50400 0 0 $X=3388100 $Y=46400
X116 278 135 84 290 337 NAND2XL $T=3544200 151200 1 0 $X=3539900 $Y=95400
X117 291 135 84 124 282 NAND2XL $T=3570600 252000 1 180 $X=3546500 $Y=248000
X118 303 135 84 300 299 NAND2XL $T=3755400 252000 1 180 $X=3731300 $Y=248000
X119 307 135 84 301 304 NAND2XL $T=3874200 151200 1 180 $X=3850100 $Y=147200
X120 297 135 84 203 128 NAND2XL $T=3874200 352800 0 180 $X=3850100 $Y=297000
X121 341 135 84 70 306 NAND2XL $T=3900600 151200 0 0 $X=3896300 $Y=147200
X122 129 135 84 72 310 NAND2XL $T=3999600 151200 0 180 $X=3975500 $Y=95400
X123 193 239 135 84 245 XOR2XL $T=2455200 151200 0 0 $X=2450900 $Y=147200
X124 56 238 352 158 353 236 135 354 84 DFFSXL $T=2303400 252000 0 0 $X=2299100 $Y=248000
X125 56 247 355 158 356 237 135 357 84 DFFSXL $T=2435400 352800 1 0 $X=2431100 $Y=297000
X126 62 162 358 84 359 11 135 360 84 DFFSXL $T=2818200 252000 1 0 $X=2813900 $Y=196200
X127 62 163 361 84 362 59 135 363 84 DFFSXL $T=2838000 252000 0 0 $X=2833700 $Y=248000
X128 62 117 364 84 365 164 135 366 84 DFFSXL $T=2950200 252000 1 0 $X=2945900 $Y=196200
X129 62 118 367 84 368 64 135 369 84 DFFSXL $T=2976600 252000 0 0 $X=2972300 $Y=248000
X130 62 275 370 84 371 115 135 372 84 DFFSXL $T=3082200 252000 1 0 $X=3077900 $Y=196200
X131 263 199 84 329 373 135 193 AOI21XL $T=2633400 151200 1 180 $X=2602700 $Y=147200
X132 200 271 84 270 374 135 262 AOI21XL $T=2745600 151200 0 180 $X=2714900 $Y=95400
X133 198 59 84 201 375 135 273 AOI21XL $T=2745600 252000 1 0 $X=2741300 $Y=196200
X134 349 60 84 59 376 135 201 AOI21XL $T=2798400 352800 0 180 $X=2767700 $Y=297000
X135 279 122 84 166 377 135 334 AOI21XL $T=3280200 252000 0 0 $X=3275900 $Y=248000
X136 304 296 84 203 378 135 341 AOI21XL $T=3867600 252000 1 0 $X=3863300 $Y=196200
X137 266 135 332 379 84 249 NAND2BXL $T=2798400 50400 1 180 $X=2767700 $Y=46400
X138 274 135 61 380 84 200 NAND2BXL $T=2811600 151200 0 0 $X=2807300 $Y=147200
X139 278 135 277 381 84 276 NAND2BXL $T=3273600 151200 0 180 $X=3242900 $Y=95400
X140 307 135 70 382 84 342 NAND2BXL $T=3907200 252000 1 0 $X=3902900 $Y=196200
X141 84 49 37 181 135 NOR2XL $T=1907400 252000 1 180 $X=1883300 $Y=248000
X142 84 90 181 92 135 NOR2XL $T=1927200 252000 1 180 $X=1903100 $Y=248000
X143 84 195 329 256 135 NOR2XL $T=2600400 50400 0 180 $X=2576300 $Y=-5400
X144 84 248 175 261 135 NOR2XL $T=2580600 252000 1 0 $X=2576300 $Y=196200
X145 84 254 329 258 135 NOR2XL $T=2593800 151200 1 0 $X=2589500 $Y=95400
X146 84 196 261 261 135 NOR2XL $T=2633400 252000 1 180 $X=2609300 $Y=248000
X147 84 199 270 260 135 NOR2XL $T=2666400 50400 0 180 $X=2642300 $Y=-5400
X148 84 114 272 194 135 NOR2XL $T=2739000 151200 1 180 $X=2714900 $Y=147200
X149 84 114 196 268 135 NOR2XL $T=2758800 252000 1 180 $X=2734700 $Y=248000
X150 84 296 304 203 135 NOR2XL $T=3828000 252000 1 0 $X=3823700 $Y=196200
X151 63 70 72 135 383 311 84 OAI2BB1XL $T=4026000 352800 1 0 $X=4021700 $Y=297000
X152 11 268 135 269 84 195 OAI21X1 $T=2653200 252000 0 0 $X=2648900 $Y=248000
X153 19 90 84 91 135 146 147 AOI211XL $T=1768800 352800 1 0 $X=1764500 $Y=297000
X154 194 175 84 193 135 248 243 AOI211XL $T=2508000 151200 0 180 $X=2470700 $Y=95400
X155 248 254 84 253 135 252 241 AOI211XL $T=2547600 151200 0 180 $X=2510300 $Y=95400
X156 266 175 84 256 135 248 251 AOI211XL $T=2567400 50400 0 180 $X=2530100 $Y=-5400
X157 61 59 84 60 196 135 AOI21X1 $T=2712600 352800 1 0 $X=2708300 $Y=297000
X158 197 196 84 135 325 AND2XL $T=2514600 252000 0 180 $X=2483900 $Y=196200
X159 295 129 135 84 305 OR2XL $T=3966600 151200 1 180 $X=3935900 $Y=147200
X160 12 138 384 84 13 135 173 84 DFFSX1 $T=1399200 252000 0 0 $X=1394900 $Y=248000
X161 12 208 385 84 85 135 29 84 DFFSX1 $T=1412400 352800 1 0 $X=1408100 $Y=297000
X162 12 314 386 84 14 135 222 84 DFFSX1 $T=1524600 252000 1 0 $X=1520300 $Y=196200
X163 12 316 387 84 215 135 19 84 DFFSX1 $T=1636800 252000 0 0 $X=1632500 $Y=248000
X164 12 145 388 84 17 135 16 84 DFFSX1 $T=1650000 252000 1 0 $X=1645700 $Y=196200
X165 65 276 389 84 278 135 390 84 DFFSX1 $T=3194400 151200 0 0 $X=3190100 $Y=147200
X166 65 333 391 84 335 135 392 84 DFFSX1 $T=3214200 252000 1 0 $X=3209900 $Y=196200
X167 65 281 393 84 285 135 394 84 DFFSX1 $T=3346200 252000 0 0 $X=3341900 $Y=248000
X168 65 336 336 84 290 135 395 84 DFFSX1 $T=3359400 151200 0 0 $X=3355100 $Y=147200
X169 65 287 396 84 286 135 397 84 DFFSX1 $T=3498000 352800 0 180 $X=3368300 $Y=297000
X170 125 292 398 84 121 135 399 84 DFFSX1 $T=3524400 352800 1 0 $X=3520100 $Y=297000
X171 125 293 400 84 117 135 401 84 DFFSX1 $T=3557400 151200 0 0 $X=3553100 $Y=147200
X172 125 294 402 84 120 135 403 84 DFFSX1 $T=3564000 252000 1 0 $X=3559700 $Y=196200
X173 125 338 404 84 405 135 292 84 DFFSX1 $T=3663000 352800 1 0 $X=3658700 $Y=297000
X174 125 339 406 84 407 135 294 84 DFFSX1 $T=3689400 151200 0 0 $X=3685100 $Y=147200
X175 125 295 408 84 409 135 293 84 DFFSX1 $T=3709200 50400 0 0 $X=3704900 $Y=46400
X176 68 340 410 84 300 135 127 84 DFFSX1 $T=3814800 252000 0 0 $X=3810500 $Y=248000
X177 68 305 411 84 301 135 302 84 DFFSX1 $T=3841200 50400 0 0 $X=3836900 $Y=46400
X178 68 306 412 84 298 135 296 84 DFFSX1 $T=3847800 151200 1 0 $X=3843500 $Y=95400
X179 68 342 413 84 307 135 414 84 DFFSX1 $T=3966600 252000 1 0 $X=3962300 $Y=196200
X180 68 343 415 84 297 135 303 84 DFFSX1 $T=3973200 252000 0 0 $X=3968900 $Y=248000
X181 309 126 416 84 417 135 308 84 DFFSX1 $T=4118400 50400 1 180 $X=3988700 $Y=46400
X182 309 308 418 84 344 135 313 84 DFFSX1 $T=4098600 50400 1 0 $X=4094300 $Y=-5400
X183 309 313 419 84 312 135 420 84 DFFSX1 $T=4237200 151200 0 180 $X=4107500 $Y=95400
X184 218 84 17 215 90 26 135 AOI22XL $T=1768800 252000 0 0 $X=1764500 $Y=248000
X185 221 84 222 16 218 23 135 AOI22XL $T=1841400 252000 0 0 $X=1837100 $Y=248000
X186 267 84 258 262 197 244 135 AOI22XL $T=2653200 151200 0 180 $X=2615900 $Y=95400
X187 58 84 198 175 264 255 135 AOI22XL $T=2653200 252000 0 180 $X=2615900 $Y=196200
X188 303 84 298 297 296 338 135 AOI22XL $T=3748800 252000 0 180 $X=3711500 $Y=196200
X189 296 84 301 298 302 339 135 AOI22XL $T=3801600 151200 0 180 $X=3764300 $Y=95400
X190 127 84 297 300 303 168 135 AOI22XL $T=3828000 352800 0 180 $X=3790700 $Y=297000
X191 318 53 135 84 CLKBUFX3 $T=2204400 352800 1 0 $X=2200100 $Y=297000
X192 236 6 135 84 CLKBUFX3 $T=2263800 252000 1 180 $X=2233100 $Y=248000
X193 237 5 135 84 CLKBUFX3 $T=2277000 252000 0 180 $X=2246300 $Y=196200
X194 104 4 135 84 CLKBUFX3 $T=2303400 252000 1 180 $X=2272700 $Y=248000
X195 55 2 135 84 CLKBUFX3 $T=2310000 151200 0 180 $X=2279300 $Y=95400
X196 205 135 84 136 BUFX1 $T=1320000 50400 1 180 $X=1289300 $Y=46400
X197 176 135 84 86 BUFX1 $T=1716000 50400 0 180 $X=1685300 $Y=-5400
X198 317 135 84 95 BUFX1 $T=1894200 50400 1 0 $X=1889900 $Y=-5400
X199 34 135 84 184 BUFX1 $T=2019600 352800 0 180 $X=1988900 $Y=297000
X200 223 135 84 99 BUFX1 $T=2191200 50400 0 0 $X=2186900 $Y=46400
X201 233 135 84 10 BUFX1 $T=2303400 50400 1 0 $X=2299100 $Y=-5400
X202 71 135 84 309 BUFX1 $T=4184400 50400 1 180 $X=4153700 $Y=46400
X203 206 84 135 73 CLKBUFX2 $T=1359600 50400 1 180 $X=1328900 $Y=46400
X204 207 84 135 134 CLKBUFX2 $T=1405800 151200 0 180 $X=1375100 $Y=95400
X205 209 84 135 80 CLKBUFX2 $T=1485000 50400 0 180 $X=1454300 $Y=-5400
X206 210 84 135 76 CLKBUFX2 $T=1498200 50400 1 180 $X=1467500 $Y=46400
X207 211 84 135 74 CLKBUFX2 $T=1531200 151200 0 180 $X=1500500 $Y=95400
X208 212 84 135 75 CLKBUFX2 $T=1551000 50400 0 180 $X=1520300 $Y=-5400
X209 24 84 135 77 CLKBUFX2 $T=1564200 50400 1 180 $X=1533500 $Y=46400
X210 213 84 135 78 CLKBUFX2 $T=1590600 50400 0 180 $X=1559900 $Y=-5400
X211 214 84 135 81 CLKBUFX2 $T=1597200 50400 1 180 $X=1566500 $Y=46400
X212 315 84 135 79 CLKBUFX2 $T=1617000 151200 0 180 $X=1586300 $Y=95400
X213 217 84 135 82 CLKBUFX2 $T=1683000 50400 0 180 $X=1652300 $Y=-5400
X214 174 84 135 83 CLKBUFX2 $T=1848000 50400 0 180 $X=1817300 $Y=-5400
X215 186 84 135 87 CLKBUFX2 $T=1993200 50400 0 180 $X=1962500 $Y=-5400
X216 187 84 135 3 CLKBUFX2 $T=2112000 50400 0 180 $X=2081300 $Y=-5400
X217 225 84 135 98 CLKBUFX2 $T=2184600 50400 1 0 $X=2180300 $Y=-5400
X218 230 84 135 101 CLKBUFX2 $T=2217600 50400 1 0 $X=2213300 $Y=-5400
X219 191 84 135 102 CLKBUFX2 $T=2217600 50400 0 0 $X=2213300 $Y=46400
X220 232 84 135 103 CLKBUFX2 $T=2263800 50400 1 0 $X=2259500 $Y=-5400
X221 231 84 135 8 CLKBUFX2 $T=2263800 50400 0 0 $X=2259500 $Y=46400
X222 226 84 135 107 CLKBUFX2 $T=2296800 50400 0 0 $X=2292500 $Y=46400
X223 188 84 135 109 CLKBUFX2 $T=2336400 50400 0 0 $X=2332100 $Y=46400
X224 234 84 135 108 CLKBUFX2 $T=2343000 50400 1 0 $X=2338700 $Y=-5400
X225 192 84 135 9 CLKBUFX2 $T=2415600 50400 1 0 $X=2411300 $Y=-5400
X226 110 84 135 111 CLKBUFX2 $T=2422200 151200 0 0 $X=2417900 $Y=147200
X227 235 84 135 112 CLKBUFX2 $T=2448600 50400 1 0 $X=2444300 $Y=-5400
X228 266 84 256 260 135 252 259 AOI211X1 $T=2620200 50400 1 180 $X=2582900 $Y=46400
X229 47 135 150 84 96 189 NAND3XL $T=2118600 352800 1 0 $X=2114300 $Y=297000
X230 199 135 266 84 265 197 NAND3XL $T=2659800 50400 1 180 $X=2629100 $Y=46400
X231 290 135 286 84 278 289 NAND3XL $T=3517800 151200 0 0 $X=3513500 $Y=147200
X232 258 84 194 252 135 NOR2BXL $T=2580600 151200 0 180 $X=2549900 $Y=95400
X233 328 194 135 250 84 249 324 OAI211XL $T=2521200 50400 1 180 $X=2477300 $Y=46400
X234 328 271 135 327 84 255 326 OAI211XL $T=2560800 252000 0 180 $X=2516900 $Y=196200
X235 335 202 135 280 84 277 333 OAI211XL $T=3326400 50400 1 180 $X=3282500 $Y=46400
X236 285 284 135 283 84 277 281 OAI211XL $T=3372600 151200 0 180 $X=3328700 $Y=95400
X237 286 288 135 289 84 277 287 OAI211XL $T=3478200 252000 1 0 $X=3473900 $Y=196200
X238 290 278 135 337 84 277 336 OAI211XL $T=3524400 151200 0 180 $X=3480500 $Y=95400
X239 124 291 135 282 84 277 123 OAI211XL $T=3524400 252000 1 180 $X=3480500 $Y=248000
X240 297 203 135 128 84 70 343 OAI211XL $T=3894000 352800 1 0 $X=3889700 $Y=297000
X241 204 84 71 135 68 AND2X2 $T=3946800 252000 0 0 $X=3942500 $Y=248000
X242 84 249 200 248 135 NOR2X1 $T=2745600 50400 1 180 $X=2721500 $Y=46400
X243 84 274 273 271 135 NOR2X1 $T=2778600 151200 1 180 $X=2754500 $Y=147200
X244 309 421 311 422 169 135 84 TLATNXL $T=3999600 151200 0 0 $X=3995300 $Y=147200
X245 309 423 310 424 204 135 84 TLATNXL $T=4019400 50400 1 0 $X=4015100 $Y=-5400
X246 94 40 135 22 84 425 173 180 27 OAI221XL $T=1854600 352800 1 0 $X=1850300 $Y=297000
X247 265 270 135 84 175 NOR2X2 $T=2712600 50400 0 180 $X=2675300 $Y=-5400
X248 33 135 220 84 CLKINVX2 $T=2151600 151200 0 180 $X=2127500 $Y=95400
X249 33 135 229 84 CLKINVX2 $T=2151600 151200 1 0 $X=2147300 $Y=95400
X250 96 135 190 84 CLKINVX2 $T=2191200 252000 1 180 $X=2167100 $Y=248000
X251 96 135 178 84 CLKINVX2 $T=2230800 252000 1 180 $X=2206700 $Y=248000
X252 241 240 426 319 239 135 84 MXI2XL $T=2362800 151200 0 180 $X=2312300 $Y=95400
X253 243 240 243 320 239 135 84 MXI2XL $T=2382600 151200 1 180 $X=2332100 $Y=147200
X254 244 240 427 323 239 135 84 MXI2XL $T=2442000 151200 0 180 $X=2391500 $Y=95400
X255 324 239 428 246 240 135 84 MXI2XL $T=2475000 50400 1 180 $X=2424500 $Y=46400
X256 117 116 116 84 117 117 135 AOI2BB2XL $T=3154800 352800 0 180 $X=3104300 $Y=297000
X257 182 41 135 190 24 24 84 OAI22XL $T=1650000 50400 0 180 $X=1606100 $Y=-5400
X258 216 41 135 190 29 214 84 OAI22XL $T=1676400 50400 1 180 $X=1632500 $Y=46400
X259 216 184 135 190 15 315 84 OAI22XL $T=1689600 151200 1 180 $X=1645700 $Y=147200
X260 177 184 135 178 94 205 84 OAI22XL $T=1729200 50400 1 180 $X=1685300 $Y=46400
X261 216 89 135 178 39 206 84 OAI22XL $T=1749000 151200 1 180 $X=1705100 $Y=147200
X262 177 41 135 178 38 172 84 OAI22XL $T=1716000 50400 1 0 $X=1711700 $Y=-5400
X263 182 184 135 178 18 210 84 OAI22XL $T=1788600 151200 0 180 $X=1744700 $Y=95400
X264 219 89 135 178 16 207 84 OAI22XL $T=1801800 151200 1 180 $X=1757900 $Y=147200
X265 220 179 135 178 19 212 84 OAI22XL $T=1815000 50400 0 180 $X=1771100 $Y=-5400
X266 219 49 135 178 20 211 84 OAI22XL $T=1834800 252000 0 180 $X=1790900 $Y=196200
X267 219 41 135 190 32 209 84 OAI22XL $T=1801800 50400 0 0 $X=1797500 $Y=46400
X268 220 19 135 190 179 317 84 OAI22XL $T=1841400 50400 0 0 $X=1837100 $Y=46400
X269 220 94 135 184 183 223 84 OAI22XL $T=1841400 151200 1 0 $X=1837100 $Y=95400
X270 220 24 135 41 224 225 84 OAI22XL $T=1894200 50400 0 0 $X=1889900 $Y=46400
X271 220 18 135 184 224 191 84 OAI22XL $T=1900800 151200 1 0 $X=1896500 $Y=95400
X272 93 39 135 20 92 28 84 OAI22XL $T=1947000 352800 0 180 $X=1903100 $Y=297000
X273 229 185 135 190 31 213 84 OAI22XL $T=1980000 50400 1 180 $X=1936100 $Y=46400
X274 49 177 135 178 30 35 84 OAI22XL $T=1980000 252000 1 180 $X=1936100 $Y=248000
X275 220 15 135 184 227 226 84 OAI22XL $T=1947000 151200 1 0 $X=1942700 $Y=95400
X276 89 183 135 51 229 176 84 OAI22XL $T=1986600 151200 1 180 $X=1942700 $Y=147200
X277 220 38 135 41 183 230 84 OAI22XL $T=2032800 50400 1 180 $X=1988900 $Y=46400
X278 220 31 135 190 185 232 84 OAI22XL $T=2019600 50400 1 0 $X=2015300 $Y=-5400
X279 220 29 135 41 227 231 84 OAI22XL $T=2019600 151200 1 0 $X=2015300 $Y=95400
X280 43 229 135 190 7 217 84 OAI22XL $T=2092200 50400 1 180 $X=2048300 $Y=46400
X281 220 32 135 41 189 188 84 OAI22XL $T=2065800 151200 1 0 $X=2061500 $Y=95400
X282 49 182 135 178 173 318 84 OAI22XL $T=2158200 252000 1 180 $X=2114300 $Y=248000
X283 220 7 135 190 43 233 84 OAI22XL $T=2131800 50400 1 0 $X=2127500 $Y=-5400
X284 220 48 135 190 44 234 84 OAI22XL $T=2145000 50400 0 0 $X=2140700 $Y=46400
X285 177 89 135 190 51 151 84 OAI22XL $T=2145000 352800 1 0 $X=2140700 $Y=297000
X286 182 89 135 178 222 50 84 OAI22XL $T=2151600 252000 1 0 $X=2147300 $Y=196200
X287 229 54 135 190 52 186 84 OAI22XL $T=2217600 151200 0 180 $X=2173700 $Y=95400
X288 229 57 135 100 178 187 84 OAI22XL $T=2237400 252000 0 180 $X=2193500 $Y=196200
X289 229 52 135 178 54 192 84 OAI22XL $T=2217600 151200 1 0 $X=2213300 $Y=95400
X290 57 178 135 100 229 235 84 OAI22XL $T=2283600 151200 1 180 $X=2239700 $Y=147200
X291 312 313 72 344 135 84 MXI2X1 $T=4125000 151200 0 0 $X=4120700 $Y=147200
X292 195 248 331 264 135 84 58 OAI2BB2XL $T=2699400 252000 0 180 $X=2648900 $Y=196200
X293 302 298 307 67 299 84 135 NAND4BXL $T=3808200 252000 0 180 $X=3764300 $Y=196200
X294 11 59 114 135 84 274 AND3X1 $T=2805000 252000 1 180 $X=2767700 $Y=248000
X295 120 275 275 120 84 135 116 AOI2BB2X1 $T=3207600 252000 1 180 $X=3157100 $Y=248000
X296 121 118 118 121 84 135 275 AOI2BB2X1 $T=3267000 352800 0 180 $X=3216500 $Y=297000
X297 30 135 220 49 84 183 21 OAI22X2 $T=1867800 151200 1 180 $X=1804100 $Y=147200
X298 89 135 224 222 84 229 88 OAI22X2 $T=1940400 151200 1 180 $X=1876700 $Y=147200
X299 173 135 229 49 84 224 25 OAI22X2 $T=1953600 252000 0 180 $X=1889900 $Y=196200
X300 89 135 227 39 84 229 46 OAI22X2 $T=1999800 151200 0 0 $X=1995500 $Y=147200
X301 89 135 189 16 84 229 36 OAI22X2 $T=2125200 252000 0 180 $X=2061500 $Y=196200
X302 49 135 189 20 84 229 152 OAI22X2 $T=2131800 151200 0 0 $X=2127500 $Y=147200
X303 196 135 261 257 84 259 239 OAI22X2 $T=2607000 252000 1 180 $X=2543300 $Y=248000
.ENDS
***************************************
.SUBCKT sar_digi_paper_core clk w_wr_data[12] w_wr_data[20] w_wr_data[21] w_wr_data[22] w_wr_data[25] w_wr_data[23] w_wr_data[24] w_wr_data[27] w_wr_data[19] w_wr_data[28] w_wr_data[26] w_wr_addr[0] w_wr_addr[1] w_wr_data[18] w_wr_addr[4] dac_n_force[3] VDD w_wr_en raw_code_o[4]
+ raw_code_o[0] raw_code_o[2] raw_code_o[6] raw_code_o[3] raw_code_valid_o raw_code_o[7] raw_code_o[8] raw_code_o[9] raw_code_o[10] raw_code_o[1] calib_overrange calib_overrange_bits[18] raw_code_o[11] dac_n_force[0] raw_code_o[5] calib_overrange_bits[19] dac_n_force[2] dac_n_force[1] VSS calib_overrange_bits[17]
+ calib_overrange_bits[16] calib_overrange_bits[15] calib_overrange_bits[13] srm_start srm_decision_valid calib_overrange_bits[12] calib_overrange_bits[8] calib_overrange_bits[11] calib_overrange_bits[10] srm_ones_count[4] srm_residue_valid srm_done srm_busy residue_consume_i srm_decision_bit calib_overrange_bits[7] calib_overrange_bits[6] calib_overrange_bits[5] srm_total_count[3] srm_total_count[4]
+ srm_ones_count[0] srm_ones_count[1] srm_ones_count[3] srm_ones_count[2] calib_overrange_bits[0] calib_overrange_bits[1] srm_total_count[1] srm_total_count[0] srm_total_count[2] srm_count_shortfall srm_stalled srm_residue_o[8] srm_residue_o[7] start_calib dec_clk w_wr_data[8] w_wr_data[9] w_wr_data[10] w_wr_data[11] w_wr_data[13]
+ w_wr_data[14] w_wr_data[3] w_wr_data[4] w_wr_data[5] w_wr_data[6] w_wr_data[7] calib_overrange_bits[14] w_wr_data[0] w_wr_data[1] w_wr_data[2] calib_overrange_bits[9] calib_overrange_bits[2] calib_overrange_bits[3] calib_overrange_bits[4] raw_bits_i[17] raw_bits_i[18] raw_bits_i[19] data_valid_i raw_bits_i[12] raw_bits_i[13]
+ raw_bits_i[14] raw_bits_i[15] raw_bits_i[16] srm_residue_o[9] raw_bits_i[9] raw_bits_i[10] raw_bits_i[11] srm_residue_o[4] srm_residue_o[5] srm_residue_o[6] raw_bits_i[6] raw_bits_i[7] raw_bits_i[8] srm_residue_o[0] srm_residue_o[1] srm_residue_o[2] srm_residue_o[3] raw_bits_i[2] raw_bits_i[3] raw_bits_i[4]
+ raw_bits_i[5] w_wr_data[15] w_wr_data[16] w_wr_data[17] w_wr_data[29] w_wr_addr[2] w_wr_addr[3] raw_code_o[12] raw_code_o[13] raw_code_o[14] raw_code_o[15] raw_code_o[16] raw_code_o[17] raw_code_o[18] raw_code_o[19] raw_bits_i[0] raw_bits_i[1] calib_done calib_mode_en dac_n_force[4]
+ dac_n_force[5] dac_n_force[6] dac_n_force[7] dac_n_force[8] dac_n_force[9] dac_n_force[10] dac_n_force[11] dac_n_force[12] dac_n_force[13] dac_n_force[14] dac_n_force[15] dac_n_force[16] dac_n_force[17] dac_n_force[18] dac_n_force[19] dac_p_force[0] dac_p_force[1] dac_p_force[2] dac_p_force[3] dac_p_force[4]
+ dac_p_force[5] dac_p_force[6] dac_p_force[7] dac_p_force[8] dac_p_force[9] dac_p_force[10] dac_p_force[11] dac_p_force[12] dac_p_force[13] dac_p_force[14] dac_p_force[15] dac_p_force[16] dac_p_force[17] dac_p_force[18] dac_p_force[19] calib_done_pulse calib_comp_out
** N=1133 EP=177 IP=2869 FDC=50866
X0 1 7 13 14 20 623 26 43 624 29 5 w_wr_data[9] 12 6 8 9 10 11 261 15
+ 16 4 17 22 18 19 21 25 24 27 28 30 62 34 35 36 37 38 45 46
+ 47 48 49 50 51 52 54 55 56 57 635 58 60 61 63 64 65 216 66 67
+ 68 69 70 71 72 639 2 76 77 78 79 80 81 82 86 83 85 283 225 652
+ 89 97 87 88 VDD 92 93 94 96 98 99 100 101 102 103 104 105 106 107 108
+ 109 110 111 112 114 657 115 116 117 119 120 121 124 125 130 128 131 132 134 135
+ 136 137 138 140 142 143 230 148 149 151 152 153 154 156 157 159 160 161 164 162
+ 163 165 166 167 168 169 172 w_wr_data[8] w_wr_data[10] w_wr_data[11] w_wr_data[13] w_wr_data[14] w_wr_data[16] 258 273 621 622 227 626 187
+ 629 632 625 641 645 644 642 647 282 654 655 284 656 668 659 650 640 662 666 660
+ 664 VSS 673 232 raw_code_o[12] 675 raw_code_o[13] 663 raw_code_o[14] 403 raw_code_o[15] raw_code_o[16] 690 694 693 raw_bits_i[0] raw_code_o[18] 699 raw_code_o[19] w_wr_data[15]
+ 614 617 618 540 619 620 553 541 191 627 628 630 631 542 633 634 212 636 638 543
+ 289 648 649 651 653 544 658 661 545 665 667 546 669 670 671 672 677 678 547 679
+ 681 682 683 685 687 688 689 691 raw_code_o[17] 695 697 698 700 702 raw_bits_i[1]
+ ICV_2 $T=0 0 0 0 $X=-4300 $Y=3574000
X1 w_wr_data[7] 176 56 48 82 200 64 50 86 104 5 VDD 12 173 8 720 174 175 110 10
+ 258 177 273 4 98 6 178 179 180 619 181 11 182 553 183 187 13 184 185 186
+ 618 14 15 16 80 188 18 189 190 541 19 192 193 624 21 22 713 194 195 196
+ w_wr_data[12] 24 25 197 28 29 198 199 30 201 202 34 35 203 220 71 37 204 205 38
+ 45 206 722 43 207 208 47 62 209 49 210 51 52 211 54 55 57 58 213 60
+ 214 63 636 66 67 215 68 216 69 70 217 72 218 731 76 78 79 81 83 219
+ 282 283 543 221 222 223 224 225 226 87 289 89 88 97 227 92 284 93 94 96
+ 673 156 152 99 100 101 105 102 103 655 106 660 107 108 109 111 VSS 112 663 114
+ 228 666 115 659 116 117 119 120 121 124 125 545 668 229 128 230 130 131 132 134
+ 135 136 137 142 231 143 240 232 148 234 236 151 237 238 239 757 758 157 679 677
+ 682 242 243 167 169 244 245 246 247 695 250 251 w_wr_data[3] w_wr_data[4] w_wr_data[6] 706 614 261 707 540
+ 709 634 620 710 719 714 627 628 717 339 542 650 723 725 724 638 727 728 642 644
+ 729 734 639 732 735 649 648 651 653 658 657 544 744 740 661 662 665 667 555 669
+ 670 671 743 403 672 751 752 753 750 755 688 547 759 760 681 685 683 762 687 763
+ 702 772 320 765 771 776 773 778 705 708 617 621 w_wr_data[2] 622 712 623 711 625 552 626
+ 715 716 629 630 631 718 632 633 721 554 635 640 726 641 281 645 730 w_wr_addr[3] 733 736
+ 652 737 654 738 739 656 742 741 664 745 746 747 748 749 556 754 675 756 678 761
+ 689 690 691 764 693 694 698 699 766 767 321 700 768 769 770 774 775 777
+ ICV_3 $T=0 0 0 0 $X=-4300 $Y=3070400
X2 w_wr_data[1] 286 85 25 283 252 12 5 254 102 173 98 175 80 255 VDD 45 256 176 257
+ 258 259 177 4 56 261 179 86 21 10 6 181 262 263 183 213 184 264 220 15
+ 51 265 17 187 188 266 192 273 267 28 194 195 196 553 791 795 197 26 79 27
+ 22 268 198 199 200 269 w_wr_data[20] 201 w_wr_data[21] w_wr_data[22] 8 270 35 36 203 71 204 205 w_wr_data[25] w_wr_data[23]
+ 271 w_wr_data[24] 721 w_wr_data[19] 207 46 62 210 w_wr_data[28] 211 272 274 w_wr_data[26] 61 275 214 29 65 50 276
+ 217 w_wr_addr[0] w_wr_addr[1] w_wr_data[18] 277 278 279 83 280 282 219 647 w_wr_addr[4] 284 733 285 808 287 221 288
+ 89 225 289 290 291 224 108 292 293 294 227 97 66 295 296 297 298 299 VSS 300
+ 301 302 303 304 305 306 228 812 307 308 747 309 230 555 310 311 312 313 138 124
+ 314 140 822 231 315 316 232 243 317 142 556 234 236 403 240 238 239 819 318 159
+ 319 160 161 163 242 169 244 832 245 322 246 323 247 324 839 250 251 w_wr_data[0] 107 w_wr_data[5]
+ 705 779 706 780 552 781 708 338 788 713 719 783 787 712 346 339 797 729 798 554
+ 37 800 802 801 804 w_wr_addr[2] 730 737 655 94 736 810 738 400 657 811 739 742 349 815
+ 814 745 746 748 750 751 354 758 756 753 755 833 763 835 764 830 762 761 834 838
+ 772 768 766 767 837 840 769 770 775 773 778 110 707 782 709 710 784 785 786 711
+ 789 558 790 714 715 716 792 717 718 793 378 794 720 796 722 723 w_wr_data[17] 799 w_wr_data[29] 724
+ 725 726 803 727 728 805 731 806 732 807 734 735 809 740 741 743 744 813 816 817
+ 818 820 821 749 358 561 823 752 754 824 825 826 757 829 827 828 759 831 685 765
+ 836 771 563 774 776 777
+ ICV_5 $T=0 0 0 0 $X=-4300 $Y=2566400
X3 clk 329 230 252 265 254 187 780 174 338 80 255 330 45 256 257 VDD 259 1 706
+ 261 178 7 180 9 86 6 4 262 182 220 12 5 213 51 190 191 332 787 20
+ 193 333 10 175 267 558 334 79 273 553 336 8 793 337 270 854 206 798 w_wr_data[27] 62
+ 208 209 272 212 339 29 274 25 340 2 390 859 50 277 77 37 341 280 342 282
+ 83 287 288 222 344 89 226 108 105 435 345 346 97 295 152 350 299 305 347 812
+ 348 243 349 306 353 307 354 355 356 772 raw_code_valid_o 309 310 311 312 358 314 561 827 315
+ 359 raw_code_o[1] 316 360 361 317 824 362 124 363 VSS 364 232 365 142 237 366 367 369 403
+ 370 240 238 169 320 322 323 324 839 107 56 102 779 28 66 35 573 98 15 227
+ 782 789 845 784 790 786 791 849 851 559 378 796 855 794 800 799 856 803 392 805
+ 863 806 807 393 866 867 871 864 868 875 811 870 560 876 874 813 815 814 816 818
+ 879 820 880 832 894 882 883 861 826 886 837 887 825 562 889 760 829 830 831 828
+ 892 836 835 895 897 563 896 841 842 843 781 844 783 785 846 788 847 848 850 792
+ 795 852 387 797 853 857 801 802 858 860 804 862 808 865 809 810 869 872 873 567
+ 817 877 878 405 819 881 821 822 823 884 885 586 888 890 159 891 893 833 834 568
+ 838 898 840
+ ICV_6 $T=0 0 0 0 $X=-4300 $Y=2010600
X4 5 168 252 329 80 330 175 258 261 12 21 254 86 780 373 706 227 265 376 264
+ 338 220 377 186 378 213 379 4 10 266 380 346 900 381 51 259 VDD 334 268 273
+ 800 337 392 553 382 383 62 384 339 385 386 799 29 387 25 340 388 857 389 390
+ 77 391 915 50 37 2 278 341 281 89 864 83 393 344 394 395 859 396 108 345
+ 105 97 280 298 402 872 304 350 348 243 349 306 403 404 raw_code_o[0] 353 405 354 406 355
+ 356 308 407 VSS 408 935 358 359 409 360 411 412 413 361 230 414 124 362 363 939
+ 364 232 365 142 154 366 367 369 240 370 162 165 166 321 172 6 15 28 107 267
+ 899 215 713 272 844 901 902 854 905 904 798 846 851 848 418 909 910 855 866 914
+ 858 860 916 863 883 282 921 435 812 924 567 929 869 560 882 946 928 926 876 577
+ 877 772 879 880 937 868 941 942 888 936 892 944 238 891 893 943 697 568 898 raw_bits_i[18]
+ raw_bits_i[17] raw_bits_i[19] data_valid_i 299 841 187 842 189 843 903 845 847 906 907 849 908 850 559 852 911
+ 853 912 856 913 861 917 918 862 919 920 922 865 867 923 925 871 873 874 875 927
+ 878 930 931 932 933 881 934 938 579 884 885 940 886 887 562 889 945 890 947 894
+ 895 raw_bits_i[16] 896 897
+ ICV_7 $T=0 0 0 0 $X=-4300 $Y=1457600
X5 373 10 377 4 333 261 273 286 439 440 402 448 406 raw_code_o[6] raw_code_o[8] 252 379 329 272 263
+ 265 185 376 338 382 378 86 332 903 780 380 254 392 220 381 51 259 553 12 269
+ 336 851 202 911 900 271 418 419 383 175 384 385 386 421 387 422 424 34 388 389
+ 390 77 391 276 425 216 426 427 428 218 586 50 VDD 429 430 2 279 431 432 342
+ 37 433 919 230 393 435 283 436 284 344 345 285 srm_done 394 395 83 289 290 105 291
+ 223 962 292 396 437 438 294 296 400 w_wr_en 297 441 444 442 443 232 445 446 300 304
+ 301 302 447 347 303 449 450 574 451 306 452 453 454 455 456 405 982 354 457 raw_code_o[3]
+ 407 229 VSS 408 raw_code_o[9] raw_code_o[10] 409 calib_overrange calib_overrange_bits[18] calib_overrange_bits[0] 411 412 413 calib_overrange_bits[2] 414 raw_code_o[11] calib_overrange_bits[1] 458 459 calib_overrange_bits[17]
+ 243 149 943 153 raw_code_o[5] calib_overrange_bits[7] calib_overrange_bits[19] calib_overrange_bits[16] 319 calib_overrange_bits[6] 164 244 calib_overrange_bits[15] calib_overrange_bits[12] calib_overrange_bits[13] calib_overrange_bits[8] calib_overrange_bits[11] calib_overrange_bits[5] calib_overrange_bits[10] 346
+ 21 573 227 950 915 908 706 907 909 906 799 339 854 958 913 917 960 959 963 965
+ 964 923 142 971 924 970 974 560 968 975 976 978 977 575 969 980 979 278 576 926
+ 930 927 983 577 485 578 933 936 939 941 579 988 calib_overrange_bits[4] calib_overrange_bits[3] calib_overrange_bits[9] calib_overrange_bits[14] 947 raw_bits_i[12] raw_bits_i[15] raw_bits_i[14]
+ raw_bits_i[13] 267 899 901 902 948 904 905 949 910 951 258 952 912 953 954 955 914 956 957
+ 916 469 470 918 961 282 859 225 864 920 921 922 587 293 966 275 967 925 313 973
+ 972 870 349 928 981 929 487 984 772 484 931 932 934 935 985 937 938 986 940 942
+ 944 945 946 987
+ ICV_8 $T=0 0 0 0 $X=-4300 $Y=953600
X6 srm_total_count[1] srm_total_count[3] srm_total_count[4] srm_total_count[0] srm_total_count[2] srm_count_shortfall srm_stalled 449 265 254 418 419 421 461 462 463 464 955 465 466
+ 467 992 425 426 480 468 429 586 VDD 440 430 2 989 431 471 472 473 37 474 475
+ 393 435 477 436 344 345 476 478 479 105 481 454 482 437 483 438 484 439 485 486
+ 488 srm_residue_o[9] srm_ones_count[0] 403 srm_ones_count[1] srm_ones_count[3] 967 srm_ones_count[2] 441 86 srm_ones_count[4] 972 973 442 443 444 490 445 446 978
+ start_calib 492 447 448 raw_code_o[4] 451 srm_busy residue_consume_i 452 453 982 455 srm_residue_valid 456 raw_code_o[2] 457 raw_code_o[7] srm_start 493 458
+ 459 1026 494 495 948 949 952 953 954 959 957 390 994 998 996 574 587 1001 512 1000
+ 230 1002 1008 966 229 1010 1007 981 971 1019 1015 975 1011 976 1018 596 980 979 1020 984
+ 1023 1041 1022 1021 318 985 986 1040 raw_bits_i[5] 1025 1027 1028 1036 1029 1030 1031 943 1037 raw_bits_i[10] raw_bits_i[9]
+ raw_bits_i[11] VSS 272 379 220 392 950 951 990 956 991 958 993 995 960 961 259 997 999 962
+ 963 964 965 1003 1004 1005 1006 968 969 1009 970 974 1012 977 1013 1014 1016 575 520 1017
+ 594 576 983 578 1024 1032 987 1033 1034 1035 1038 597 1039 988 raw_bits_i[8] raw_bits_i[7] raw_bits_i[6] 1132 1133
+ ICV_9 $T=0 0 0 0 $X=-4300 $Y=651200
X7 srm_residue_o[8] srm_residue_o[6] 419 422 424 461 462 463 464 465 466 1046 467 427 468 VDD 496 497 469 431
+ 470 472 471 498 473 499 474 475 500 507 501 502 503 504 505 506 476 450 477 478
+ 508 509 999 510 481 511 VSS 479 512 480 513 440 514 454 515 516 1003 482 455 449
+ 1002 484 483 487 517 485 518 439 486 srm_residue_o[7] 520 519 1014 492 521 522 523 1074 524 596
+ 493 494 dac_n_force[0] 86 1031 525 526 srm_decision_valid 527 dac_n_force[2] dac_n_force[1] 1038 1091 495 dec_clk srm_residue_o[4] srm_residue_o[5] 1000 989 994
+ 996 990 991 1055 1044 1047 1049 993 1050 997 1053 1057 1058 457 1062 1064 1063 1006 1066 1009
+ 1013 1065 1021 1012 1016 1017 594 1073 1072 1078 595 1030 1075 586 calib_mode_en 1024 1082 1081 1083 1028
+ 1034 1033 1087 1088 1092 1090 597 1042 1043 1045 992 1048 995 1051 1052 605 1054 1056 998 1001
+ 606 1059 1060 1061 1010 1067 1015 1068 1069 1070 1071 1018 1019 1020 1022 1076 1023 calib_done 607 1079
+ 1080 1025 1026 1027 1084 608 1029 1032 1086 1036 1089 1037 1039 1093 raw_bits_i[4]
+ ICV_10 $T=0 0 0 0 $X=-4300 $Y=348800
X8 srm_residue_o[0] dac_n_force[18] srm_residue_o[2] srm_residue_o[1] srm_residue_o[3] 473 dac_p_force[15] dac_p_force[19] dac_p_force[16] 1070 419 424 428 496 497 432 498 433 499 dac_p_force[2]
+ 506 1056 500 dac_p_force[3] 501 502 503 504 505 507 476 1007 508 509 dac_p_force[4] 510 481 1050 511 512
+ 513 514 515 516 dac_p_force[5] 484 487 517 518 490 488 dac_n_force[3] 403 519 520 232 1067 1071 1072 521
+ 522 srm_decision_bit 523 524 86 525 526 527 1091 dec_clk 1092 dac_n_force[5] dac_n_force[6] dac_n_force[7] dac_n_force[9] dac_n_force[11] dac_n_force[12] dac_n_force[13] dac_n_force[14] dac_n_force[15]
+ dac_n_force[16] dac_n_force[17] VDD 474 dac_p_force[0] dac_n_force[19] dac_p_force[1] 1059 606 1051 605 1054 1055 dac_p_force[7] 1005 1058 dac_p_force[11] dac_p_force[8] 1004 dac_p_force[10]
+ dac_p_force[9] dac_p_force[12] 1069 calib_comp_out 1021 dac_p_force[13] dac_p_force[17] dac_p_force[14] 1011 calib_done_pulse dac_p_force[18] 1073 595 1076 1079 608 607 1080 1083 1084
+ 1086 586 1035 1088 1089 1090 raw_bits_i[3] raw_bits_i[2] dac_n_force[4] VSS dac_n_force[8] dac_n_force[10] 1042 1043 1044 1045 1046 1047 1048 1049
+ 1052 1053 450 1057 440 1060 dac_p_force[6] 1061 1008 1062 1063 1064 1013 1065 1066 1068 1074 1075 1078 1081
+ 1082 1087 1093 1040 1041
+ ICV_11 $T=0 0 0 0 $X=-4300 $Y=-5400
*.CALIBRE WARNING SHORT Short circuit(s) detected by extraction in this cell. See extraction report for details.
.ENDS
***************************************
