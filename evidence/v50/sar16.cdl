$ Spice netlist generated by v2lvs
$ v2025.1_16.10    Thu Jan 2 11:57:15 PST 2025
.INCLUDE "smic18_san.cdl"
*.BUSDELIMITER [

.SUBCKT SNPS_CLOCK_GATE_HIGH_srm_residue_estimator_DECISION_COUNT22_RESIDUE_WIDTH10_RES_FRAC8_SIGMA_Q8128_STALL_CYCLES64_1
+ CLK EN ENCLK TE
Xlatch TLATNXL $PINS D=EN GN=CLK Q=net1614
Xmain_gate AND2X4 $PINS A=net1614 B=CLK Y=ENCLK
.ENDS

.SUBCKT SNPS_CLOCK_GATE_HIGH_srm_residue_estimator_DECISION_COUNT22_RESIDUE_WIDTH10_RES_FRAC8_SIGMA_Q8128_STALL_CYCLES64_2
+ CLK EN ENCLK TE
Xlatch TLATNXL $PINS D=EN GN=CLK Q=net1614
Xmain_gate AND2X2 $PINS A=net1614 B=CLK Y=ENCLK
.ENDS

.SUBCKT SNPS_CLOCK_GATE_HIGH_srm_residue_estimator_DECISION_COUNT22_RESIDUE_WIDTH10_RES_FRAC8_SIGMA_Q8128_STALL_CYCLES64_3
+ CLK EN ENCLK TE
Xlatch TLATNXL $PINS D=EN GN=CLK Q=net1614
Xmain_gate AND2X2 $PINS A=net1614 B=CLK Y=ENCLK
.ENDS

.SUBCKT SNPS_CLOCK_GATE_HIGH_srm_residue_estimator_DECISION_COUNT22_RESIDUE_WIDTH10_RES_FRAC8_SIGMA_Q8128_STALL_CYCLES64_4
+ CLK EN ENCLK TE ctosc_gls_0
Xlatch TLATNXL $PINS D=EN GN=ctosc_gls_0 Q=net1614
Xmain_gate AND2X2 $PINS A=net1614 B=CLK Y=ENCLK
.ENDS

.SUBCKT SNPS_CLOCK_GATE_HIGH_srm_residue_estimator_DECISION_COUNT22_RESIDUE_WIDTH10_RES_FRAC8_SIGMA_Q8128_STALL_CYCLES64_0
+ CLK EN ENCLK TE ctosc_gls_0
Xlatch TLATNXL $PINS D=EN GN=ctosc_gls_0 Q=net1614
Xmain_gate AND2X1 $PINS A=net1614 B=CLK Y=ENCLK
.ENDS

.SUBCKT srm_residue_lut_22_128_8_8_10_1 cnt[4] cnt[3] cnt[2] cnt[1] cnt[0]
+ v_res[9] v_res[8] v_res[7] v_res[6] v_res[5] v_res[4] v_res[3] v_res[2]
+ v_res[1] v_res[0]
XU3 INVXL $PINS A=n8 Y=n13
XU6 NOR2XL $PINS A=n52 B=n50 Y=n22
XU7 AOI211XL $PINS A0=n52 A1=n38 B0=n50 C0=n26 Y=n27
XU8 AOI21XL $PINS A0=n15 A1=n29 B0=n14 Y=n26
XU9 INVXL $PINS A=n52 Y=n14
XU10 INVXL $PINS A=n21 Y=n1
XU11 MXI2XL $PINS A=n48 B=n57 S0=n33 Y=v_res[5]
XU12 MXI2XL $PINS A=n48 B=n57 S0=n47 Y=v_res[7]
XU13 MXI2XL $PINS A=n48 B=n57 S0=n27 Y=v_res[4]
XU14 NAND2XL $PINS A=n57 B=n56 Y=n55
XU15 MXI2XL $PINS A=n57 B=n48 S0=n39 Y=v_res[6]
XU16 XOR2XL $PINS A=n48 B=n26 Y=v_res[3]
XU17 INVXL $PINS A=n48 Y=n57
XU18 OAI211XL $PINS A0=n42 A1=n37 B0=n20 C0=n19 Y=v_res[1]
XU19 AOI211XL $PINS A0=n32 A1=n50 B0=n31 C0=n30 Y=n33
XU20 NAND2XL $PINS A=n54 B=n53 Y=n56
XU23 NOR2XL $PINS A=n22 B=n21 Y=n25
XU24 OAI2BB2XL $PINS B0=n18 B1=n17 A0N=n16 A1N=n50 Y=v_res[0]
XU25 OAI211XL $PINS A0=n38 A1=n37 B0=n36 C0=n54 Y=n39
XU26 NOR2BXL $PINS AN=n44 B=n38 Y=n31
XU27 NAND2XL $PINS A=n35 B=n34 Y=n54
XU28 AOI22XL $PINS A0=n46 A1=n45 B0=n44 B1=n43 Y=n47
XU29 NOR2XL $PINS A=n14 B=n32 Y=n44
XU30 NOR2XL $PINS A=n40 B=n15 Y=n34
XU32 INVXL $PINS A=n16 Y=n32
XU35 NAND2XL $PINS A=n10 B=cnt[1] Y=n9
XU36 AOI21XL $PINS A0=cnt[4] A1=n6 B0=cnt[2] Y=n7
XU37 INVXL $PINS A=cnt[0] Y=n43
XU39 AND3X1 $PINS A=cnt[1] B=cnt[2] C=cnt[0] Y=n11
XU40 NOR2X1 $PINS A=n8 B=n11 Y=n42
XU41 AOI211XL $PINS A0=n52 A1=n51 B0=n50 C0=n49 Y=n53
XU42 NOR2X1 $PINS A=n41 B=n36 Y=n50
XU43 NOR2X2 $PINS A=n35 B=n40 Y=n52
XU45 AOI211X1 $PINS A0=n49 A1=n51 B0=n31 C0=n34 Y=n24
XU46 AOI21X1 $PINS A0=cnt[2] A1=cnt[3] B0=cnt[4] Y=n21
XU47 NOR2XL $PINS A=n14 B=n16 Y=n49
XU48 OAI21X1 $PINS A0=n10 A1=cnt[1] B0=n9 Y=n16
XU49 NAND2XL $PINS A=cnt[1] B=cnt[0] Y=n6
XU50 AOI21XL $PINS A0=cnt[2] A1=n1 B0=n7 Y=n8
XU52 NOR2XL $PINS A=n21 B=cnt[0] Y=n10
XU53 NAND2XL $PINS A=n42 B=n16 Y=n15
XU54 NAND3XL $PINS A=n35 B=n51 C=n15 Y=n45
XU55 AND2XL $PINS A=n45 B=n21 Y=v_res[9]
XU56 OAI21XL $PINS A0=cnt[3] A1=n11 B0=cnt[4] Y=n12
XU57 NOR2XL $PINS A=n13 B=cnt[0] Y=n38
XU58 NAND2XL $PINS A=cnt[0] B=n42 Y=n29
XU59 NAND2XL $PINS A=cnt[0] B=n15 Y=n18
XU60 OAI21XL $PINS A0=n42 A1=n16 B0=n52 Y=n17
XU61 INVXL $PINS A=n49 Y=n37
XU62 AOI22XL $PINS A0=n52 A1=n18 B0=n1 B1=v_res[0] Y=n20
XU63 NAND2XL $PINS A=n50 B=n32 Y=n19
XU64 NAND2XL $PINS A=n25 B=n24 Y=n23
XU65 OAI21XL $PINS A0=n25 A1=n24 B0=n23 Y=v_res[2]
XU66 OAI21XL $PINS A0=n42 A1=n43 B0=n49 Y=n28
XU67 OAI31XL $PINS A0=cnt[1] A1=n40 A2=n29 B0=n28 Y=n30
XU68 AOI21XL $PINS A0=n42 A1=n41 B0=n40 Y=n46
XU69 OAI21XL $PINS A0=n57 A1=n56 B0=n55 Y=v_res[8]
XU5 INVXL $PINS A=n12 Y=n40
XU21 NAND2BXL $PINS AN=n51 B=n12 Y=n36
XU31 NAND2XL $PINS A=n13 B=n43 Y=n51
XU33 INVXL $PINS A=n41 Y=n35
XU34 NAND2BXL $PINS AN=n11 B=cnt[3] Y=n41
XctmTdsLR_1_830 INVXL $PINS A=n1 Y=tmp_net122
XctmTdsLR_2_831 OAI22X2 $PINS A0=n24 A1=tmp_net122 B0=n22 B1=n21 Y=n48
.ENDS

.SUBCKT srm_residue_estimator_DECISION_COUNT22_RESIDUE_WIDTH10_RES_FRAC8_SIGMA_Q8128_STALL_CYCLES64
+ dec_clk decision_valid decision_bit clk rst_n start residue_consume busy done
+ residue_valid ones_count[4] ones_count[3] ones_count[2] ones_count[1]
+ ones_count[0] total_count[4] total_count[3] total_count[2] total_count[1]
+ total_count[0] count_shortfall stalled residue_q[9] residue_q[8] residue_q[7]
+ residue_q[6] residue_q[5] residue_q[4] residue_q[3] residue_q[2] residue_q[1]
+ residue_q[0] HFSNET_5 HFSNET_6 HFSNET_7 HFSNET_9
Xu_lut srm_residue_lut_22_128_8_8_10_1 $PINS cnt[4]=cap_ones[4]
+ cnt[3]=cap_ones[3] cnt[2]=cap_ones[2] cnt[1]=cap_ones[1] cnt[0]=cap_ones[0]
+ v_res[9]=lut_out[9] v_res[8]=lut_out[8] v_res[7]=lut_out[7] v_res[6]=lut_out[6]
+ v_res[5]=lut_out[5] v_res[4]=lut_out[4] v_res[3]=lut_out[3] v_res[2]=lut_out[2]
+ v_res[1]=lut_out[1] v_res[0]=lut_out[0]
Xclk_gate_dec_ones_reg
+ SNPS_CLOCK_GATE_HIGH_srm_residue_estimator_DECISION_COUNT22_RESIDUE_WIDTH10_RES_FRAC8_SIGMA_Q8128_STALL_CYCLES64_0
+ $PINS CLK=dec_clk EN=N43 ENCLK=net1622 TE=VSS ctosc_gls_0=ctosc_gls_0
Xclk_gate_dec_total_reg
+ SNPS_CLOCK_GATE_HIGH_srm_residue_estimator_DECISION_COUNT22_RESIDUE_WIDTH10_RES_FRAC8_SIGMA_Q8128_STALL_CYCLES64_4
+ $PINS CLK=dec_clk EN=N49 ENCLK=net1628 TE=VSS ctosc_gls_0=ctosc_gls_0
Xclk_gate_cap_ones_reg
+ SNPS_CLOCK_GATE_HIGH_srm_residue_estimator_DECISION_COUNT22_RESIDUE_WIDTH10_RES_FRAC8_SIGMA_Q8128_STALL_CYCLES64_3
+ $PINS CLK=clk EN=N105 ENCLK=net1633 TE=VSS
Xclk_gate_stall_cnt_reg
+ SNPS_CLOCK_GATE_HIGH_srm_residue_estimator_DECISION_COUNT22_RESIDUE_WIDTH10_RES_FRAC8_SIGMA_Q8128_STALL_CYCLES64_2
+ $PINS CLK=clk EN=n124 ENCLK=net1638 TE=VSS
Xclk_gate_residue_q_small_reg
+ SNPS_CLOCK_GATE_HIGH_srm_residue_estimator_DECISION_COUNT22_RESIDUE_WIDTH10_RES_FRAC8_SIGMA_Q8128_STALL_CYCLES64_1
+ $PINS CLK=clk EN=n123 ENCLK=net1643 TE=VSS
Xdec_run_reg DFFSX1 $PINS D=n79 CK=net1628 SN=HFSNET_9 QN=dec_run
Xtgl_s2_reg DFFSX1 $PINS D=n142 CK=clk SN=HFSNET_9 QN=tgl_s2
Xdone_pending_reg DFFSX1 $PINS D=n84 CK=net1638 SN=HFSNET_8 QN=done_pending
Xcap_total_reg[4] DFFSXL $PINS D=n126 CK=net1633 SN=HFSNET_8 QN=cap_total[4]
Xstate_reg[1] DFFSX1 $PINS D=n72 CK=clk SN=HFSNET_8 Q=n81 QN=state[1]
Xstate_reg[2] DFFSX1 $PINS D=n71 CK=clk SN=rst_n Q=n131 QN=state[2]
Xstall_cnt_reg[6] DFFSX1 $PINS D=n85 CK=net1638 SN=HFSNET_8 QN=stall_cnt[6]
Xstall_cnt_reg[5] DFFSX1 $PINS D=n86 CK=net1638 SN=HFSNET_8 QN=stall_cnt[5]
Xstall_cnt_reg[4] DFFSX1 $PINS D=n87 CK=net1638 SN=HFSNET_8 QN=stall_cnt[4]
Xstall_cnt_reg[3] DFFSX1 $PINS D=n88 CK=net1638 SN=HFSNET_8 QN=stall_cnt[3]
Xstall_cnt_reg[2] DFFSX1 $PINS D=n89 CK=net1638 SN=HFSNET_8 QN=stall_cnt[2]
Xstall_cnt_reg[1] DFFSX1 $PINS D=n90 CK=net1638 SN=HFSNET_8 QN=stall_cnt[1]
Xstall_cnt_reg[0] DFFSX1 $PINS D=n91 CK=net1638 SN=HFSNET_8 QN=stall_cnt[0]
Xtot_g_s2_reg[0] DFFSX1 $PINS D=n141 CK=clk SN=HFSNET_9 QN=tot_g_s2[0]
Xdec_total_reg[2] DFFSX1 $PINS D=n120 CK=net1628 SN=HFSNET_9 Q=n75
+ QN=dec_total[2]
Xtot_g_s2_reg[1] DFFSX1 $PINS D=n140 CK=clk SN=HFSNET_9 QN=tot_g_s2[1]
Xtot_g_s2_reg[3] DFFSX1 $PINS D=n139 CK=clk SN=HFSNET_9 QN=tot_g_s2[3]
Xcap_total_reg[3] DFFSXL $PINS D=n63 CK=net1633 SN=HFSNET_8 QN=cap_total[3]
Xtot_g_s2_reg[2] DFFSX1 $PINS D=n138 CK=clk SN=HFSNET_9 QN=tot_g_s2[2]
Xcap_total_reg[2] DFFSXL $PINS D=n60 CK=net1633 SN=HFSNET_8 QN=cap_total[2]
Xcap_shortfall_reg DFFSXL $PINS D=n59 CK=net1633 SN=HFSNET_8 QN=cap_shortfall
Xcap_total_reg[0] DFFSXL $PINS D=n58 CK=net1633 SN=HFSNET_8 QN=cap_total[0]
Xcap_total_reg[1] DFFSXL $PINS D=n57 CK=net1633 SN=HFSNET_8 QN=cap_total[1]
Xones_g_s2_reg[0] DFFSX1 $PINS D=n137 CK=clk SN=HFSNET_9 QN=ones_g_s2[0]
Xones_g_s2_reg[1] DFFSX1 $PINS D=n136 CK=clk SN=HFSNET_6 QN=ones_g_s2[1]
Xdec_ones_reg[3] DFFSX1 $PINS D=n114 CK=net1622 SN=HFSNET_9 Q=n144
+ QN=dec_ones[3]
Xones_g_s2_reg[2] DFFSX1 $PINS D=n135 CK=clk SN=HFSNET_9 QN=ones_g_s2[2]
Xcap_ones_reg[4] DFFSXL $PINS D=n125 CK=net1633 SN=HFSNET_8 QN=cap_ones[4]
Xones_g_s2_reg[3] DFFSX1 $PINS D=n133 CK=clk SN=HFSNET_9 QN=ones_g_s2[3]
Xcap_ones_reg[3] DFFSX1 $PINS D=n45 CK=net1633 SN=HFSNET_8 QN=cap_ones[3]
Xtgl_ref_reg DFFSX1 $PINS D=n37 CK=net1638 SN=HFSNET_8 QN=tgl_ref
Xtot_g_s1_reg[4] DFFSX1 $PINS D=n128 CK=clk SN=HFSNET_9 Q=n143
Xtgl_s1_reg DFFSX1 $PINS D=n129 CK=clk SN=HFSNET_9 Q=n142
Xtot_g_s1_reg[0] DFFSX1 $PINS D=n69 CK=clk SN=HFSNET_9 Q=n141
Xtot_g_s1_reg[1] DFFSX1 $PINS D=n67 CK=clk SN=HFSNET_9 Q=n140
Xtot_g_s1_reg[3] DFFSX1 $PINS D=n65 CK=clk SN=HFSNET_9 Q=n139
Xtot_g_s1_reg[2] DFFSX1 $PINS D=n62 CK=clk SN=HFSNET_9 Q=n138
Xones_g_s1_reg[0] DFFSX1 $PINS D=n56 CK=clk SN=HFSNET_9 Q=n137
Xones_g_s1_reg[1] DFFSX1 $PINS D=n54 CK=clk SN=HFSNET_6 Q=n136
Xones_g_s1_reg[2] DFFSX1 $PINS D=n52 CK=clk SN=HFSNET_9 Q=n135
Xones_g_s1_reg[4] DFFSX1 $PINS D=n78 CK=clk SN=HFSNET_9 Q=n134
Xones_g_s1_reg[3] DFFSX1 $PINS D=n47 CK=clk SN=HFSNET_9 Q=n133
Xgo_tgl_reg DFFSX1 $PINS D=n39 CK=clk SN=rst_n Q=n132 QN=go_tgl
Xdec_done_tgl_reg DFFSX1 $PINS D=n38 CK=net1628 SN=HFSNET_9 Q=n129
Xdec_total_reg[1] DFFSX1 $PINS D=n121 CK=net1628 SN=HFSNET_9 Q=n127
+ QN=dec_total[1]
Xtot_g_s2_reg[4] DFFSX1 $PINS D=n143 CK=clk SN=HFSNET_9 Q=n126 QN=tot_g_s2[4]
Xones_g_s2_reg[4] DFFSX1 $PINS D=n134 CK=clk SN=HFSNET_8 Q=n125 QN=ones_g_s2[4]
Xgo_tgl_s1_reg DFFSX1 $PINS D=n132 CK=ctosc_gls_0 SN=HFSNET_9 Q=n82
Xdec_total_reg[3] DFFSX1 $PINS D=n119 CK=net1628 SN=HFSNET_9 Q=n76
+ QN=dec_total[3]
Xdone_reg DFFSX1 $PINS D=n41 CK=clk SN=HFSNET_5 QN=done
Xresidue_q_small_reg[9] DFFSXL $PINS D=n92 CK=net1643 SN=HFSNET_5
+ QN=residue_q[9]
Xresidue_q_small_reg[8] DFFSXL $PINS D=n93 CK=net1643 SN=HFSNET_5
+ QN=residue_q[8]
Xresidue_q_small_reg[7] DFFSXL $PINS D=n94 CK=net1643 SN=HFSNET_5
+ QN=residue_q[7]
Xresidue_q_small_reg[6] DFFSXL $PINS D=n95 CK=net1643 SN=HFSNET_5
+ QN=residue_q[6]
Xresidue_q_small_reg[5] DFFSXL $PINS D=n96 CK=net1643 SN=HFSNET_5
+ QN=residue_q[5]
Xresidue_q_small_reg[4] DFFSXL $PINS D=n97 CK=net1643 SN=HFSNET_5
+ QN=residue_q[4]
Xresidue_q_small_reg[3] DFFSXL $PINS D=n98 CK=net1643 SN=HFSNET_5
+ QN=residue_q[3]
Xresidue_q_small_reg[2] DFFSXL $PINS D=n99 CK=net1643 SN=HFSNET_5
+ QN=residue_q[2]
Xresidue_q_small_reg[1] DFFSXL $PINS D=n100 CK=net1643 SN=HFSNET_5
+ QN=residue_q[1]
Xresidue_q_small_reg[0] DFFSXL $PINS D=n101 CK=net1643 SN=HFSNET_5
+ QN=residue_q[0]
Xones_count_reg[4] DFFSXL $PINS D=n103 CK=net1643 SN=HFSNET_5 QN=ones_count[4]
Xones_count_reg[3] DFFSXL $PINS D=n104 CK=net1643 SN=HFSNET_5 QN=ones_count[3]
Xones_count_reg[2] DFFSXL $PINS D=n105 CK=net1643 SN=HFSNET_5 QN=ones_count[2]
Xones_count_reg[1] DFFSXL $PINS D=n106 CK=net1643 SN=HFSNET_5 QN=ones_count[1]
Xones_count_reg[0] DFFSXL $PINS D=n107 CK=net1643 SN=HFSNET_5 QN=ones_count[0]
Xtotal_count_reg[4] DFFSXL $PINS D=n108 CK=net1643 SN=HFSNET_5
+ QN=total_count[4]
Xtotal_count_reg[3] DFFSXL $PINS D=n109 CK=net1643 SN=HFSNET_5
+ QN=total_count[3]
Xtotal_count_reg[2] DFFSXL $PINS D=n110 CK=net1643 SN=HFSNET_5
+ QN=total_count[2]
Xtotal_count_reg[1] DFFSXL $PINS D=n111 CK=net1643 SN=HFSNET_8
+ QN=total_count[1]
Xtotal_count_reg[0] DFFSXL $PINS D=n112 CK=net1643 SN=HFSNET_5
+ QN=total_count[0]
Xcount_shortfall_reg DFFSXL $PINS D=n102 CK=net1643 SN=HFSNET_5
+ QN=count_shortfall
Xdec_total_reg[0] DFFSX1 $PINS D=n122 CK=net1628 SN=HFSNET_9 QN=dec_total[0]
Xgo_tgl_s2_reg DFFSX1 $PINS D=n82 CK=ctosc_gls_0 SN=HFSNET_9 Q=n80 QN=go_tgl_s2
Xcap_ones_reg[2] DFFSXL $PINS D=n44 CK=net1633 SN=HFSNET_8 QN=cap_ones[2]
Xcap_ones_reg[0] DFFSX1 $PINS D=n43 CK=net1633 SN=HFSNET_8 QN=cap_ones[0]
Xcap_ones_reg[1] DFFSXL $PINS D=n42 CK=net1633 SN=HFSNET_8 QN=cap_ones[1]
Xdec_total_reg[4] DFFSX1 $PINS D=n118 CK=net1628 SN=HFSNET_9 Q=n128
+ QN=dec_total[4]
Xbusy_reg DFFSX1 $PINS D=n83 CK=clk SN=HFSNET_8 QN=aps_rename_5_
Xstalled_reg DFFSX1 $PINS D=n70 CK=clk SN=HFSNET_6 QN=stalled
Xresidue_valid_reg DFFSX1 $PINS D=n40 CK=clk SN=HFSNET_6 QN=aps_rename_6_
Xstate_reg[0] DFFSX1 $PINS D=n73 CK=clk SN=HFSNET_8 Q=n130 QN=state[0]
Xdec_ones_reg[4] DFFSX1 $PINS D=n113 CK=net1622 SN=HFSNET_9 Q=n78
+ QN=dec_ones[4]
Xdec_ones_reg[2] DFFSX1 $PINS D=n115 CK=net1622 SN=HFSNET_9 Q=n77
+ QN=dec_ones[2]
Xdec_ones_reg[0] DFFSX1 $PINS D=n117 CK=net1622 SN=HFSNET_9 QN=dec_ones[0]
Xdec_ones_reg[1] DFFSX1 $PINS D=n116 CK=net1622 SN=HFSNET_9 QN=dec_ones[1]
Xgo_tgl_s3_reg DFFSX1 $PINS D=n80 CK=ctosc_gls_0 SN=HFSNET_9 QN=go_tgl_s3
XU3 OAI21XL $PINS A0=n129 A1=n74 B0=n68 Y=n38
XU4 OAI21XL $PINS A0=n78 A1=n36 B0=n35 Y=n113
XU5 OAI21XL $PINS A0=n128 A1=n32 B0=n31 Y=n118
XU6 NAND2BXL $PINS AN=dec_ones[0] B=n33 Y=n117
XU7 OAI211XL $PINS A0=n29 A1=dec_total[3] B0=n33 C0=n32 Y=n119
XU8 NAND2XL $PINS A=n29 B=dec_total[3] Y=n32
XU9 NAND2XL $PINS A=n28 B=dec_ones[3] Y=n36
XU10 NAND4BXL $PINS AN=n23 B=dec_total[0] C=dec_total[2] D=n127 Y=n66
XU11 INVXL $PINS A=n30 Y=n64
XU12 NAND2XL $PINS A=dec_ones[1] B=dec_ones[0] Y=n24
XU13 NAND2XL $PINS A=dec_total[1] B=dec_total[0] Y=n26
XU14 OAI21XL $PINS A0=dec_ones[1] A1=dec_ones[0] B0=n24 Y=n56
XHFSINV_12109_645 CLKINVX4 $PINS A=HFSNET_7 Y=HFSNET_8
XU16 AOI21XL $PINS A0=n78 A1=n36 B0=n34 Y=n35
XU17 AOI21XL $PINS A0=n128 A1=n32 B0=n34 Y=n31
XU18 AOI2BB1XL $PINS A0N=n17 A1N=stall_cnt[6] B0=n49 Y=N105
XU19 OAI2BB2XL $PINS B0=tgl_ref B1=tgl_s2 A0N=tgl_s2 A1N=tgl_ref Y=n3
XU20 NAND2XL $PINS A=n131 B=n81 Y=n55
Xctosc_gls_inst_1569 BUFX1 $PINS A=dec_clk Y=ctosc_gls_0
XU22 NAND2XL $PINS A=n7 B=lut_out[8] Y=n93
XU23 NAND2XL $PINS A=n7 B=lut_out[7] Y=n94
XU24 NAND2XL $PINS A=n7 B=lut_out[6] Y=n95
XU25 NAND2XL $PINS A=n7 B=lut_out[5] Y=n96
XU26 NAND2XL $PINS A=n7 B=lut_out[4] Y=n97
XU27 NAND2XL $PINS A=n12 B=stall_cnt[4] Y=n14
XU28 INVXL $PINS A=n11 Y=n12
XU29 NAND2XL $PINS A=stall_cnt[3] B=n8 Y=n11
XU31 INVXL $PINS A=n34 Y=n33
XU32 NAND2BXL $PINS AN=done_pending B=n3 Y=n17
XU33 NAND2XL $PINS A=n30 B=n34 Y=N49
XU35 AOI2BB2XL $PINS B0=dec_ones[1] B1=n77 A0N=n77 A1N=dec_ones[1] Y=n54
XU36 NAND3X1 $PINS A=n30 B=decision_valid C=dec_run Y=n34
XU37 AOI2BB2XL $PINS B0=busy B1=state[1] A0N=state[2] A1N=n53 Y=n83
XU38 MXI2XL $PINS A=go_tgl B=n132 S0=n61 Y=n39
XU39 MXI2X1 $PINS A=go_tgl_s2 B=n80 S0=go_tgl_s3 Y=n30
XU40 NOR2BXL $PINS AN=start B=busy Y=n61
XU43 NOR2XL $PINS A=state[2] B=n81 Y=n21
XU44 OAI21X1 $PINS A0=tot_g_s2[4] A1=tot_g_s2[3] B0=n6 Y=n63
XU46 INVXL $PINS A=n49 Y=n46
XU47 NAND2XL $PINS A=n21 B=n130 Y=n49
XU49 NOR2XL $PINS A=state[0] B=state[1] Y=n53
XU50 NAND2XL $PINS A=state[2] B=n53 Y=n41
XU51 NAND2XL $PINS A=tot_g_s2[4] B=tot_g_s2[3] Y=n6
XU52 MXI2X1 $PINS A=ones_g_s2[4] B=n125 S0=ones_g_s2[3] Y=n45
XU53 AOI2BB2X1 $PINS B0=tot_g_s2[2] B1=n63 A0N=n63 A1N=tot_g_s2[2] Y=n60
XU54 AOI2BB2X1 $PINS B0=tot_g_s2[1] B1=n60 A0N=n60 A1N=tot_g_s2[1] Y=n57
XU55 OAI21XL $PINS A0=n130 A1=n55 B0=n49 Y=n124
XU56 OAI21XL $PINS A0=dec_total[0] A1=dec_total[1] B0=n26 Y=n69
XU57 XOR2XL $PINS A=ones_g_s2[2] B=n45 Y=n44
XU58 XOR2XL $PINS A=ones_g_s2[1] B=n44 Y=n42
XU59 XOR2XL $PINS A=ones_g_s2[0] B=n42 Y=n43
XU60 AOI22XL $PINS A0=dec_total[3] A1=n75 B0=dec_total[2] B1=n76 Y=n62
XU61 AOI22XL $PINS A0=dec_ones[3] A1=n77 B0=dec_ones[2] B1=n144 Y=n52
XU62 AOI22XL $PINS A0=dec_total[2] A1=n127 B0=dec_total[1] B1=n75 Y=n67
XU63 AOI22XL $PINS A0=dec_total[4] A1=n76 B0=dec_total[3] B1=n128 Y=n65
XU64 AOI22XL $PINS A0=dec_ones[4] A1=n144 B0=dec_ones[3] B1=n78 Y=n47
XU65 AOI22XL $PINS A0=state[0] A1=tgl_s2 B0=tgl_ref B1=n130 Y=n37
XU66 OAI211XL $PINS A0=n21 A1=n3 B0=n130 C0=n17 Y=n84
XU67 NOR2BXL $PINS AN=stall_cnt[6] B=n49 Y=n4
XU68 AOI21XL $PINS A0=stalled A1=n55 B0=n4 Y=n70
XU69 INVXL $PINS A=n124 Y=n72
XU70 NAND4BXL $PINS AN=n4 B=tot_g_s2[2] C=tot_g_s2[0] D=n17 Y=n5
XU71 NOR3XL $PINS A=tot_g_s2[1] B=n6 C=n5 Y=n59
XU72 INVX2 $PINS A=n41 Y=n7
XU73 NAND2XL $PINS A=n7 B=cap_total[4] Y=n108
XU74 NAND2XL $PINS A=n7 B=cap_shortfall Y=n102
XU75 NAND2XL $PINS A=n7 B=cap_total[3] Y=n109
XU76 NAND2XL $PINS A=n7 B=cap_total[0] Y=n112
XU77 NAND2XL $PINS A=n7 B=cap_total[2] Y=n110
XU78 NAND2XL $PINS A=n7 B=cap_total[1] Y=n111
XU79 NAND2XL $PINS A=n7 B=cap_ones[3] Y=n104
XU80 NAND2XL $PINS A=n7 B=cap_ones[4] Y=n103
XU81 NAND2XL $PINS A=n7 B=cap_ones[2] Y=n105
XU82 NAND2XL $PINS A=n7 B=cap_ones[1] Y=n106
XU83 NAND2XL $PINS A=n7 B=cap_ones[0] Y=n107
XU84 NAND3XL $PINS A=stall_cnt[0] B=stall_cnt[2] C=stall_cnt[1] Y=n9
XU85 INVXL $PINS A=n9 Y=n8
XU86 OAI211XL $PINS A0=n8 A1=stall_cnt[3] B0=n46 C0=n11 Y=n88
XU87 NAND2XL $PINS A=stall_cnt[1] B=stall_cnt[0] Y=n13
XU88 INVXL $PINS A=n13 Y=n10
XU89 OAI211XL $PINS A0=n10 A1=stall_cnt[2] B0=n46 C0=n9 Y=n89
XU90 OAI211XL $PINS A0=n12 A1=stall_cnt[4] B0=n46 C0=n14 Y=n87
XU91 OAI211XL $PINS A0=stall_cnt[0] A1=stall_cnt[1] B0=n46 C0=n13 Y=n90
XU92 INVXL $PINS A=n14 Y=n15
XU93 NAND2XL $PINS A=stall_cnt[5] B=n15 Y=n48
XU94 OAI211XL $PINS A0=n15 A1=stall_cnt[5] B0=n46 C0=n48 Y=n86
XU95 OAI211XL $PINS A0=residue_consume A1=n131 B0=state[0] C0=n81 Y=n16
XU96 AOI21XL $PINS A0=HFSNET_1 A1=n16 B0=n7 Y=n40
XU97 AOI211XL $PINS A0=state[0] A1=residue_consume B0=n131 C0=state[1] Y=n18
XU98 AOI211XL $PINS A0=n53 A1=start B0=N105 C0=n18 Y=n73
XU99 OR3XL $PINS A=residue_consume B=n131 C=state[1] Y=n19
XU100 OAI21XL $PINS A0=start A1=n19 B0=n41 Y=n20
XU101 AOI21XL $PINS A0=state[0] A1=n21 B0=n20 Y=n71
XU102 NAND2XL $PINS A=n7 B=lut_out[9] Y=n92
XU103 NAND2XL $PINS A=n7 B=lut_out[0] Y=n101
XU104 NAND2XL $PINS A=n7 B=lut_out[1] Y=n100
XU105 NAND2XL $PINS A=n7 B=lut_out[2] Y=n99
XU106 NAND2XL $PINS A=n7 B=lut_out[3] Y=n98
XU107 NAND2XL $PINS A=dec_total[4] B=n76 Y=n23
XU108 AOI21XL $PINS A0=dec_run A1=n66 B0=n64 Y=n79
XU109 OR2XL $PINS A=n56 B=n34 Y=n116
XU110 OR2XL $PINS A=n69 B=n34 Y=n121
XU111 AOI21XL $PINS A0=n24 A1=n77 B0=n28 Y=n25
XU112 NAND2XL $PINS A=n33 B=n25 Y=n115
XU113 AOI21XL $PINS A0=n75 A1=n26 B0=n29 Y=n27
XU114 NAND2XL $PINS A=n33 B=n27 Y=n120
XU115 OAI211XL $PINS A0=dec_ones[3] A1=n28 B0=n33 C0=n36 Y=n114
XU116 OAI2BB1XL $PINS A0N=n33 A1N=decision_bit B0=n30 Y=N43
XU117 NAND2BXL $PINS AN=dec_total[0] B=n33 Y=n122
XU118 NAND2BXL $PINS AN=stall_cnt[0] B=n46 Y=n91
XU119 INVXL $PINS A=n48 Y=n51
XU120 AOI21XL $PINS A0=stall_cnt[6] A1=n51 B0=n49 Y=n50
XU121 OAI21XL $PINS A0=stall_cnt[6] A1=n51 B0=n50 Y=n85
XU123 AOI2BB2XL $PINS B0=tot_g_s2[0] B1=n57 A0N=n57 A1N=tot_g_s2[0] Y=n58
XU124 OAI21XL $PINS A0=n130 A1=n55 B0=n41 Y=n123
XU125 OR2XL $PINS A=n66 B=n64 Y=n74
XU126 NAND2XL $PINS A=n129 B=n74 Y=n68
XU30 NOR2XL $PINS A=n24 B=n77 Y=n28
XU34 NOR2XL $PINS A=n26 B=n75 Y=n29
XHFSINV_4_445 INVXL $PINS A=residue_valid Y=HFSNET_1
XHFSINV_38_447 INVXL $PINS A=aps_rename_6_ Y=residue_valid
XHFSBUF_59_500 CLKBUFX3 $PINS A=aps_rename_5_ Y=busy
.ENDS

.SUBCKT SNPS_CLOCK_GATE_HIGH_sar_calib_ctrl_serial_20_30_16_32_5_256_1_1_1_2
+ CLK EN ENCLK TE ZCTSNET_1
Xlatch TLATNXL $PINS D=EN GN=CLK Q=net1652
Xmain_gate AND2X4 $PINS A=HFSNET_0 B=ZCTSNET_1 Y=ENCLK
XHFSBUF_2_272 CLKBUFXL $PINS A=net1652 Y=HFSNET_0
.ENDS

.SUBCKT SNPS_CLOCK_GATE_HIGH_sar_calib_ctrl_serial_20_30_16_32_5_256_1_1_1 CLK
+ EN ENCLK TE ZCTSNET_0
Xlatch TLATNXL $PINS D=EN GN=CLK Q=net1652
Xmain_gate AND2X4 $PINS A=net1652 B=ZCTSNET_0 Y=ENCLK
.ENDS

.SUBCKT SNPS_CLOCK_GATE_HIGH_sar_calib_ctrl_serial_20_30_16_32_5_256_1_1_2 CLK
+ EN ENCLK TE ZCTSNET_0
Xlatch TLATNXL $PINS D=EN GN=CLK Q=net1652
Xmain_gate AND2X4 $PINS A=net1652 B=ZCTSNET_0 Y=ENCLK
.ENDS

.SUBCKT SNPS_CLOCK_GATE_HIGH_sar_calib_ctrl_serial_20_30_16_32_5_256_1_1_3 CLK
+ EN ENCLK TE ZCTSNET_0
Xlatch TLATNXL $PINS D=EN GN=CLK Q=net1652
Xmain_gate AND2X2 $PINS A=net1652 B=ZCTSNET_0 Y=ENCLK
.ENDS

.SUBCKT SNPS_CLOCK_GATE_HIGH_sar_calib_ctrl_serial_20_30_16_32_5_256_1_1_4 CLK
+ EN ENCLK TE
Xlatch TLATNXL $PINS D=EN GN=CLK Q=net1652
Xmain_gate AND2X2 $PINS A=net1652 B=CLK Y=ENCLK
.ENDS

.SUBCKT SNPS_CLOCK_GATE_HIGH_sar_calib_ctrl_serial_20_30_16_32_5_256_1_1_5 CLK
+ EN ENCLK TE ZCTSNET_2
Xlatch TLATNXL $PINS D=EN GN=CLK Q=net1652
Xmain_gate AND2X4 $PINS A=net1652 B=ZCTSNET_2 Y=ENCLK
.ENDS

.SUBCKT SNPS_CLOCK_GATE_HIGH_sar_calib_ctrl_serial_20_30_16_32_5_256_1_1_6 CLK
+ EN ENCLK TE ZCTSNET_2
Xlatch TLATNXL $PINS D=EN GN=CLK Q=net1652
Xmain_gate AND2X4 $PINS A=net1652 B=ZCTSNET_2 Y=ENCLK
.ENDS

.SUBCKT SNPS_CLOCK_GATE_HIGH_sar_calib_ctrl_serial_20_30_16_32_5_256_1_1_7 CLK
+ EN ENCLK TE ZCTSNET_0
Xlatch TLATNXL $PINS D=EN GN=CLK Q=net1652
Xmain_gate AND2X4 $PINS A=ZBUF_2_12 B=ZCTSNET_0 Y=ENCLK
XZBUF_2_inst_1624 BUFX1 $PINS A=net1652 Y=ZBUF_2_12
.ENDS

.SUBCKT SNPS_CLOCK_GATE_HIGH_sar_calib_ctrl_serial_20_30_16_32_5_256_1_1_8 CLK
+ EN ENCLK TE ZCTSNET_0
Xlatch TLATNXL $PINS D=EN GN=CLK Q=net1652
Xmain_gate AND2X2 $PINS A=net1652 B=ZCTSNET_0 Y=ENCLK
.ENDS

.SUBCKT SNPS_CLOCK_GATE_HIGH_sar_calib_ctrl_serial_20_30_16_32_5_256_1_1_9 CLK
+ EN ENCLK TE
Xlatch TLATNXL $PINS D=EN GN=CLK Q=net1652
Xmain_gate AND2X2 $PINS A=net1652 B=CLK Y=ENCLK
.ENDS

.SUBCKT SNPS_CLOCK_GATE_HIGH_sar_calib_ctrl_serial_20_30_16_32_5_256_1_1_10 CLK
+ EN ENCLK TE
Xlatch TLATNXL $PINS D=EN GN=CLK Q=net1652
Xmain_gate AND2X2 $PINS A=net1652 B=CLK Y=ENCLK
.ENDS

.SUBCKT SNPS_CLOCK_GATE_HIGH_sar_calib_ctrl_serial_20_30_16_32_5_256_1_1_11 CLK
+ EN ENCLK TE
Xlatch TLATNXL $PINS D=EN GN=CLK Q=net1652
Xmain_gate AND2X4 $PINS A=net1652 B=CLK Y=ENCLK
.ENDS

.SUBCKT SNPS_CLOCK_GATE_HIGH_sar_calib_ctrl_serial_20_30_16_32_5_256_1_1_12 CLK
+ EN ENCLK TE
Xlatch TLATNXL $PINS D=EN GN=CLK Q=net1652
Xmain_gate AND2X2 $PINS A=net1652 B=CLK Y=ENCLK
.ENDS

.SUBCKT SNPS_CLOCK_GATE_HIGH_sar_calib_ctrl_serial_20_30_16_32_5_256_1_1_13 CLK
+ EN ENCLK TE ZCTSNET_0
Xlatch TLATNXL $PINS D=EN GN=CLK Q=net1652
Xmain_gate AND2X4 $PINS A=net1652 B=ZCTSNET_0 Y=ENCLK
.ENDS

.SUBCKT SNPS_CLOCK_GATE_HIGH_sar_calib_ctrl_serial_20_30_16_32_5_256_1_1_14 CLK
+ EN ENCLK TE
Xlatch TLATNXL $PINS D=EN GN=CLK Q=net1652
Xmain_gate AND2X2 $PINS A=net1652 B=CLK Y=ENCLK
.ENDS

.SUBCKT SNPS_CLOCK_GATE_HIGH_sar_calib_ctrl_serial_20_30_16_32_5_256_1_1_15 CLK
+ EN ENCLK TE ZCTSNET_0
Xlatch TLATNXL $PINS D=EN GN=CLK Q=net1652
Xmain_gate AND2X2 $PINS A=net1652 B=ZCTSNET_0 Y=ENCLK
.ENDS

.SUBCKT SNPS_CLOCK_GATE_HIGH_sar_calib_ctrl_serial_20_30_16_32_5_256_1_1_16 CLK
+ EN ENCLK TE ZCTSNET_0
Xlatch TLATNXL $PINS D=EN GN=ZCTSNET_0 Q=net1652
Xmain_gate AND2X4 $PINS A=net1652 B=CLK Y=ENCLK
.ENDS

.SUBCKT SNPS_CLOCK_GATE_HIGH_sar_calib_ctrl_serial_20_30_16_32_5_256_1_1_17 CLK
+ EN ENCLK TE ZCTSNET_1
Xlatch TLATNXL $PINS D=EN GN=CLK Q=net1652
Xmain_gate AND2X2 $PINS A=net1652 B=ZCTSNET_1 Y=ENCLK
.ENDS

.SUBCKT SNPS_CLOCK_GATE_HIGH_sar_calib_ctrl_serial_20_30_16_32_5_256_1_1_18 CLK
+ EN ENCLK TE ZCTSNET_0
Xlatch TLATNXL $PINS D=EN GN=CLK Q=net1652
Xmain_gate AND2X2 $PINS A=net1652 B=ZCTSNET_0 Y=ENCLK
.ENDS

.SUBCKT SNPS_CLOCK_GATE_HIGH_sar_calib_ctrl_serial_20_30_16_32_5_256_1_1_19 CLK
+ EN ENCLK TE ZCTSNET_0
Xlatch TLATNXL $PINS D=EN GN=CLK Q=net1652
Xmain_gate AND2X2 $PINS A=net1652 B=ZCTSNET_0 Y=ENCLK
.ENDS

.SUBCKT SNPS_CLOCK_GATE_HIGH_sar_calib_ctrl_serial_20_30_16_32_5_256_1_1_20 CLK
+ EN ENCLK TE ZCTSNET_1
Xlatch TLATNXL $PINS D=EN GN=CLK Q=net1652
Xmain_gate AND2X2 $PINS A=HFSNET_0 B=ZCTSNET_1 Y=ENCLK
XHFSBUF_2_267 CLKBUFX3 $PINS A=net1652 Y=HFSNET_0
.ENDS

.SUBCKT SNPS_CLOCK_GATE_HIGH_sar_calib_ctrl_serial_20_30_16_32_5_256_1_1_21 CLK
+ EN ENCLK TE ZCTSNET_0
Xlatch TLATNXL $PINS D=EN GN=CLK Q=net1652
Xmain_gate AND2X2 $PINS A=net1652 B=ZCTSNET_0 Y=ENCLK
.ENDS

.SUBCKT SNPS_CLOCK_GATE_HIGH_sar_calib_ctrl_serial_20_30_16_32_5_256_1_1_22 CLK
+ EN ENCLK TE ZCTSNET_1
Xlatch TLATNXL $PINS D=EN GN=CLK Q=net1652
Xmain_gate AND2X2 $PINS A=ropt_net_506 B=ZCTSNET_1 Y=ENCLK
Xropt_mt_inst_2193 BUFXL $PINS A=net1652 Y=ropt_net_506
.ENDS

.SUBCKT SNPS_CLOCK_GATE_HIGH_sar_calib_ctrl_serial_20_30_16_32_5_256_1_1_23 CLK
+ EN ENCLK TE ZCTSNET_1
Xlatch TLATNXL $PINS D=EN GN=CLK Q=net1652
Xmain_gate AND2X2 $PINS A=HFSNET_0 B=ZCTSNET_1 Y=ENCLK
XHFSBUF_2_265 CLKBUFX3 $PINS A=net1652 Y=HFSNET_0
.ENDS

.SUBCKT SNPS_CLOCK_GATE_HIGH_sar_calib_ctrl_serial_20_30_16_32_5_256_1_1_24 CLK
+ EN ENCLK TE ZCTSNET_0
Xlatch TLATNXL $PINS D=EN GN=CLK Q=net1652
Xmain_gate AND2X2 $PINS A=net1652 B=ZCTSNET_0 Y=ENCLK
.ENDS

.SUBCKT SNPS_CLOCK_GATE_HIGH_sar_calib_ctrl_serial_20_30_16_32_5_256_1_1_25 CLK
+ EN ENCLK TE ZCTSNET_1
Xlatch TLATNXL $PINS D=HFSNET_0 GN=CLK Q=net1652
Xmain_gate AND2X2 $PINS A=ZBUF_2_12 B=ZCTSNET_1 Y=ENCLK
XHFSINV_95_504 INVXL $PINS A=EN Y=HFSNET_0
XZBUF_2_inst_1616 BUFX1 $PINS A=net1652 Y=ZBUF_2_12
.ENDS

.SUBCKT SNPS_CLOCK_GATE_HIGH_sar_calib_ctrl_serial_20_30_16_32_5_256_1_1_26 CLK
+ EN ENCLK TE ZCTSNET_1
Xlatch TLATNXL $PINS D=EN GN=CLK Q=net1652
Xmain_gate AND2X4 $PINS A=net1652 B=ZCTSNET_1 Y=ENCLK
.ENDS

.SUBCKT SNPS_CLOCK_GATE_HIGH_sar_calib_ctrl_serial_20_30_16_32_5_256_1_1_27 CLK
+ EN ENCLK TE ZCTSNET_1
Xlatch TLATNXL $PINS D=EN GN=CLK Q=net1652
Xmain_gate AND2X2 $PINS A=HFSNET_0 B=ZCTSNET_1 Y=ENCLK
XHFSBUF_2_271 BUFX1 $PINS A=net1652 Y=HFSNET_0
.ENDS

.SUBCKT SNPS_CLOCK_GATE_HIGH_sar_calib_ctrl_serial_20_30_16_32_5_256_1_1_28 CLK
+ EN ENCLK TE ZCTSNET_0
Xlatch TLATNXL $PINS D=EN GN=CLK Q=net1652
Xmain_gate AND2X2 $PINS A=ZBUF_2_12 B=ZCTSNET_0 Y=ENCLK
XZBUF_2_inst_1617 BUFX1 $PINS A=net1652 Y=ZBUF_2_12
.ENDS

.SUBCKT SNPS_CLOCK_GATE_HIGH_sar_calib_ctrl_serial_20_30_16_32_5_256_1_1_29 CLK
+ EN ENCLK TE ZCTSNET_1
Xlatch TLATNXL $PINS D=EN GN=CLK Q=net1652
Xmain_gate AND2X2 $PINS A=HFSNET_0 B=ZCTSNET_1 Y=ENCLK
XHFSBUF_2_270 CLKBUFX3 $PINS A=net1652 Y=HFSNET_0
.ENDS

.SUBCKT SNPS_CLOCK_GATE_HIGH_sar_calib_ctrl_serial_20_30_16_32_5_256_1_1_30 CLK
+ EN ENCLK TE ZCTSNET_1
Xlatch TLATNXL $PINS D=EN GN=CLK Q=net1652
Xmain_gate AND2X2 $PINS A=net1652 B=ZCTSNET_1 Y=ENCLK
.ENDS

.SUBCKT SNPS_CLOCK_GATE_HIGH_sar_calib_ctrl_serial_20_30_16_32_5_256_1_1_31 CLK
+ EN ENCLK TE ZCTSNET_1
Xlatch TLATNXL $PINS D=EN GN=CLK Q=net1652
Xmain_gate AND2X2 $PINS A=HFSNET_0 B=ZCTSNET_1 Y=ENCLK
XHFSBUF_2_268 CLKBUFX3 $PINS A=net1652 Y=HFSNET_0
.ENDS

.SUBCKT SNPS_CLOCK_GATE_HIGH_sar_calib_ctrl_serial_20_30_16_32_5_256_1_1_32 CLK
+ EN ENCLK TE ZCTSNET_0
Xlatch TLATNXL $PINS D=EN GN=CLK Q=net1652
Xmain_gate AND2X2 $PINS A=net1652 B=ZCTSNET_0 Y=ENCLK
.ENDS

.SUBCKT SNPS_CLOCK_GATE_HIGH_sar_calib_ctrl_serial_20_30_16_32_5_256_1_1_33 CLK
+ EN ENCLK TE ZCTSNET_0
Xlatch TLATNXL $PINS D=EN GN=CLK Q=net1652
Xmain_gate AND2X2 $PINS A=net1652 B=ZCTSNET_0 Y=ENCLK
.ENDS

.SUBCKT SNPS_CLOCK_GATE_HIGH_sar_calib_ctrl_serial_20_30_16_32_5_256_1_1_0 CLK
+ EN ENCLK TE ZCTSNET_0
Xlatch TLATNXL $PINS D=EN GN=CLK Q=net1652
Xmain_gate AND2X4 $PINS A=net1652 B=ZCTSNET_0 Y=ENCLK
.ENDS

.SUBCKT sar_calib_ctrl_serial_20_30_16_32_5_256_1_1 clk rst_n start_calib
+ calib_done calib_done_pulse calib_mode_en comp_out dac_p_force[19]
+ dac_p_force[18] dac_p_force[17] dac_p_force[16] dac_p_force[15]
+ dac_p_force[14] dac_p_force[13] dac_p_force[12] dac_p_force[11]
+ dac_p_force[10] dac_p_force[9] dac_p_force[8] dac_p_force[7] dac_p_force[6]
+ dac_p_force[5] dac_p_force[4] dac_p_force[3] dac_p_force[2] dac_p_force[1]
+ dac_p_force[0] dac_n_force[19] dac_n_force[18] dac_n_force[17]
+ dac_n_force[16] dac_n_force[15] dac_n_force[14] dac_n_force[13]
+ dac_n_force[12] dac_n_force[11] dac_n_force[10] dac_n_force[9] dac_n_force[8]
+ dac_n_force[7] dac_n_force[6] dac_n_force[5] dac_n_force[4] dac_n_force[3]
+ dac_n_force[2] dac_n_force[1] dac_n_force[0] w_wr_en w_wr_addr[4]
+ w_wr_addr[3] w_wr_addr[2] w_wr_addr[1] w_wr_addr[0] w_wr_data[29]
+ w_wr_data[28] w_wr_data[27] w_wr_data[26] w_wr_data[25] w_wr_data[24]
+ w_wr_data[23] w_wr_data[22] w_wr_data[21] w_wr_data[20] w_wr_data[19]
+ w_wr_data[18] w_wr_data[17] w_wr_data[16] w_wr_data[15] w_wr_data[14]
+ w_wr_data[13] w_wr_data[12] w_wr_data[11] w_wr_data[10] w_wr_data[9]
+ w_wr_data[8] w_wr_data[7] w_wr_data[6] w_wr_data[5] w_wr_data[4] w_wr_data[3]
+ w_wr_data[2] w_wr_data[1] w_wr_data[0] calib_overrange overrange_bits[19]
+ overrange_bits[18] overrange_bits[17] overrange_bits[16] overrange_bits[15]
+ overrange_bits[14] overrange_bits[13] overrange_bits[12] overrange_bits[11]
+ overrange_bits[10] overrange_bits[9] overrange_bits[8] overrange_bits[7]
+ overrange_bits[6] overrange_bits[5] overrange_bits[4] overrange_bits[3]
+ overrange_bits[2] overrange_bits[1] overrange_bits[0] HFSNET_351 HFSNET_365
+ HFSNET_371 HFSNET_381 HFSNET_382 ZBUF_24_2 ZBUF_22_2 ZCTSNET_411 ZCTSNET_413
+ gre_a_BUF_36_0 gre_a_BUF_36_1 gre_a_BUF_36_2 gre_a_BUF_36_3
Xclk_gate_shadow_weights_reg[0]
+ SNPS_CLOCK_GATE_HIGH_sar_calib_ctrl_serial_20_30_16_32_5_256_1_1_0 $PINS
+ CLK=clk EN=N1842 ENCLK=net1660 TE=VSS ZCTSNET_0=ZCTSNET_412
Xclk_gate_shadow_weights_reg[1]
+ SNPS_CLOCK_GATE_HIGH_sar_calib_ctrl_serial_20_30_16_32_5_256_1_1_33 $PINS
+ CLK=clk EN=N1841 ENCLK=net1666 TE=VSS ZCTSNET_0=ZCTSNET_412
Xclk_gate_shadow_weights_reg[2]
+ SNPS_CLOCK_GATE_HIGH_sar_calib_ctrl_serial_20_30_16_32_5_256_1_1_32 $PINS
+ CLK=clk EN=N1840 ENCLK=net1671 TE=VSS ZCTSNET_0=ZCTSNET_412
Xclk_gate_shadow_weights_reg[3]
+ SNPS_CLOCK_GATE_HIGH_sar_calib_ctrl_serial_20_30_16_32_5_256_1_1_31 $PINS
+ CLK=clk EN=N1839 ENCLK=net1676 TE=VSS ZCTSNET_1=ZCTSNET_412
Xclk_gate_shadow_weights_reg[4]
+ SNPS_CLOCK_GATE_HIGH_sar_calib_ctrl_serial_20_30_16_32_5_256_1_1_30 $PINS
+ CLK=clk EN=N1838 ENCLK=net1681 TE=VSS ZCTSNET_1=ZCTSNET_412
Xclk_gate_shadow_weights_reg[5]
+ SNPS_CLOCK_GATE_HIGH_sar_calib_ctrl_serial_20_30_16_32_5_256_1_1_29 $PINS
+ CLK=clk EN=N1837 ENCLK=net1686 TE=VSS ZCTSNET_1=ZCTSNET_412
Xclk_gate_shadow_weights_reg[6]
+ SNPS_CLOCK_GATE_HIGH_sar_calib_ctrl_serial_20_30_16_32_5_256_1_1_28 $PINS
+ CLK=clk EN=HFSNET_252 ENCLK=net1691 TE=VSS ZCTSNET_0=ZCTSNET_412
Xclk_gate_shadow_weights_reg[7]
+ SNPS_CLOCK_GATE_HIGH_sar_calib_ctrl_serial_20_30_16_32_5_256_1_1_27 $PINS
+ CLK=clk EN=N1835 ENCLK=net1696 TE=VSS ZCTSNET_1=ZCTSNET_412
Xclk_gate_shadow_weights_reg[8]
+ SNPS_CLOCK_GATE_HIGH_sar_calib_ctrl_serial_20_30_16_32_5_256_1_1_26 $PINS
+ CLK=clk EN=N1834 ENCLK=net1701 TE=VSS ZCTSNET_1=ZCTSNET_412
Xclk_gate_shadow_weights_reg[9]
+ SNPS_CLOCK_GATE_HIGH_sar_calib_ctrl_serial_20_30_16_32_5_256_1_1_25 $PINS
+ CLK=clk EN=N1833 ENCLK=net1706 TE=VSS ZCTSNET_1=ZCTSNET_412
Xclk_gate_shadow_weights_reg[10]
+ SNPS_CLOCK_GATE_HIGH_sar_calib_ctrl_serial_20_30_16_32_5_256_1_1_24 $PINS
+ CLK=clk EN=N1832 ENCLK=net1711 TE=VSS ZCTSNET_0=ZCTSNET_412
Xclk_gate_shadow_weights_reg[11]
+ SNPS_CLOCK_GATE_HIGH_sar_calib_ctrl_serial_20_30_16_32_5_256_1_1_23 $PINS
+ CLK=clk EN=N1831 ENCLK=net1716 TE=VSS ZCTSNET_1=ZCTSNET_412
Xclk_gate_shadow_weights_reg[12]
+ SNPS_CLOCK_GATE_HIGH_sar_calib_ctrl_serial_20_30_16_32_5_256_1_1_22 $PINS
+ CLK=clk EN=N1830 ENCLK=net1721 TE=VSS ZCTSNET_1=ZCTSNET_412
Xclk_gate_shadow_weights_reg[13]
+ SNPS_CLOCK_GATE_HIGH_sar_calib_ctrl_serial_20_30_16_32_5_256_1_1_21 $PINS
+ CLK=clk EN=HFSNET_269 ENCLK=net1726 TE=VSS ZCTSNET_0=ZCTSNET_412
Xclk_gate_shadow_weights_reg[14]
+ SNPS_CLOCK_GATE_HIGH_sar_calib_ctrl_serial_20_30_16_32_5_256_1_1_20 $PINS
+ CLK=clk EN=N1828 ENCLK=net1731 TE=VSS ZCTSNET_1=ZCTSNET_412
Xclk_gate_shadow_weights_reg[15]
+ SNPS_CLOCK_GATE_HIGH_sar_calib_ctrl_serial_20_30_16_32_5_256_1_1_19 $PINS
+ CLK=clk EN=N1827 ENCLK=net1736 TE=VSS ZCTSNET_0=ZCTSNET_412
Xclk_gate_shadow_weights_reg[16]
+ SNPS_CLOCK_GATE_HIGH_sar_calib_ctrl_serial_20_30_16_32_5_256_1_1_18 $PINS
+ CLK=clk EN=HFSNET_250 ENCLK=net1741 TE=VSS ZCTSNET_0=ZCTSNET_412
Xclk_gate_shadow_weights_reg[17]
+ SNPS_CLOCK_GATE_HIGH_sar_calib_ctrl_serial_20_30_16_32_5_256_1_1_17 $PINS
+ CLK=clk EN=N1825 ENCLK=net1746 TE=VSS ZCTSNET_1=ZCTSNET_412
Xclk_gate_shadow_weights_reg[18]
+ SNPS_CLOCK_GATE_HIGH_sar_calib_ctrl_serial_20_30_16_32_5_256_1_1_16 $PINS
+ CLK=ZCTSNET_412 EN=N1824 ENCLK=net1751 TE=VSS ZCTSNET_0=ZCTSNET_411
Xclk_gate_shadow_weights_reg[19]
+ SNPS_CLOCK_GATE_HIGH_sar_calib_ctrl_serial_20_30_16_32_5_256_1_1_15 $PINS
+ CLK=clk EN=N1823 ENCLK=net1756 TE=VSS ZCTSNET_0=ZCTSNET_412
Xclk_gate_calib_done_reg
+ SNPS_CLOCK_GATE_HIGH_sar_calib_ctrl_serial_20_30_16_32_5_256_1_1_14 $PINS
+ CLK=clk EN=N1485 ENCLK=net1761 TE=VSS
Xclk_gate_target_bit_reg
+ SNPS_CLOCK_GATE_HIGH_sar_calib_ctrl_serial_20_30_16_32_5_256_1_1_13 $PINS
+ CLK=clk EN=N1488 ENCLK=net1766 TE=VSS ZCTSNET_0=ZCTSNET_411
Xclk_gate_avg_cnt_reg
+ SNPS_CLOCK_GATE_HIGH_sar_calib_ctrl_serial_20_30_16_32_5_256_1_1_12 $PINS
+ CLK=ZCTSNET_411 EN=N1536 ENCLK=net1771 TE=VSS
Xclk_gate_accumulator_reg
+ SNPS_CLOCK_GATE_HIGH_sar_calib_ctrl_serial_20_30_16_32_5_256_1_1_11 $PINS
+ CLK=ZCTSNET_411 EN=N1536 ENCLK=net1776 TE=VSS
Xclk_gate_sar_ptr_reg
+ SNPS_CLOCK_GATE_HIGH_sar_calib_ctrl_serial_20_30_16_32_5_256_1_1_10 $PINS
+ CLK=clk EN=N1602 ENCLK=net1781 TE=VSS
Xclk_gate_wait_cnt_reg
+ SNPS_CLOCK_GATE_HIGH_sar_calib_ctrl_serial_20_30_16_32_5_256_1_1_9 $PINS
+ CLK=clk EN=N1608 ENCLK=net1786 TE=VSS
Xclk_gate_w_wr_addr_reg
+ SNPS_CLOCK_GATE_HIGH_sar_calib_ctrl_serial_20_30_16_32_5_256_1_1_8 $PINS
+ CLK=clk EN=N1822 ENCLK=net1791 TE=VSS ZCTSNET_0=ZCTSNET_412
Xclk_gate_w_wr_data_reg
+ SNPS_CLOCK_GATE_HIGH_sar_calib_ctrl_serial_20_30_16_32_5_256_1_1_7 $PINS
+ CLK=clk EN=N1822 ENCLK=net1796 TE=VSS ZCTSNET_0=ZCTSNET_412
Xclk_gate_meas_val_p_reg
+ SNPS_CLOCK_GATE_HIGH_sar_calib_ctrl_serial_20_30_16_32_5_256_1_1_6 $PINS
+ CLK=clk EN=N1692 ENCLK=net1801 TE=VSS ZCTSNET_2=ZCTSNET_411
Xclk_gate_meas_val_n_reg
+ SNPS_CLOCK_GATE_HIGH_sar_calib_ctrl_serial_20_30_16_32_5_256_1_1_5 $PINS
+ CLK=clk EN=N1723 ENCLK=net1806 TE=VSS ZCTSNET_2=ZCTSNET_411
Xclk_gate_calc_cnt_reg
+ SNPS_CLOCK_GATE_HIGH_sar_calib_ctrl_serial_20_30_16_32_5_256_1_1_4 $PINS
+ CLK=clk EN=N1614 ENCLK=net1811 TE=VSS
Xclk_gate_avg_rounded_r_reg
+ SNPS_CLOCK_GATE_HIGH_sar_calib_ctrl_serial_20_30_16_32_5_256_1_1_3 $PINS
+ CLK=ZCTSNET_408 EN=N1754 ENCLK=net1816 TE=VSS ZCTSNET_0=ZCTSNET_411
Xclk_gate_avg_rounded_r_reg_0
+ SNPS_CLOCK_GATE_HIGH_sar_calib_ctrl_serial_20_30_16_32_5_256_1_1_2 $PINS
+ CLK=ZCTSNET_408 EN=N1754 ENCLK=net1821 TE=VSS ZCTSNET_0=ZCTSNET_411
Xclk_gate_calc_result_r_reg
+ SNPS_CLOCK_GATE_HIGH_sar_calib_ctrl_serial_20_30_16_32_5_256_1_1_1 $PINS
+ CLK=ZCTSNET_408 EN=N1791 ENCLK=net1826 TE=VSS ZCTSNET_0=ZCTSNET_411
Xcomp_out_rr_reg DFFSX1 $PINS D=n2233 CK=clk SN=HFSNET_380 QN=comp_out_rr
Xstate_reg[3] DFFSX1 $PINS D=n822 CK=clk SN=HFSNET_381 Q=n2172 QN=state[3]
Xaccumulator_reg[19] DFFSXL $PINS D=n945 CK=net1776 SN=HFSNET_364
+ QN=accumulator[19]
Xaccumulator_reg[9] DFFSXL $PINS D=n954 CK=net1776 SN=HFSNET_364
+ QN=accumulator[9]
Xaccumulator_reg[5] DFFSX1 $PINS D=n817 CK=net1776 SN=HFSNET_352
+ QN=accumulator[5]
Xaccumulator_reg[4] DFFSXL $PINS D=n958 CK=net1776 SN=HFSNET_352
+ QN=accumulator[4]
Xaccumulator_reg[3] DFFSXL $PINS D=n959 CK=net1776 SN=HFSNET_352
+ QN=accumulator[3]
Xaccumulator_reg[2] DFFSXL $PINS D=n960 CK=net1776 SN=HFSNET_353
+ QN=accumulator[2]
Xavg_cnt_reg[3] DFFSXL $PINS D=n964 CK=net1771 SN=HFSNET_354 QN=avg_cnt[3]
Xavg_cnt_reg[2] DFFSXL $PINS D=n965 CK=net1771 SN=HFSNET_354 QN=avg_cnt[2]
Xavg_cnt_reg[1] DFFSXL $PINS D=n966 CK=net1771 SN=HFSNET_354 QN=avg_cnt[1]
Xavg_cnt_reg[0] DFFSXL $PINS D=n967 CK=net1771 SN=HFSNET_354 QN=avg_cnt[0]
Xavg_rounded_r_reg[17] DFFSXL $PINS D=n878 CK=net1821 SN=HFSNET_354
+ QN=avg_rounded_r[17]
Xcalc_result_r_reg[11] DFFSXL $PINS D=n848 CK=net1826 SN=HFSNET_363
+ QN=calc_result_r[11]
Xshadow_weights_reg[19][11] DFFSXL $PINS D=gre_a_INV_1788_54 CK=ZCTSNET_397
+ SN=HFSNET_359 QN=shadow_weights[19][11]
Xavg_rounded_r_reg[16] DFFSXL $PINS D=n879 CK=net1821 SN=HFSNET_354
+ QN=avg_rounded_r[16]
Xcalc_result_r_reg[10] DFFSXL $PINS D=n849 CK=net1826 SN=HFSNET_355
+ QN=calc_result_r[10]
Xshadow_weights_reg[19][10] DFFSXL $PINS D=HFSNET_301 CK=ZCTSNET_397
+ SN=HFSNET_359 QN=shadow_weights[19][10]
Xavg_rounded_r_reg[15] DFFSXL $PINS D=n880 CK=net1821 SN=HFSNET_354
+ QN=avg_rounded_r[15]
Xshadow_weights_reg[19][9] DFFSXL $PINS D=n69 CK=ZCTSNET_397 SN=HFSNET_359
+ QN=shadow_weights[19][9]
Xavg_rounded_r_reg[14] DFFSXL $PINS D=n881 CK=net1821 SN=HFSNET_354
+ QN=avg_rounded_r[14]
Xshadow_weights_reg[19][8] DFFSXL $PINS D=HFSNET_296 CK=ZCTSNET_397
+ SN=HFSNET_359 QN=shadow_weights[19][8]
Xcalc_result_r_reg[7] DFFSXL $PINS D=n852 CK=net1826 SN=HFSNET_354
+ QN=calc_result_r[7]
Xshadow_weights_reg[19][7] DFFSXL $PINS D=HFSNET_341 CK=ZCTSNET_397
+ SN=HFSNET_359 QN=shadow_weights[19][7]
Xavg_rounded_r_reg[12] DFFSXL $PINS D=HFSNET_7 CK=net1821 SN=HFSNET_354
+ QN=avg_rounded_r[12]
Xcalc_result_r_reg[6] DFFSXL $PINS D=n853 CK=net1826 SN=HFSNET_354
+ QN=calc_result_r[6]
Xshadow_weights_reg[19][6] DFFSXL $PINS D=HFSNET_339 CK=ZCTSNET_397
+ SN=HFSNET_356 QN=shadow_weights[19][6]
Xavg_rounded_r_reg[11] DFFSXL $PINS D=HFSNET_8 CK=net1821 SN=HFSNET_354
+ QN=avg_rounded_r[11]
Xcalc_result_r_reg[5] DFFSXL $PINS D=n854 CK=net1826 SN=HFSNET_355
+ QN=calc_result_r[5]
Xshadow_weights_reg[19][5] DFFSXL $PINS D=HFSNET_337 CK=ZCTSNET_397
+ SN=HFSNET_362 QN=shadow_weights[19][5]
Xavg_rounded_r_reg[10] DFFSXL $PINS D=n885 CK=net1821 SN=HFSNET_354
+ QN=avg_rounded_r[10]
Xcalc_result_r_reg[4] DFFSXL $PINS D=n855 CK=net1826 SN=HFSNET_363
+ QN=calc_result_r[4]
Xshadow_weights_reg[19][4] DFFSXL $PINS D=HFSNET_336 CK=ZCTSNET_397
+ SN=HFSNET_359 QN=shadow_weights[19][4]
Xavg_rounded_r_reg[9] DFFSXL $PINS D=n886 CK=net1821 SN=HFSNET_354
+ QN=avg_rounded_r[9]
Xcalc_result_r_reg[3] DFFSXL $PINS D=n856 CK=net1826 SN=HFSNET_355
+ QN=calc_result_r[3]
Xshadow_weights_reg[19][3] DFFSXL $PINS D=HFSNET_332 CK=ZCTSNET_397
+ SN=HFSNET_359 QN=shadow_weights[19][3]
Xcalc_result_r_reg[2] DFFSXL $PINS D=n857 CK=net1826 SN=HFSNET_355
+ QN=calc_result_r[2]
Xshadow_weights_reg[19][2] DFFSXL $PINS D=HFSNET_327 CK=ZCTSNET_397
+ SN=HFSNET_359 QN=shadow_weights[19][2]
Xavg_rounded_r_reg[7] DFFSXL $PINS D=n888 CK=net1821 SN=HFSNET_354
+ QN=avg_rounded_r[7]
Xcalc_result_r_reg[1] DFFSXL $PINS D=n858 CK=net1826 SN=HFSNET_363
+ QN=calc_result_r[1]
Xshadow_weights_reg[19][1] DFFSXL $PINS D=HFSNET_317 CK=ZCTSNET_397
+ SN=HFSNET_359 QN=shadow_weights[19][1]
Xavg_rounded_r_reg[6] DFFSXL $PINS D=HFSNET_3 CK=net1821 SN=HFSNET_354
+ QN=avg_rounded_r[6]
Xcalc_result_r_reg[0] DFFSXL $PINS D=n859 CK=net1826 SN=HFSNET_354
+ QN=calc_result_r[0]
Xshadow_weights_reg[19][0] DFFSXL $PINS D=HFSNET_311 CK=ZCTSNET_397
+ SN=HFSNET_359 QN=shadow_weights[19][0]
Xshadow_weights_reg[2][11] DFFSXL $PINS D=gre_a_INV_1788_54 CK=ZCTSNET_399
+ SN=HFSNET_357 QN=shadow_weights[2][11]
Xshadow_weights_reg[2][9] DFFSXL $PINS D=n69 CK=ZCTSNET_399 SN=HFSNET_357
+ QN=shadow_weights[2][9]
Xshadow_weights_reg[2][8] DFFSXL $PINS D=HFSNET_296 CK=ZCTSNET_399
+ SN=HFSNET_357 QN=shadow_weights[2][8]
Xshadow_weights_reg[2][7] DFFSXL $PINS D=HFSNET_341 CK=ZCTSNET_399
+ SN=HFSNET_357 QN=shadow_weights[2][7]
Xshadow_weights_reg[2][6] DFFSXL $PINS D=HFSNET_339 CK=ZCTSNET_399
+ SN=HFSNET_357 QN=shadow_weights[2][6]
Xshadow_weights_reg[2][5] DFFSXL $PINS D=HFSNET_337 CK=ZCTSNET_399
+ SN=HFSNET_357 QN=shadow_weights[2][5]
Xshadow_weights_reg[2][3] DFFSXL $PINS D=HFSNET_332 CK=ZCTSNET_399
+ SN=HFSNET_360 QN=shadow_weights[2][3]
Xshadow_weights_reg[2][2] DFFSXL $PINS D=HFSNET_327 CK=ZCTSNET_399
+ SN=HFSNET_356 QN=shadow_weights[2][2]
Xshadow_weights_reg[2][1] DFFSXL $PINS D=HFSNET_317 CK=ZCTSNET_399
+ SN=HFSNET_357 QN=shadow_weights[2][1]
Xshadow_weights_reg[2][0] DFFSXL $PINS D=HFSNET_311 CK=ZCTSNET_399
+ SN=HFSNET_357 QN=shadow_weights[2][0]
Xshadow_weights_reg[3][10] DFFSXL $PINS D=HFSNET_301 CK=ZCTSNET_400
+ SN=HFSNET_358 QN=shadow_weights[3][10]
Xshadow_weights_reg[3][9] DFFSXL $PINS D=n69 CK=ZCTSNET_400 SN=HFSNET_368
+ QN=shadow_weights[3][9]
Xshadow_weights_reg[3][8] DFFSXL $PINS D=HFSNET_296 CK=ZCTSNET_400
+ SN=HFSNET_375 QN=shadow_weights[3][8]
Xshadow_weights_reg[3][7] DFFSXL $PINS D=HFSNET_341 CK=ZCTSNET_400
+ SN=HFSNET_358 QN=shadow_weights[3][7]
Xshadow_weights_reg[3][6] DFFSXL $PINS D=HFSNET_339 CK=ZCTSNET_400
+ SN=HFSNET_377 QN=shadow_weights[3][6]
Xshadow_weights_reg[3][5] DFFSXL $PINS D=HFSNET_337 CK=ZCTSNET_400
+ SN=HFSNET_358 QN=shadow_weights[3][5]
Xshadow_weights_reg[3][4] DFFSXL $PINS D=HFSNET_336 CK=ZCTSNET_400
+ SN=HFSNET_375 QN=shadow_weights[3][4]
Xshadow_weights_reg[3][3] DFFSXL $PINS D=HFSNET_332 CK=ZCTSNET_400
+ SN=HFSNET_375 QN=shadow_weights[3][3]
Xshadow_weights_reg[3][2] DFFSXL $PINS D=HFSNET_327 CK=ZCTSNET_400
+ SN=HFSNET_375 QN=shadow_weights[3][2]
Xshadow_weights_reg[3][1] DFFSXL $PINS D=HFSNET_317 CK=ZCTSNET_400
+ SN=HFSNET_378 QN=shadow_weights[3][1]
Xshadow_weights_reg[6][11] DFFSXL $PINS D=gre_a_INV_1788_54 CK=ZCTSNET_403
+ SN=HFSNET_361 QN=shadow_weights[6][11]
Xshadow_weights_reg[6][10] DFFSXL $PINS D=HFSNET_301 CK=ZCTSNET_403
+ SN=HFSNET_357 QN=shadow_weights[6][10]
Xshadow_weights_reg[6][9] DFFSXL $PINS D=n69 CK=ZCTSNET_403 SN=HFSNET_360
+ QN=shadow_weights[6][9]
Xshadow_weights_reg[6][8] DFFSXL $PINS D=HFSNET_296 CK=ZCTSNET_403
+ SN=HFSNET_361 QN=shadow_weights[6][8]
Xshadow_weights_reg[6][7] DFFSXL $PINS D=HFSNET_341 CK=ZCTSNET_403
+ SN=HFSNET_361 QN=shadow_weights[6][7]
Xshadow_weights_reg[6][6] DFFSXL $PINS D=HFSNET_339 CK=ZCTSNET_403
+ SN=HFSNET_361 QN=shadow_weights[6][6]
Xshadow_weights_reg[6][5] DFFSXL $PINS D=HFSNET_337 CK=ZCTSNET_403
+ SN=HFSNET_361 QN=shadow_weights[6][5]
Xshadow_weights_reg[6][4] DFFSXL $PINS D=HFSNET_336 CK=ZCTSNET_403
+ SN=HFSNET_361 QN=shadow_weights[6][4]
Xshadow_weights_reg[6][3] DFFSXL $PINS D=HFSNET_332 CK=ZCTSNET_403
+ SN=HFSNET_361 QN=shadow_weights[6][3]
Xshadow_weights_reg[6][2] DFFSXL $PINS D=HFSNET_327 CK=ZCTSNET_403
+ SN=HFSNET_361 QN=shadow_weights[6][2]
Xshadow_weights_reg[6][1] DFFSXL $PINS D=HFSNET_317 CK=ZCTSNET_403
+ SN=HFSNET_361 QN=shadow_weights[6][1]
Xshadow_weights_reg[6][0] DFFSXL $PINS D=HFSNET_311 CK=ZCTSNET_403
+ SN=HFSNET_361 QN=shadow_weights[6][0]
Xshadow_weights_reg[7][11] DFFSXL $PINS D=gre_a_INV_1788_54 CK=ZCTSNET_404
+ SN=HFSNET_375 QN=shadow_weights[7][11]
Xshadow_weights_reg[7][10] DFFSXL $PINS D=HFSNET_301 CK=ZCTSNET_404
+ SN=HFSNET_375 QN=shadow_weights[7][10]
Xshadow_weights_reg[7][8] DFFSXL $PINS D=HFSNET_296 CK=ZCTSNET_404
+ SN=HFSNET_376 QN=shadow_weights[7][8]
Xshadow_weights_reg[7][7] DFFSXL $PINS D=HFSNET_341 CK=ZCTSNET_404
+ SN=HFSNET_361 QN=shadow_weights[7][7]
Xshadow_weights_reg[7][6] DFFSXL $PINS D=HFSNET_339 CK=ZCTSNET_404
+ SN=HFSNET_375 QN=shadow_weights[7][6]
Xshadow_weights_reg[7][5] DFFSXL $PINS D=HFSNET_337 CK=ZCTSNET_404
+ SN=HFSNET_368 QN=shadow_weights[7][5]
Xshadow_weights_reg[7][4] DFFSXL $PINS D=HFSNET_336 CK=ZCTSNET_404
+ SN=HFSNET_374 QN=shadow_weights[7][4]
Xshadow_weights_reg[7][3] DFFSXL $PINS D=HFSNET_332 CK=ZCTSNET_404
+ SN=HFSNET_377 QN=shadow_weights[7][3]
Xshadow_weights_reg[7][2] DFFSXL $PINS D=HFSNET_327 CK=ZCTSNET_404
+ SN=HFSNET_358 QN=shadow_weights[7][2]
Xshadow_weights_reg[7][1] DFFSXL $PINS D=HFSNET_317 CK=ZCTSNET_404
+ SN=HFSNET_376 QN=shadow_weights[7][1]
Xshadow_weights_reg[7][0] DFFSXL $PINS D=HFSNET_311 CK=ZCTSNET_404
+ SN=HFSNET_358 QN=shadow_weights[7][0]
Xshadow_weights_reg[10][11] DFFSXL $PINS D=gre_a_INV_1788_54 CK=ZCTSNET_388
+ SN=HFSNET_369 QN=shadow_weights[10][11]
Xshadow_weights_reg[10][10] DFFSXL $PINS D=HFSNET_301 CK=ZCTSNET_388
+ SN=HFSNET_360 QN=shadow_weights[10][10]
Xshadow_weights_reg[10][9] DFFSXL $PINS D=n69 CK=ZCTSNET_388 SN=HFSNET_369
+ QN=shadow_weights[10][9]
Xshadow_weights_reg[10][8] DFFSXL $PINS D=n70 CK=ZCTSNET_388 SN=HFSNET_363
+ QN=shadow_weights[10][8]
Xshadow_weights_reg[10][7] DFFSXL $PINS D=HFSNET_341 CK=ZCTSNET_388
+ SN=HFSNET_356 QN=shadow_weights[10][7]
Xshadow_weights_reg[10][5] DFFSXL $PINS D=HFSNET_337 CK=ZCTSNET_388
+ SN=HFSNET_369 QN=shadow_weights[10][5]
Xshadow_weights_reg[10][4] DFFSXL $PINS D=HFSNET_336 CK=ZCTSNET_388
+ SN=HFSNET_360 QN=shadow_weights[10][4]
Xshadow_weights_reg[10][3] DFFSXL $PINS D=HFSNET_332 CK=ZCTSNET_388
+ SN=HFSNET_360 QN=shadow_weights[10][3]
Xshadow_weights_reg[10][2] DFFSXL $PINS D=HFSNET_327 CK=ZCTSNET_388
+ SN=HFSNET_360 QN=shadow_weights[10][2]
Xshadow_weights_reg[10][1] DFFSXL $PINS D=HFSNET_317 CK=ZCTSNET_388
+ SN=HFSNET_356 QN=shadow_weights[10][1]
Xshadow_weights_reg[10][0] DFFSXL $PINS D=HFSNET_311 CK=ZCTSNET_388
+ SN=HFSNET_356 QN=shadow_weights[10][0]
Xshadow_weights_reg[14][11] DFFSXL $PINS D=gre_a_INV_1788_54 CK=ZCTSNET_392
+ SN=HFSNET_377 QN=shadow_weights[14][11]
Xshadow_weights_reg[14][10] DFFSXL $PINS D=HFSNET_301 CK=ZCTSNET_392
+ SN=HFSNET_377 QN=shadow_weights[14][10]
Xshadow_weights_reg[14][9] DFFSXL $PINS D=n69 CK=ZCTSNET_392 SN=HFSNET_377
+ QN=shadow_weights[14][9]
Xshadow_weights_reg[14][8] DFFSXL $PINS D=n70 CK=ZCTSNET_392 SN=HFSNET_377
+ QN=shadow_weights[14][8]
Xshadow_weights_reg[14][7] DFFSXL $PINS D=HFSNET_341 CK=ZCTSNET_392
+ SN=HFSNET_374 QN=shadow_weights[14][7]
Xshadow_weights_reg[14][6] DFFSXL $PINS D=HFSNET_339 CK=ZCTSNET_392
+ SN=HFSNET_377 QN=shadow_weights[14][6]
Xshadow_weights_reg[14][5] DFFSXL $PINS D=HFSNET_337 CK=ZCTSNET_392
+ SN=HFSNET_377 QN=shadow_weights[14][5]
Xshadow_weights_reg[14][4] DFFSXL $PINS D=HFSNET_336 CK=ZCTSNET_392
+ SN=HFSNET_374 QN=shadow_weights[14][4]
Xshadow_weights_reg[14][2] DFFSXL $PINS D=HFSNET_327 CK=ZCTSNET_392
+ SN=HFSNET_378 QN=shadow_weights[14][2]
Xshadow_weights_reg[14][1] DFFSXL $PINS D=HFSNET_317 CK=ZCTSNET_392
+ SN=HFSNET_377 QN=shadow_weights[14][1]
Xshadow_weights_reg[14][0] DFFSXL $PINS D=HFSNET_311 CK=ZCTSNET_392
+ SN=HFSNET_377 QN=shadow_weights[14][0]
Xshadow_weights_reg[15][11] DFFSXL $PINS D=gre_a_INV_1788_54 CK=ZCTSNET_393
+ SN=HFSNET_361 QN=shadow_weights[15][11]
Xshadow_weights_reg[15][10] DFFSXL $PINS D=HFSNET_301 CK=ZCTSNET_393
+ SN=HFSNET_360 QN=shadow_weights[15][10]
Xshadow_weights_reg[15][9] DFFSXL $PINS D=n69 CK=ZCTSNET_393 SN=HFSNET_360
+ QN=shadow_weights[15][9]
Xshadow_weights_reg[15][8] DFFSXL $PINS D=HFSNET_296 CK=ZCTSNET_393
+ SN=HFSNET_361 QN=shadow_weights[15][8]
Xshadow_weights_reg[15][6] DFFSXL $PINS D=HFSNET_339 CK=ZCTSNET_393
+ SN=HFSNET_361 QN=shadow_weights[15][6]
Xshadow_weights_reg[15][5] DFFSXL $PINS D=HFSNET_337 CK=ZCTSNET_393
+ SN=HFSNET_360 QN=shadow_weights[15][5]
Xshadow_weights_reg[15][4] DFFSXL $PINS D=HFSNET_336 CK=ZCTSNET_393
+ SN=HFSNET_360 QN=shadow_weights[15][4]
Xshadow_weights_reg[15][3] DFFSXL $PINS D=HFSNET_332 CK=ZCTSNET_393
+ SN=HFSNET_361 QN=shadow_weights[15][3]
Xshadow_weights_reg[15][2] DFFSXL $PINS D=HFSNET_327 CK=ZCTSNET_393
+ SN=HFSNET_361 QN=shadow_weights[15][2]
Xshadow_weights_reg[15][1] DFFSXL $PINS D=HFSNET_317 CK=ZCTSNET_393
+ SN=HFSNET_360 QN=shadow_weights[15][1]
Xshadow_weights_reg[15][0] DFFSXL $PINS D=HFSNET_311 CK=ZCTSNET_393
+ SN=HFSNET_360 QN=shadow_weights[15][0]
Xshadow_weights_reg[0][10] DFFSXL $PINS D=HFSNET_301 CK=net1660 SN=HFSNET_369
+ QN=shadow_weights[0][10]
Xshadow_weights_reg[0][9] DFFSXL $PINS D=n69 CK=net1660 SN=HFSNET_369
+ QN=shadow_weights[0][9]
Xshadow_weights_reg[0][7] DFFSXL $PINS D=HFSNET_341 CK=net1660 SN=HFSNET_358
+ QN=shadow_weights[0][7]
Xshadow_weights_reg[0][6] DFFSXL $PINS D=HFSNET_339 CK=net1660 SN=HFSNET_357
+ QN=shadow_weights[0][6]
Xshadow_weights_reg[0][5] DFFSXL $PINS D=HFSNET_337 CK=net1660 SN=HFSNET_369
+ QN=shadow_weights[0][5]
Xshadow_weights_reg[0][4] DFFSXL $PINS D=HFSNET_336 CK=net1660 SN=HFSNET_357
+ QN=shadow_weights[0][4]
Xshadow_weights_reg[0][3] DFFSXL $PINS D=HFSNET_332 CK=net1660 SN=HFSNET_369
+ QN=shadow_weights[0][3]
Xshadow_weights_reg[0][2] DFFSXL $PINS D=HFSNET_327 CK=net1660 SN=HFSNET_357
+ QN=shadow_weights[0][2]
Xshadow_weights_reg[0][1] DFFSXL $PINS D=HFSNET_317 CK=net1660 SN=HFSNET_358
+ QN=shadow_weights[0][1]
Xshadow_weights_reg[0][0] DFFSXL $PINS D=HFSNET_311 CK=net1660 SN=HFSNET_357
+ QN=shadow_weights[0][0]
Xshadow_weights_reg[5][11] DFFSXL $PINS D=gre_a_INV_1788_54 CK=ZCTSNET_402
+ SN=HFSNET_377 QN=shadow_weights[5][11]
Xshadow_weights_reg[5][10] DFFSXL $PINS D=HFSNET_301 CK=ZCTSNET_402
+ SN=HFSNET_377 QN=shadow_weights[5][10]
Xshadow_weights_reg[5][9] DFFSXL $PINS D=n69 CK=ZCTSNET_402 SN=HFSNET_377
+ QN=shadow_weights[5][9]
Xshadow_weights_reg[5][8] DFFSXL $PINS D=n70 CK=ZCTSNET_402 SN=HFSNET_378
+ QN=shadow_weights[5][8]
Xshadow_weights_reg[5][6] DFFSXL $PINS D=HFSNET_339 CK=ZCTSNET_402
+ SN=HFSNET_377 QN=shadow_weights[5][6]
Xshadow_weights_reg[5][5] DFFSXL $PINS D=HFSNET_337 CK=ZCTSNET_402
+ SN=HFSNET_358 QN=shadow_weights[5][5]
Xshadow_weights_reg[5][4] DFFSXL $PINS D=HFSNET_336 CK=ZCTSNET_402
+ SN=HFSNET_377 QN=shadow_weights[5][4]
Xshadow_weights_reg[5][3] DFFSXL $PINS D=HFSNET_332 CK=ZCTSNET_402
+ SN=HFSNET_378 QN=shadow_weights[5][3]
Xshadow_weights_reg[5][2] DFFSXL $PINS D=HFSNET_327 CK=ZCTSNET_402
+ SN=HFSNET_378 QN=shadow_weights[5][2]
Xshadow_weights_reg[5][1] DFFSXL $PINS D=HFSNET_317 CK=ZCTSNET_402
+ SN=HFSNET_378 QN=shadow_weights[5][1]
Xshadow_weights_reg[5][0] DFFSXL $PINS D=HFSNET_311 CK=ZCTSNET_402
+ SN=HFSNET_358 QN=shadow_weights[5][0]
Xshadow_weights_reg[8][11] DFFSXL $PINS D=gre_a_INV_1788_54 CK=net1701
+ SN=HFSNET_360 QN=shadow_weights[8][11]
Xshadow_weights_reg[8][10] DFFSXL $PINS D=HFSNET_301 CK=net1701 SN=HFSNET_359
+ QN=shadow_weights[8][10]
Xshadow_weights_reg[8][9] DFFSXL $PINS D=n69 CK=net1701 SN=HFSNET_367
+ QN=shadow_weights[8][9]
Xshadow_weights_reg[8][8] DFFSXL $PINS D=n70 CK=net1701 SN=HFSNET_367
+ QN=shadow_weights[8][8]
Xshadow_weights_reg[8][7] DFFSXL $PINS D=HFSNET_341 CK=net1701 SN=HFSNET_356
+ QN=shadow_weights[8][7]
Xshadow_weights_reg[8][6] DFFSXL $PINS D=HFSNET_339 CK=net1701 SN=HFSNET_359
+ QN=shadow_weights[8][6]
Xshadow_weights_reg[8][5] DFFSXL $PINS D=HFSNET_337 CK=net1701 SN=HFSNET_356
+ QN=shadow_weights[8][5]
Xshadow_weights_reg[8][3] DFFSXL $PINS D=HFSNET_332 CK=net1701 SN=HFSNET_360
+ QN=shadow_weights[8][3]
Xshadow_weights_reg[8][2] DFFSXL $PINS D=HFSNET_327 CK=net1701 SN=HFSNET_360
+ QN=shadow_weights[8][2]
Xshadow_weights_reg[8][1] DFFSXL $PINS D=HFSNET_317 CK=net1701 SN=HFSNET_356
+ QN=shadow_weights[8][1]
Xshadow_weights_reg[8][0] DFFSXL $PINS D=HFSNET_311 CK=net1701 SN=HFSNET_356
+ QN=shadow_weights[8][0]
Xshadow_weights_reg[12][11] DFFSXL $PINS D=gre_a_INV_1788_54 CK=ZCTSNET_390
+ SN=HFSNET_378 QN=shadow_weights[12][11]
Xshadow_weights_reg[12][10] DFFSX1 $PINS D=HFSNET_301 CK=ZCTSNET_390
+ SN=HFSNET_358 QN=shadow_weights[12][10]
Xshadow_weights_reg[12][9] DFFSXL $PINS D=n69 CK=ZCTSNET_390 SN=HFSNET_377
+ QN=shadow_weights[12][9]
Xshadow_weights_reg[12][8] DFFSXL $PINS D=n70 CK=ZCTSNET_390 SN=HFSNET_378
+ QN=shadow_weights[12][8]
Xshadow_weights_reg[12][7] DFFSXL $PINS D=HFSNET_341 CK=ZCTSNET_390
+ SN=HFSNET_378 QN=shadow_weights[12][7]
Xshadow_weights_reg[12][6] DFFSXL $PINS D=HFSNET_339 CK=ZCTSNET_390
+ SN=HFSNET_377 QN=shadow_weights[12][6]
Xshadow_weights_reg[12][5] DFFSXL $PINS D=HFSNET_337 CK=ZCTSNET_390
+ SN=HFSNET_378 QN=shadow_weights[12][5]
Xshadow_weights_reg[12][4] DFFSXL $PINS D=HFSNET_336 CK=ZCTSNET_390
+ SN=HFSNET_378 QN=shadow_weights[12][4]
Xshadow_weights_reg[12][3] DFFSXL $PINS D=HFSNET_332 CK=ZCTSNET_390
+ SN=HFSNET_378 QN=shadow_weights[12][3]
Xshadow_weights_reg[12][2] DFFSXL $PINS D=HFSNET_327 CK=ZCTSNET_390
+ SN=HFSNET_378 QN=shadow_weights[12][2]
Xshadow_weights_reg[12][0] DFFSXL $PINS D=HFSNET_311 CK=ZCTSNET_390
+ SN=HFSNET_374 QN=shadow_weights[12][0]
Xshadow_weights_reg[13][11] DFFSXL $PINS D=gre_a_INV_1788_54 CK=ZCTSNET_391
+ SN=HFSNET_368 QN=shadow_weights[13][11]
Xshadow_weights_reg[13][10] DFFSXL $PINS D=HFSNET_301 CK=ZCTSNET_391
+ SN=HFSNET_360 QN=shadow_weights[13][10]
Xshadow_weights_reg[13][9] DFFSXL $PINS D=n69 CK=ZCTSNET_391 SN=HFSNET_360
+ QN=shadow_weights[13][9]
Xshadow_weights_reg[13][8] DFFSXL $PINS D=HFSNET_296 CK=ZCTSNET_391
+ SN=HFSNET_361 QN=shadow_weights[13][8]
Xshadow_weights_reg[13][7] DFFSXL $PINS D=HFSNET_341 CK=ZCTSNET_391
+ SN=HFSNET_361 QN=shadow_weights[13][7]
Xshadow_weights_reg[13][6] DFFSXL $PINS D=HFSNET_339 CK=ZCTSNET_391
+ SN=HFSNET_360 QN=shadow_weights[13][6]
Xshadow_weights_reg[13][5] DFFSXL $PINS D=HFSNET_337 CK=ZCTSNET_391
+ SN=HFSNET_360 QN=shadow_weights[13][5]
Xshadow_weights_reg[13][4] DFFSXL $PINS D=HFSNET_336 CK=ZCTSNET_391
+ SN=HFSNET_361 QN=shadow_weights[13][4]
Xshadow_weights_reg[13][3] DFFSXL $PINS D=HFSNET_332 CK=ZCTSNET_391
+ SN=HFSNET_361 QN=shadow_weights[13][3]
Xshadow_weights_reg[13][2] DFFSXL $PINS D=HFSNET_327 CK=ZCTSNET_391
+ SN=HFSNET_360 QN=shadow_weights[13][2]
Xshadow_weights_reg[13][1] DFFSXL $PINS D=HFSNET_317 CK=ZCTSNET_391
+ SN=HFSNET_360 QN=shadow_weights[13][1]
Xshadow_weights_reg[13][0] DFFSXL $PINS D=HFSNET_311 CK=ZCTSNET_391
+ SN=HFSNET_361 QN=shadow_weights[13][0]
Xshadow_weights_reg[1][11] DFFSXL $PINS D=gre_a_INV_1788_54 CK=ZCTSNET_398
+ SN=HFSNET_374 QN=shadow_weights[1][11]
Xshadow_weights_reg[1][8] DFFSXL $PINS D=HFSNET_296 CK=ZCTSNET_398
+ SN=HFSNET_375 QN=shadow_weights[1][8]
Xshadow_weights_reg[1][7] DFFSXL $PINS D=HFSNET_341 CK=ZCTSNET_398
+ SN=HFSNET_375 QN=shadow_weights[1][7]
Xshadow_weights_reg[1][6] DFFSXL $PINS D=HFSNET_339 CK=ZCTSNET_398
+ SN=HFSNET_376 QN=shadow_weights[1][6]
Xshadow_weights_reg[1][5] DFFSXL $PINS D=HFSNET_337 CK=ZCTSNET_398
+ SN=HFSNET_375 QN=shadow_weights[1][5]
Xshadow_weights_reg[1][4] DFFSXL $PINS D=HFSNET_336 CK=ZCTSNET_398
+ SN=HFSNET_375 QN=shadow_weights[1][4]
Xshadow_weights_reg[1][3] DFFSXL $PINS D=HFSNET_332 CK=ZCTSNET_398
+ SN=HFSNET_375 QN=shadow_weights[1][3]
Xshadow_weights_reg[1][2] DFFSXL $PINS D=HFSNET_327 CK=ZCTSNET_398
+ SN=HFSNET_376 QN=shadow_weights[1][2]
Xshadow_weights_reg[1][1] DFFSXL $PINS D=HFSNET_317 CK=ZCTSNET_398
+ SN=HFSNET_358 QN=shadow_weights[1][1]
Xshadow_weights_reg[1][0] DFFSXL $PINS D=HFSNET_311 CK=ZCTSNET_398
+ SN=HFSNET_376 QN=shadow_weights[1][0]
Xshadow_weights_reg[9][11] DFFSXL $PINS D=gre_a_INV_1788_54 CK=ZCTSNET_406
+ SN=HFSNET_377 QN=shadow_weights[9][11]
Xshadow_weights_reg[9][10] DFFSXL $PINS D=HFSNET_301 CK=ZCTSNET_406
+ SN=HFSNET_378 QN=shadow_weights[9][10]
Xshadow_weights_reg[9][9] DFFSXL $PINS D=n69 CK=ZCTSNET_406 SN=HFSNET_376
+ QN=shadow_weights[9][9]
Xshadow_weights_reg[9][8] DFFSXL $PINS D=HFSNET_296 CK=ZCTSNET_406
+ SN=HFSNET_376 QN=shadow_weights[9][8]
Xshadow_weights_reg[9][7] DFFSXL $PINS D=HFSNET_341 CK=ZCTSNET_406
+ SN=HFSNET_375 QN=shadow_weights[9][7]
Xshadow_weights_reg[9][5] DFFSXL $PINS D=HFSNET_337 CK=ZCTSNET_406
+ SN=HFSNET_375 QN=shadow_weights[9][5]
Xshadow_weights_reg[9][4] DFFSXL $PINS D=HFSNET_336 CK=ZCTSNET_406
+ SN=HFSNET_375 QN=shadow_weights[9][4]
Xshadow_weights_reg[9][3] DFFSXL $PINS D=HFSNET_332 CK=ZCTSNET_406
+ SN=HFSNET_376 QN=shadow_weights[9][3]
Xshadow_weights_reg[9][2] DFFSXL $PINS D=HFSNET_327 CK=ZCTSNET_406
+ SN=HFSNET_376 QN=shadow_weights[9][2]
Xshadow_weights_reg[9][1] DFFSXL $PINS D=HFSNET_317 CK=ZCTSNET_406
+ SN=HFSNET_376 QN=shadow_weights[9][1]
Xshadow_weights_reg[9][0] DFFSXL $PINS D=HFSNET_311 CK=ZCTSNET_406
+ SN=HFSNET_376 QN=shadow_weights[9][0]
Xavg_rounded_r_reg[20] DFFSXL $PINS D=n875 CK=net1816 SN=HFSNET_354
+ QN=avg_rounded_r[20]
Xcalc_result_r_reg[14] DFFSXL $PINS D=n845 CK=net1826 SN=HFSNET_354
+ QN=calc_result_r[14]
Xshadow_weights_reg[19][14] DFFSXL $PINS D=HFSNET_312 CK=ZCTSNET_397
+ SN=HFSNET_359 QN=shadow_weights[19][14]
Xshadow_weights_reg[15][14] DFFSXL $PINS D=HFSNET_312 CK=ZCTSNET_393
+ SN=HFSNET_361 QN=shadow_weights[15][14]
Xshadow_weights_reg[14][14] DFFSXL $PINS D=HFSNET_312 CK=ZCTSNET_392
+ SN=HFSNET_377 QN=shadow_weights[14][14]
Xshadow_weights_reg[13][14] DFFSXL $PINS D=HFSNET_312 CK=ZCTSNET_391
+ SN=HFSNET_357 QN=shadow_weights[13][14]
Xshadow_weights_reg[12][14] DFFSXL $PINS D=HFSNET_312 CK=ZCTSNET_390
+ SN=HFSNET_377 QN=shadow_weights[12][14]
Xshadow_weights_reg[10][14] DFFSXL $PINS D=HFSNET_312 CK=ZCTSNET_388
+ SN=HFSNET_360 QN=shadow_weights[10][14]
Xshadow_weights_reg[8][14] DFFSXL $PINS D=HFSNET_312 CK=net1701 SN=HFSNET_360
+ QN=shadow_weights[8][14]
Xshadow_weights_reg[7][14] DFFSXL $PINS D=HFSNET_312 CK=ZCTSNET_404
+ SN=HFSNET_375 QN=shadow_weights[7][14]
Xshadow_weights_reg[6][14] DFFSXL $PINS D=HFSNET_312 CK=ZCTSNET_403
+ SN=HFSNET_357 QN=shadow_weights[6][14]
Xshadow_weights_reg[5][14] DFFSXL $PINS D=HFSNET_312 CK=ZCTSNET_402
+ SN=HFSNET_377 QN=shadow_weights[5][14]
Xshadow_weights_reg[3][14] DFFSXL $PINS D=HFSNET_312 CK=ZCTSNET_400
+ SN=HFSNET_375 QN=shadow_weights[3][14]
Xshadow_weights_reg[2][14] DFFSXL $PINS D=HFSNET_312 CK=ZCTSNET_399
+ SN=HFSNET_361 QN=shadow_weights[2][14]
Xshadow_weights_reg[1][14] DFFSXL $PINS D=HFSNET_312 CK=ZCTSNET_398
+ SN=HFSNET_376 QN=shadow_weights[1][14]
Xshadow_weights_reg[0][14] DFFSXL $PINS D=HFSNET_312 CK=net1660 SN=HFSNET_357
+ QN=shadow_weights[0][14]
Xavg_rounded_r_reg[19] DFFSXL $PINS D=n876 CK=net1816 SN=HFSNET_365
+ QN=avg_rounded_r[19]
Xcalc_result_r_reg[13] DFFSXL $PINS D=n846 CK=net1826 SN=HFSNET_366
+ QN=calc_result_r[13]
Xshadow_weights_reg[19][13] DFFSXL $PINS D=gre_a_INV_1970_54 CK=ZCTSNET_397
+ SN=HFSNET_359 QN=shadow_weights[19][13]
Xshadow_weights_reg[15][13] DFFSXL $PINS D=gre_a_INV_1970_54 CK=ZCTSNET_393
+ SN=HFSNET_361 QN=shadow_weights[15][13]
Xshadow_weights_reg[14][13] DFFSXL $PINS D=gre_a_INV_1970_54 CK=ZCTSNET_392
+ SN=HFSNET_374 QN=shadow_weights[14][13]
Xshadow_weights_reg[13][13] DFFSXL $PINS D=gre_a_INV_1970_54 CK=ZCTSNET_391
+ SN=HFSNET_361 QN=shadow_weights[13][13]
Xshadow_weights_reg[10][13] DFFSXL $PINS D=gre_a_INV_1970_54 CK=ZCTSNET_388
+ SN=HFSNET_360 QN=shadow_weights[10][13]
Xshadow_weights_reg[9][13] DFFSXL $PINS D=gre_a_INV_1970_54 CK=ZCTSNET_406
+ SN=HFSNET_375 QN=shadow_weights[9][13]
Xshadow_weights_reg[8][13] DFFSXL $PINS D=gre_a_INV_1970_54 CK=net1701
+ SN=HFSNET_360 QN=shadow_weights[8][13]
Xshadow_weights_reg[7][13] DFFSXL $PINS D=gre_a_INV_1970_54 CK=ZCTSNET_404
+ SN=HFSNET_375 QN=shadow_weights[7][13]
Xshadow_weights_reg[6][13] DFFSXL $PINS D=gre_a_INV_1970_54 CK=ZCTSNET_403
+ SN=HFSNET_357 QN=shadow_weights[6][13]
Xshadow_weights_reg[3][13] DFFSXL $PINS D=gre_a_INV_1970_54 CK=ZCTSNET_400
+ SN=HFSNET_358 QN=shadow_weights[3][13]
Xshadow_weights_reg[2][13] DFFSXL $PINS D=gre_a_INV_1970_54 CK=ZCTSNET_399
+ SN=HFSNET_357 QN=shadow_weights[2][13]
Xshadow_weights_reg[1][13] DFFSXL $PINS D=gre_a_INV_1970_54 CK=ZCTSNET_398
+ SN=HFSNET_358 QN=shadow_weights[1][13]
Xshadow_weights_reg[0][13] DFFSXL $PINS D=gre_a_INV_1970_54 CK=net1660
+ SN=HFSNET_357 QN=shadow_weights[0][13]
Xavg_rounded_r_reg[18] DFFSXL $PINS D=HFSNET_2 CK=net1816 SN=HFSNET_365
+ QN=avg_rounded_r[18]
Xcalc_result_r_reg[12] DFFSXL $PINS D=n847 CK=net1826 SN=HFSNET_366
+ QN=calc_result_r[12]
Xshadow_weights_reg[19][12] DFFSXL $PINS D=gre_a_INV_1896_55 CK=ZCTSNET_397
+ SN=HFSNET_356 QN=shadow_weights[19][12]
Xshadow_weights_reg[14][12] DFFSXL $PINS D=gre_a_INV_1896_55 CK=ZCTSNET_392
+ SN=HFSNET_379 QN=shadow_weights[14][12]
Xshadow_weights_reg[13][12] DFFSXL $PINS D=gre_a_INV_1896_55 CK=ZCTSNET_391
+ SN=HFSNET_357 QN=shadow_weights[13][12]
Xshadow_weights_reg[10][12] DFFSXL $PINS D=gre_a_INV_1896_55 CK=ZCTSNET_388
+ SN=HFSNET_356 QN=shadow_weights[10][12]
Xshadow_weights_reg[9][12] DFFSXL $PINS D=gre_a_INV_1896_55 CK=ZCTSNET_406
+ SN=HFSNET_374 QN=shadow_weights[9][12]
Xshadow_weights_reg[8][12] DFFSXL $PINS D=gre_a_INV_1896_55 CK=net1701
+ SN=HFSNET_356 QN=shadow_weights[8][12]
Xshadow_weights_reg[7][12] DFFSXL $PINS D=gre_a_INV_1896_55 CK=ZCTSNET_404
+ SN=HFSNET_358 QN=shadow_weights[7][12]
Xshadow_weights_reg[6][12] DFFSXL $PINS D=gre_a_INV_1896_55 CK=ZCTSNET_403
+ SN=HFSNET_358 QN=shadow_weights[6][12]
Xshadow_weights_reg[5][12] DFFSXL $PINS D=gre_a_INV_1896_55 CK=ZCTSNET_402
+ SN=HFSNET_379 QN=shadow_weights[5][12]
Xshadow_weights_reg[3][12] DFFSXL $PINS D=gre_a_INV_1896_55 CK=ZCTSNET_400
+ SN=HFSNET_358 QN=shadow_weights[3][12]
Xshadow_weights_reg[2][12] DFFSXL $PINS D=gre_a_INV_1896_55 CK=ZCTSNET_399
+ SN=HFSNET_357 QN=shadow_weights[2][12]
Xshadow_weights_reg[1][12] DFFSXL $PINS D=gre_a_INV_1896_55 CK=ZCTSNET_398
+ SN=HFSNET_358 QN=shadow_weights[1][12]
Xshadow_weights_reg[0][12] DFFSXL $PINS D=gre_a_INV_1896_55 CK=net1660
+ SN=HFSNET_357 QN=shadow_weights[0][12]
Xwait_cnt_reg[0] DFFSX1 $PINS D=n927 CK=ZCTSNET_384 SN=HFSNET_379
+ QN=wait_cnt[0]
Xwait_cnt_reg[4] DFFSX1 $PINS D=n790 CK=ZCTSNET_384 SN=HFSNET_379
+ QN=wait_cnt[4]
Xwait_cnt_reg[1] DFFSX1 $PINS D=n926 CK=ZCTSNET_384 SN=HFSNET_380
+ QN=wait_cnt[1]
Xwait_cnt_reg[3] DFFSX1 $PINS D=n924 CK=ZCTSNET_384 SN=HFSNET_379
+ QN=wait_cnt[3]
Xavg_rounded_r_reg[35] DFFSXL $PINS D=n860 CK=net1816 SN=HFSNET_354
+ QN=avg_rounded_r[35]
Xcalc_result_r_reg[29] DFFSXL $PINS D=n830 CK=net1826 SN=HFSNET_363
+ QN=calc_result_r[29]
Xshadow_weights_reg[19][29] DFFSXL $PINS D=HFSNET_323 CK=ZCTSNET_397
+ SN=HFSNET_363 QN=shadow_weights[19][29]
Xshadow_weights_reg[14][29] DFFSXL $PINS D=HFSNET_323 CK=ZCTSNET_392
+ SN=HFSNET_373 QN=shadow_weights[14][29]
Xshadow_weights_reg[13][29] DFFSXL $PINS D=HFSNET_323 CK=ZCTSNET_391
+ SN=HFSNET_367 QN=shadow_weights[13][29]
Xshadow_weights_reg[12][29] DFFSXL $PINS D=HFSNET_323 CK=ZCTSNET_390
+ SN=HFSNET_373 QN=shadow_weights[12][29]
Xshadow_weights_reg[10][29] DFFSXL $PINS D=HFSNET_323 CK=ZCTSNET_388
+ SN=HFSNET_363 QN=shadow_weights[10][29]
Xshadow_weights_reg[9][29] DFFSXL $PINS D=HFSNET_323 CK=ZCTSNET_406
+ SN=HFSNET_374 QN=shadow_weights[9][29]
Xshadow_weights_reg[8][29] DFFSXL $PINS D=HFSNET_323 CK=net1701 SN=HFSNET_367
+ QN=shadow_weights[8][29]
Xshadow_weights_reg[7][29] DFFSXL $PINS D=HFSNET_323 CK=ZCTSNET_404
+ SN=HFSNET_374 QN=shadow_weights[7][29]
Xshadow_weights_reg[6][29] DFFSXL $PINS D=HFSNET_323 CK=ZCTSNET_403
+ SN=HFSNET_367 QN=shadow_weights[6][29]
Xshadow_weights_reg[5][29] DFFSXL $PINS D=HFSNET_323 CK=ZCTSNET_402
+ SN=HFSNET_373 QN=shadow_weights[5][29]
Xshadow_weights_reg[3][29] DFFSXL $PINS D=HFSNET_323 CK=ZCTSNET_400
+ SN=HFSNET_373 QN=shadow_weights[3][29]
Xshadow_weights_reg[1][29] DFFSXL $PINS D=HFSNET_323 CK=ZCTSNET_398
+ SN=HFSNET_370 QN=shadow_weights[1][29]
Xshadow_weights_reg[0][29] DFFSXL $PINS D=HFSNET_323 CK=net1660 SN=HFSNET_367
+ QN=shadow_weights[0][29]
Xavg_rounded_r_reg[34] DFFSXL $PINS D=n861 CK=net1816 SN=HFSNET_365
+ QN=avg_rounded_r[34]
Xcalc_result_r_reg[28] DFFSXL $PINS D=n831 CK=net1826 SN=HFSNET_365
+ QN=calc_result_r[28]
Xshadow_weights_reg[19][28] DFFSX1 $PINS D=n2306 CK=ZCTSNET_397 SN=HFSNET_366
+ QN=shadow_weights[19][28]
Xshadow_weights_reg[17][28] DFFSX1 $PINS D=n2306 CK=ZCTSNET_395 SN=HFSNET_366
+ QN=shadow_weights[17][28]
Xshadow_weights_reg[14][28] DFFSXL $PINS D=n2306 CK=ZCTSNET_392 SN=HFSNET_374
+ QN=shadow_weights[14][28]
Xshadow_weights_reg[13][28] DFFSXL $PINS D=n2306 CK=ZCTSNET_391 SN=HFSNET_367
+ QN=shadow_weights[13][28]
Xshadow_weights_reg[12][28] DFFSX1 $PINS D=n2306 CK=ZCTSNET_390 SN=HFSNET_374
+ QN=shadow_weights[12][28]
Xshadow_weights_reg[10][28] DFFSXL $PINS D=n2306 CK=ZCTSNET_388 SN=HFSNET_366
+ QN=shadow_weights[10][28]
Xshadow_weights_reg[9][28] DFFSXL $PINS D=n2306 CK=ZCTSNET_406 SN=HFSNET_370
+ QN=shadow_weights[9][28]
Xshadow_weights_reg[8][28] DFFSXL $PINS D=n2306 CK=net1701 SN=HFSNET_366
+ QN=shadow_weights[8][28]
Xshadow_weights_reg[7][28] DFFSXL $PINS D=n2306 CK=ZCTSNET_404 SN=HFSNET_370
+ QN=shadow_weights[7][28]
Xshadow_weights_reg[6][28] DFFSXL $PINS D=n2306 CK=ZCTSNET_403 SN=HFSNET_367
+ QN=shadow_weights[6][28]
Xshadow_weights_reg[3][28] DFFSXL $PINS D=n2306 CK=ZCTSNET_400 SN=HFSNET_379
+ QN=shadow_weights[3][28]
Xshadow_weights_reg[2][28] DFFSXL $PINS D=n2306 CK=ZCTSNET_399 SN=HFSNET_370
+ QN=shadow_weights[2][28]
Xshadow_weights_reg[1][28] DFFSXL $PINS D=n2306 CK=ZCTSNET_398 SN=HFSNET_373
+ QN=shadow_weights[1][28]
Xshadow_weights_reg[0][28] DFFSXL $PINS D=n2306 CK=net1660 SN=HFSNET_370
+ QN=shadow_weights[0][28]
Xavg_rounded_r_reg[33] DFFSXL $PINS D=n862 CK=net1816 SN=HFSNET_365
+ QN=avg_rounded_r[33]
Xcalc_result_r_reg[27] DFFSXL $PINS D=n832 CK=net1826 SN=HFSNET_366
+ QN=calc_result_r[27]
Xshadow_weights_reg[19][27] DFFSXL $PINS D=n2305 CK=ZCTSNET_397 SN=HFSNET_366
+ QN=shadow_weights[19][27]
Xshadow_weights_reg[17][27] DFFSXL $PINS D=n2305 CK=ZCTSNET_395 SN=HFSNET_366
+ QN=shadow_weights[17][27]
Xshadow_weights_reg[14][27] DFFSXL $PINS D=n2305 CK=ZCTSNET_392 SN=HFSNET_379
+ QN=shadow_weights[14][27]
Xshadow_weights_reg[13][27] DFFSXL $PINS D=n2305 CK=ZCTSNET_391 SN=HFSNET_370
+ QN=shadow_weights[13][27]
Xshadow_weights_reg[12][27] DFFSXL $PINS D=n2305 CK=ZCTSNET_390 SN=HFSNET_379
+ QN=shadow_weights[12][27]
Xshadow_weights_reg[10][27] DFFSXL $PINS D=n2305 CK=ZCTSNET_388 SN=HFSNET_380
+ QN=shadow_weights[10][27]
Xshadow_weights_reg[9][27] DFFSXL $PINS D=n2305 CK=ZCTSNET_406 SN=HFSNET_373
+ QN=shadow_weights[9][27]
Xshadow_weights_reg[8][27] DFFSXL $PINS D=n2305 CK=net1701 SN=HFSNET_366
+ QN=shadow_weights[8][27]
Xshadow_weights_reg[6][27] DFFSXL $PINS D=n2305 CK=ZCTSNET_403 SN=HFSNET_370
+ QN=shadow_weights[6][27]
Xshadow_weights_reg[5][27] DFFSXL $PINS D=n2305 CK=ZCTSNET_402 SN=HFSNET_373
+ QN=shadow_weights[5][27]
Xshadow_weights_reg[3][27] DFFSXL $PINS D=n2305 CK=ZCTSNET_400 SN=HFSNET_379
+ QN=shadow_weights[3][27]
Xshadow_weights_reg[2][27] DFFSXL $PINS D=n2305 CK=ZCTSNET_399 SN=HFSNET_370
+ QN=shadow_weights[2][27]
Xshadow_weights_reg[1][27] DFFSXL $PINS D=n2305 CK=ZCTSNET_398 SN=HFSNET_370
+ QN=shadow_weights[1][27]
Xshadow_weights_reg[0][27] DFFSXL $PINS D=n2305 CK=net1660 SN=HFSNET_370
+ QN=shadow_weights[0][27]
Xavg_rounded_r_reg[32] DFFSXL $PINS D=n863 CK=net1816 SN=HFSNET_365
+ QN=avg_rounded_r[32]
Xshadow_weights_reg[19][26] DFFSXL $PINS D=n71 CK=ZCTSNET_397 SN=HFSNET_366
+ QN=shadow_weights[19][26]
Xshadow_weights_reg[17][26] DFFSXL $PINS D=n71 CK=ZCTSNET_395 SN=HFSNET_366
+ QN=shadow_weights[17][26]
Xshadow_weights_reg[14][26] DFFSXL $PINS D=HFSNET_299 CK=ZCTSNET_392
+ SN=HFSNET_379 QN=shadow_weights[14][26]
Xshadow_weights_reg[13][26] DFFSXL $PINS D=HFSNET_299 CK=ZCTSNET_391
+ SN=HFSNET_370 QN=shadow_weights[13][26]
Xshadow_weights_reg[12][26] DFFSXL $PINS D=HFSNET_299 CK=ZCTSNET_390
+ SN=HFSNET_379 QN=shadow_weights[12][26]
Xshadow_weights_reg[10][26] DFFSXL $PINS D=n71 CK=ZCTSNET_388 SN=HFSNET_366
+ QN=shadow_weights[10][26]
Xshadow_weights_reg[9][26] DFFSXL $PINS D=HFSNET_299 CK=ZCTSNET_406
+ SN=HFSNET_370 QN=shadow_weights[9][26]
Xshadow_weights_reg[7][26] DFFSXL $PINS D=HFSNET_299 CK=ZCTSNET_404
+ SN=HFSNET_373 QN=shadow_weights[7][26]
Xshadow_weights_reg[6][26] DFFSXL $PINS D=HFSNET_299 CK=ZCTSNET_403
+ SN=HFSNET_367 QN=shadow_weights[6][26]
Xshadow_weights_reg[5][26] DFFSXL $PINS D=HFSNET_299 CK=ZCTSNET_402
+ SN=HFSNET_379 QN=shadow_weights[5][26]
Xshadow_weights_reg[3][26] DFFSXL $PINS D=HFSNET_299 CK=ZCTSNET_400
+ SN=HFSNET_379 QN=shadow_weights[3][26]
Xshadow_weights_reg[2][26] DFFSXL $PINS D=HFSNET_299 CK=ZCTSNET_399
+ SN=HFSNET_370 QN=shadow_weights[2][26]
Xshadow_weights_reg[1][26] DFFSXL $PINS D=HFSNET_299 CK=ZCTSNET_398
+ SN=HFSNET_373 QN=shadow_weights[1][26]
Xshadow_weights_reg[0][26] DFFSXL $PINS D=HFSNET_299 CK=net1660 SN=HFSNET_370
+ QN=shadow_weights[0][26]
Xavg_rounded_r_reg[31] DFFSXL $PINS D=n864 CK=net1816 SN=HFSNET_365
+ QN=avg_rounded_r[31]
Xcalc_result_r_reg[25] DFFSXL $PINS D=n834 CK=net1826 SN=HFSNET_366
+ QN=calc_result_r[25]
Xshadow_weights_reg[19][25] DFFSXL $PINS D=HFSNET_322 CK=ZCTSNET_397
+ SN=HFSNET_366 QN=shadow_weights[19][25]
Xshadow_weights_reg[17][25] DFFSX1 $PINS D=HFSNET_322 CK=ZCTSNET_395
+ SN=HFSNET_366 QN=shadow_weights[17][25]
Xshadow_weights_reg[14][25] DFFSXL $PINS D=HFSNET_322 CK=ZCTSNET_392
+ SN=HFSNET_379 QN=shadow_weights[14][25]
Xshadow_weights_reg[13][25] DFFSXL $PINS D=HFSNET_322 CK=ZCTSNET_391
+ SN=HFSNET_370 QN=shadow_weights[13][25]
Xshadow_weights_reg[12][25] DFFSXL $PINS D=HFSNET_322 CK=ZCTSNET_390
+ SN=HFSNET_379 QN=shadow_weights[12][25]
Xshadow_weights_reg[9][25] DFFSXL $PINS D=HFSNET_322 CK=ZCTSNET_406
+ SN=HFSNET_374 QN=shadow_weights[9][25]
Xshadow_weights_reg[8][25] DFFSXL $PINS D=HFSNET_322 CK=net1701 SN=HFSNET_366
+ QN=shadow_weights[8][25]
Xshadow_weights_reg[7][25] DFFSXL $PINS D=HFSNET_322 CK=ZCTSNET_404
+ SN=HFSNET_379 QN=shadow_weights[7][25]
Xshadow_weights_reg[6][25] DFFSXL $PINS D=HFSNET_322 CK=ZCTSNET_403
+ SN=HFSNET_370 QN=shadow_weights[6][25]
Xshadow_weights_reg[5][25] DFFSXL $PINS D=HFSNET_322 CK=ZCTSNET_402
+ SN=HFSNET_379 QN=shadow_weights[5][25]
Xshadow_weights_reg[3][25] DFFSXL $PINS D=HFSNET_322 CK=ZCTSNET_400
+ SN=HFSNET_370 QN=shadow_weights[3][25]
Xshadow_weights_reg[2][25] DFFSXL $PINS D=HFSNET_322 CK=ZCTSNET_399
+ SN=HFSNET_370 QN=shadow_weights[2][25]
Xshadow_weights_reg[1][25] DFFSXL $PINS D=HFSNET_322 CK=ZCTSNET_398
+ SN=HFSNET_370 QN=shadow_weights[1][25]
Xshadow_weights_reg[0][25] DFFSXL $PINS D=HFSNET_322 CK=net1660 SN=HFSNET_370
+ QN=shadow_weights[0][25]
Xavg_rounded_r_reg[30] DFFSXL $PINS D=n865 CK=net1816 SN=HFSNET_365
+ QN=avg_rounded_r[30]
Xcalc_result_r_reg[24] DFFSXL $PINS D=n835 CK=net1826 SN=HFSNET_363
+ QN=calc_result_r[24]
Xshadow_weights_reg[19][24] DFFSXL $PINS D=HFSNET_321 CK=ZCTSNET_397
+ SN=HFSNET_366 QN=shadow_weights[19][24]
Xshadow_weights_reg[17][24] DFFSXL $PINS D=HFSNET_321 CK=ZCTSNET_395
+ SN=HFSNET_366 QN=shadow_weights[17][24]
Xshadow_weights_reg[14][24] DFFSXL $PINS D=HFSNET_321 CK=ZCTSNET_392
+ SN=HFSNET_374 QN=shadow_weights[14][24]
Xshadow_weights_reg[12][24] DFFSXL $PINS D=HFSNET_321 CK=ZCTSNET_390
+ SN=HFSNET_368 QN=shadow_weights[12][24]
Xshadow_weights_reg[10][24] DFFSXL $PINS D=HFSNET_321 CK=ZCTSNET_388
+ SN=HFSNET_369 QN=shadow_weights[10][24]
Xshadow_weights_reg[9][24] DFFSXL $PINS D=HFSNET_321 CK=ZCTSNET_406
+ SN=HFSNET_374 QN=shadow_weights[9][24]
Xshadow_weights_reg[8][24] DFFSXL $PINS D=HFSNET_321 CK=net1701 SN=HFSNET_367
+ QN=shadow_weights[8][24]
Xshadow_weights_reg[7][24] DFFSXL $PINS D=HFSNET_321 CK=ZCTSNET_404
+ SN=HFSNET_368 QN=shadow_weights[7][24]
Xshadow_weights_reg[6][24] DFFSXL $PINS D=HFSNET_321 CK=ZCTSNET_403
+ SN=HFSNET_370 QN=shadow_weights[6][24]
Xshadow_weights_reg[5][24] DFFSXL $PINS D=HFSNET_321 CK=ZCTSNET_402
+ SN=HFSNET_373 QN=shadow_weights[5][24]
Xshadow_weights_reg[3][24] DFFSXL $PINS D=HFSNET_321 CK=ZCTSNET_400
+ SN=HFSNET_370 QN=shadow_weights[3][24]
Xshadow_weights_reg[2][24] DFFSXL $PINS D=HFSNET_321 CK=ZCTSNET_399
+ SN=HFSNET_370 QN=shadow_weights[2][24]
Xshadow_weights_reg[1][24] DFFSXL $PINS D=HFSNET_321 CK=ZCTSNET_398
+ SN=HFSNET_373 QN=shadow_weights[1][24]
Xshadow_weights_reg[0][24] DFFSXL $PINS D=HFSNET_321 CK=net1660 SN=HFSNET_370
+ QN=shadow_weights[0][24]
Xaccumulator_reg[29] DFFSX1 $PINS D=HFSNET_67 CK=net1771 SN=HFSNET_365
+ QN=accumulator[29]
Xavg_rounded_r_reg[29] DFFSXL $PINS D=n866 CK=net1816 SN=HFSNET_363
+ QN=avg_rounded_r[29]
Xcalc_result_r_reg[23] DFFSXL $PINS D=n836 CK=net1826 SN=HFSNET_363
+ QN=calc_result_r[23]
Xshadow_weights_reg[17][23] DFFSXL $PINS D=HFSNET_320 CK=ZCTSNET_395
+ SN=HFSNET_363 QN=shadow_weights[17][23]
Xshadow_weights_reg[14][23] DFFSXL $PINS D=HFSNET_320 CK=ZCTSNET_392
+ SN=HFSNET_373 QN=shadow_weights[14][23]
Xshadow_weights_reg[13][23] DFFSXL $PINS D=HFSNET_320 CK=ZCTSNET_391
+ SN=HFSNET_368 QN=shadow_weights[13][23]
Xshadow_weights_reg[12][23] DFFSXL $PINS D=HFSNET_320 CK=ZCTSNET_390
+ SN=HFSNET_368 QN=shadow_weights[12][23]
Xshadow_weights_reg[10][23] DFFSXL $PINS D=HFSNET_320 CK=ZCTSNET_388
+ SN=HFSNET_367 QN=shadow_weights[10][23]
Xshadow_weights_reg[9][23] DFFSXL $PINS D=HFSNET_320 CK=ZCTSNET_406
+ SN=HFSNET_374 QN=shadow_weights[9][23]
Xshadow_weights_reg[8][23] DFFSXL $PINS D=HFSNET_320 CK=net1701 SN=HFSNET_366
+ QN=shadow_weights[8][23]
Xshadow_weights_reg[7][23] DFFSXL $PINS D=HFSNET_320 CK=ZCTSNET_404
+ SN=HFSNET_374 QN=shadow_weights[7][23]
Xshadow_weights_reg[6][23] DFFSXL $PINS D=HFSNET_320 CK=ZCTSNET_403
+ SN=HFSNET_367 QN=shadow_weights[6][23]
Xshadow_weights_reg[5][23] DFFSXL $PINS D=HFSNET_320 CK=ZCTSNET_402
+ SN=HFSNET_373 QN=shadow_weights[5][23]
Xshadow_weights_reg[3][23] DFFSXL $PINS D=HFSNET_320 CK=ZCTSNET_400
+ SN=HFSNET_368 QN=shadow_weights[3][23]
Xshadow_weights_reg[2][23] DFFSXL $PINS D=HFSNET_320 CK=ZCTSNET_399
+ SN=HFSNET_369 QN=shadow_weights[2][23]
Xshadow_weights_reg[1][23] DFFSXL $PINS D=HFSNET_320 CK=ZCTSNET_398
+ SN=HFSNET_358 QN=shadow_weights[1][23]
Xshadow_weights_reg[0][23] DFFSXL $PINS D=HFSNET_320 CK=net1660 SN=HFSNET_368
+ QN=shadow_weights[0][23]
Xavg_rounded_r_reg[28] DFFSXL $PINS D=n867 CK=net1816 SN=HFSNET_363
+ QN=avg_rounded_r[28]
Xcalc_result_r_reg[22] DFFSXL $PINS D=n837 CK=net1826 SN=HFSNET_363
+ QN=calc_result_r[22]
Xshadow_weights_reg[19][22] DFFSXL $PINS D=HFSNET_319 CK=ZCTSNET_397
+ SN=HFSNET_369 QN=shadow_weights[19][22]
Xshadow_weights_reg[17][22] DFFSXL $PINS D=HFSNET_319 CK=ZCTSNET_395
+ SN=HFSNET_363 QN=shadow_weights[17][22]
Xshadow_weights_reg[14][22] DFFSXL $PINS D=HFSNET_319 CK=ZCTSNET_392
+ SN=HFSNET_373 QN=shadow_weights[14][22]
Xshadow_weights_reg[13][22] DFFSXL $PINS D=HFSNET_319 CK=ZCTSNET_391
+ SN=HFSNET_370 QN=shadow_weights[13][22]
Xshadow_weights_reg[12][22] DFFSXL $PINS D=HFSNET_319 CK=ZCTSNET_390
+ SN=HFSNET_373 QN=shadow_weights[12][22]
Xshadow_weights_reg[10][22] DFFSXL $PINS D=HFSNET_319 CK=ZCTSNET_388
+ SN=HFSNET_367 QN=shadow_weights[10][22]
Xshadow_weights_reg[9][22] DFFSXL $PINS D=HFSNET_319 CK=ZCTSNET_406
+ SN=HFSNET_373 QN=shadow_weights[9][22]
Xshadow_weights_reg[8][22] DFFSXL $PINS D=HFSNET_319 CK=net1701 SN=HFSNET_367
+ QN=shadow_weights[8][22]
Xshadow_weights_reg[7][22] DFFSXL $PINS D=HFSNET_319 CK=ZCTSNET_404
+ SN=HFSNET_373 QN=shadow_weights[7][22]
Xshadow_weights_reg[6][22] DFFSXL $PINS D=HFSNET_319 CK=ZCTSNET_403
+ SN=HFSNET_367 QN=shadow_weights[6][22]
Xshadow_weights_reg[5][22] DFFSXL $PINS D=HFSNET_319 CK=ZCTSNET_402
+ SN=HFSNET_373 QN=shadow_weights[5][22]
Xshadow_weights_reg[3][22] DFFSXL $PINS D=HFSNET_319 CK=ZCTSNET_400
+ SN=HFSNET_373 QN=shadow_weights[3][22]
Xshadow_weights_reg[1][22] DFFSXL $PINS D=HFSNET_319 CK=ZCTSNET_398
+ SN=HFSNET_373 QN=shadow_weights[1][22]
Xshadow_weights_reg[0][22] DFFSXL $PINS D=HFSNET_319 CK=net1660 SN=HFSNET_368
+ QN=shadow_weights[0][22]
Xaccumulator_reg[27] DFFSXL $PINS D=HFSNET_69 CK=net1771 SN=HFSNET_365
+ QN=accumulator[27]
Xavg_rounded_r_reg[27] DFFSXL $PINS D=n868 CK=net1816 SN=HFSNET_365
+ QN=avg_rounded_r[27]
Xcalc_result_r_reg[21] DFFSXL $PINS D=n838 CK=net1826 SN=HFSNET_365
+ QN=calc_result_r[21]
Xshadow_weights_reg[19][21] DFFSXL $PINS D=HFSNET_318 CK=ZCTSNET_397
+ SN=HFSNET_367 QN=shadow_weights[19][21]
Xshadow_weights_reg[17][21] DFFSX1 $PINS D=HFSNET_318 CK=ZCTSNET_395
+ SN=HFSNET_365 QN=shadow_weights[17][21]
Xshadow_weights_reg[14][21] DFFSXL $PINS D=HFSNET_318 CK=ZCTSNET_392
+ SN=HFSNET_379 QN=shadow_weights[14][21]
Xshadow_weights_reg[13][21] DFFSXL $PINS D=HFSNET_318 CK=ZCTSNET_391
+ SN=HFSNET_367 QN=shadow_weights[13][21]
Xshadow_weights_reg[12][21] DFFSXL $PINS D=HFSNET_318 CK=ZCTSNET_390
+ SN=HFSNET_373 QN=shadow_weights[12][21]
Xshadow_weights_reg[10][21] DFFSXL $PINS D=HFSNET_318 CK=ZCTSNET_388
+ SN=HFSNET_366 QN=shadow_weights[10][21]
Xshadow_weights_reg[9][21] DFFSXL $PINS D=HFSNET_318 CK=ZCTSNET_406
+ SN=HFSNET_370 QN=shadow_weights[9][21]
Xshadow_weights_reg[8][21] DFFSXL $PINS D=HFSNET_318 CK=net1701 SN=HFSNET_366
+ QN=shadow_weights[8][21]
Xshadow_weights_reg[7][21] DFFSXL $PINS D=HFSNET_318 CK=ZCTSNET_404
+ SN=HFSNET_373 QN=shadow_weights[7][21]
Xshadow_weights_reg[5][21] DFFSXL $PINS D=HFSNET_318 CK=ZCTSNET_402
+ SN=HFSNET_373 QN=shadow_weights[5][21]
Xshadow_weights_reg[3][21] DFFSXL $PINS D=HFSNET_318 CK=ZCTSNET_400
+ SN=HFSNET_379 QN=shadow_weights[3][21]
Xshadow_weights_reg[2][21] DFFSXL $PINS D=HFSNET_318 CK=ZCTSNET_399
+ SN=HFSNET_370 QN=shadow_weights[2][21]
Xshadow_weights_reg[1][21] DFFSXL $PINS D=HFSNET_318 CK=ZCTSNET_398
+ SN=HFSNET_370 QN=shadow_weights[1][21]
Xshadow_weights_reg[0][21] DFFSXL $PINS D=HFSNET_318 CK=net1660 SN=HFSNET_370
+ QN=shadow_weights[0][21]
Xaccumulator_reg[26] DFFSXL $PINS D=HFSNET_70 CK=net1771 SN=HFSNET_365
+ QN=accumulator[26]
Xavg_rounded_r_reg[26] DFFSXL $PINS D=n869 CK=net1816 SN=HFSNET_365
+ QN=avg_rounded_r[26]
Xcalc_result_r_reg[20] DFFSXL $PINS D=n839 CK=net1826 SN=HFSNET_366
+ QN=calc_result_r[20]
Xshadow_weights_reg[19][20] DFFSXL $PINS D=n2299 CK=ZCTSNET_397 SN=HFSNET_367
+ QN=shadow_weights[19][20]
Xshadow_weights_reg[17][20] DFFSXL $PINS D=n2299 CK=ZCTSNET_395 SN=HFSNET_366
+ QN=shadow_weights[17][20]
Xshadow_weights_reg[14][20] DFFSXL $PINS D=n2299 CK=ZCTSNET_392 SN=HFSNET_374
+ QN=shadow_weights[14][20]
Xshadow_weights_reg[13][20] DFFSXL $PINS D=n2299 CK=ZCTSNET_391 SN=HFSNET_367
+ QN=shadow_weights[13][20]
Xshadow_weights_reg[12][20] DFFSXL $PINS D=n2299 CK=ZCTSNET_390 SN=HFSNET_374
+ QN=shadow_weights[12][20]
Xshadow_weights_reg[10][20] DFFSXL $PINS D=n2299 CK=ZCTSNET_388 SN=HFSNET_369
+ QN=shadow_weights[10][20]
Xshadow_weights_reg[8][20] DFFSXL $PINS D=n2299 CK=net1701 SN=HFSNET_369
+ QN=shadow_weights[8][20]
Xshadow_weights_reg[7][20] DFFSXL $PINS D=n2299 CK=ZCTSNET_404 SN=HFSNET_374
+ QN=shadow_weights[7][20]
Xshadow_weights_reg[6][20] DFFSXL $PINS D=n2299 CK=ZCTSNET_403 SN=HFSNET_367
+ QN=shadow_weights[6][20]
Xshadow_weights_reg[5][20] DFFSXL $PINS D=n2299 CK=ZCTSNET_402 SN=HFSNET_374
+ QN=shadow_weights[5][20]
Xshadow_weights_reg[3][20] DFFSXL $PINS D=n2299 CK=ZCTSNET_400 SN=HFSNET_368
+ QN=shadow_weights[3][20]
Xshadow_weights_reg[2][20] DFFSXL $PINS D=n2299 CK=ZCTSNET_399 SN=HFSNET_367
+ QN=shadow_weights[2][20]
Xshadow_weights_reg[1][20] DFFSXL $PINS D=n2299 CK=ZCTSNET_398 SN=HFSNET_374
+ QN=shadow_weights[1][20]
Xshadow_weights_reg[0][20] DFFSXL $PINS D=n2299 CK=net1660 SN=HFSNET_368
+ QN=shadow_weights[0][20]
Xaccumulator_reg[25] DFFSXL $PINS D=HFSNET_71 CK=net1771 SN=HFSNET_365
+ QN=accumulator[25]
Xavg_rounded_r_reg[25] DFFSXL $PINS D=n870 CK=net1816 SN=HFSNET_365
+ QN=avg_rounded_r[25]
Xcalc_result_r_reg[19] DFFSX1 $PINS D=n840 CK=net1826 SN=HFSNET_365
+ QN=calc_result_r[19]
Xshadow_weights_reg[19][19] DFFSXL $PINS D=n2298 CK=ZCTSNET_397 SN=HFSNET_363
+ QN=shadow_weights[19][19]
Xshadow_weights_reg[17][19] DFFSX1 $PINS D=n2298 CK=ZCTSNET_395 SN=HFSNET_363
+ QN=shadow_weights[17][19]
Xshadow_weights_reg[14][19] DFFSXL $PINS D=n2298 CK=ZCTSNET_392 SN=HFSNET_374
+ QN=shadow_weights[14][19]
Xshadow_weights_reg[12][19] DFFSXL $PINS D=n2298 CK=ZCTSNET_390 SN=HFSNET_374
+ QN=shadow_weights[12][19]
Xshadow_weights_reg[10][19] DFFSXL $PINS D=n2298 CK=ZCTSNET_388 SN=HFSNET_363
+ QN=shadow_weights[10][19]
Xshadow_weights_reg[9][19] DFFSXL $PINS D=n2298 CK=ZCTSNET_406 SN=HFSNET_374
+ QN=shadow_weights[9][19]
Xshadow_weights_reg[8][19] DFFSXL $PINS D=n2298 CK=net1701 SN=HFSNET_369
+ QN=shadow_weights[8][19]
Xshadow_weights_reg[7][19] DFFSXL $PINS D=n2298 CK=ZCTSNET_404 SN=HFSNET_368
+ QN=shadow_weights[7][19]
Xshadow_weights_reg[6][19] DFFSXL $PINS D=n2298 CK=ZCTSNET_403 SN=HFSNET_369
+ QN=shadow_weights[6][19]
Xshadow_weights_reg[5][19] DFFSXL $PINS D=n2298 CK=ZCTSNET_402 SN=HFSNET_374
+ QN=shadow_weights[5][19]
Xshadow_weights_reg[3][19] DFFSXL $PINS D=n2298 CK=ZCTSNET_400 SN=HFSNET_368
+ QN=shadow_weights[3][19]
Xshadow_weights_reg[2][19] DFFSXL $PINS D=n2298 CK=ZCTSNET_399 SN=HFSNET_368
+ QN=shadow_weights[2][19]
Xshadow_weights_reg[1][19] DFFSXL $PINS D=n2298 CK=ZCTSNET_398 SN=HFSNET_374
+ QN=shadow_weights[1][19]
Xshadow_weights_reg[0][19] DFFSXL $PINS D=n2298 CK=net1660 SN=HFSNET_368
+ QN=shadow_weights[0][19]
Xaccumulator_reg[24] DFFSXL $PINS D=HFSNET_12 CK=net1771 SN=HFSNET_354
+ QN=accumulator[24]
Xavg_rounded_r_reg[24] DFFSXL $PINS D=n871 CK=net1816 SN=HFSNET_365
+ QN=avg_rounded_r[24]
Xcalc_result_r_reg[18] DFFSXL $PINS D=n841 CK=net1826 SN=HFSNET_363
+ QN=calc_result_r[18]
Xshadow_weights_reg[17][18] DFFSX1 $PINS D=HFSNET_316 CK=ZCTSNET_395
+ SN=HFSNET_355 QN=shadow_weights[17][18]
Xshadow_weights_reg[14][18] DFFSXL $PINS D=HFSNET_316 CK=ZCTSNET_392
+ SN=HFSNET_377 QN=shadow_weights[14][18]
Xshadow_weights_reg[13][18] DFFSXL $PINS D=HFSNET_316 CK=ZCTSNET_391
+ SN=HFSNET_369 QN=shadow_weights[13][18]
Xshadow_weights_reg[12][18] DFFSXL $PINS D=HFSNET_316 CK=ZCTSNET_390
+ SN=HFSNET_358 QN=shadow_weights[12][18]
Xshadow_weights_reg[10][18] DFFSXL $PINS D=HFSNET_316 CK=ZCTSNET_388
+ SN=HFSNET_369 QN=shadow_weights[10][18]
Xshadow_weights_reg[9][18] DFFSXL $PINS D=HFSNET_316 CK=ZCTSNET_406
+ SN=HFSNET_375 QN=shadow_weights[9][18]
Xshadow_weights_reg[8][18] DFFSXL $PINS D=HFSNET_316 CK=net1701 SN=HFSNET_369
+ QN=shadow_weights[8][18]
Xshadow_weights_reg[7][18] DFFSXL $PINS D=HFSNET_316 CK=ZCTSNET_404
+ SN=HFSNET_375 QN=shadow_weights[7][18]
Xshadow_weights_reg[6][18] DFFSXL $PINS D=HFSNET_316 CK=ZCTSNET_403
+ SN=HFSNET_369 QN=shadow_weights[6][18]
Xshadow_weights_reg[5][18] DFFSXL $PINS D=HFSNET_316 CK=ZCTSNET_402
+ SN=HFSNET_377 QN=shadow_weights[5][18]
Xshadow_weights_reg[3][18] DFFSXL $PINS D=HFSNET_316 CK=ZCTSNET_400
+ SN=HFSNET_375 QN=shadow_weights[3][18]
Xshadow_weights_reg[2][18] DFFSX1 $PINS D=HFSNET_316 CK=ZCTSNET_399
+ SN=HFSNET_361 QN=shadow_weights[2][18]
Xshadow_weights_reg[1][18] DFFSXL $PINS D=HFSNET_316 CK=ZCTSNET_398
+ SN=HFSNET_376 QN=shadow_weights[1][18]
Xshadow_weights_reg[0][18] DFFSXL $PINS D=HFSNET_316 CK=net1660 SN=HFSNET_357
+ QN=shadow_weights[0][18]
Xavg_rounded_r_reg[23] DFFSXL $PINS D=n872 CK=net1816 SN=HFSNET_365
+ QN=avg_rounded_r[23]
Xcalc_result_r_reg[17] DFFSXL $PINS D=n842 CK=net1826 SN=HFSNET_355
+ QN=calc_result_r[17]
Xshadow_weights_reg[19][17] DFFSXL $PINS D=HFSNET_315 CK=ZCTSNET_397
+ SN=HFSNET_356 QN=shadow_weights[19][17]
Xshadow_weights_reg[14][17] DFFSXL $PINS D=HFSNET_315 CK=ZCTSNET_392
+ SN=HFSNET_377 QN=shadow_weights[14][17]
Xshadow_weights_reg[13][17] DFFSXL $PINS D=HFSNET_315 CK=ZCTSNET_391
+ SN=HFSNET_361 QN=shadow_weights[13][17]
Xshadow_weights_reg[12][17] DFFSXL $PINS D=HFSNET_315 CK=ZCTSNET_390
+ SN=HFSNET_377 QN=shadow_weights[12][17]
Xshadow_weights_reg[10][17] DFFSXL $PINS D=HFSNET_315 CK=ZCTSNET_388
+ SN=HFSNET_369 QN=shadow_weights[10][17]
Xshadow_weights_reg[9][17] DFFSXL $PINS D=HFSNET_315 CK=ZCTSNET_406
+ SN=HFSNET_376 QN=shadow_weights[9][17]
Xshadow_weights_reg[8][17] DFFSXL $PINS D=HFSNET_315 CK=net1701 SN=HFSNET_356
+ QN=shadow_weights[8][17]
Xshadow_weights_reg[7][17] DFFSXL $PINS D=HFSNET_315 CK=ZCTSNET_404
+ SN=HFSNET_358 QN=shadow_weights[7][17]
Xshadow_weights_reg[6][17] DFFSXL $PINS D=HFSNET_315 CK=ZCTSNET_403
+ SN=HFSNET_361 QN=shadow_weights[6][17]
Xshadow_weights_reg[5][17] DFFSXL $PINS D=HFSNET_315 CK=ZCTSNET_402
+ SN=HFSNET_377 QN=shadow_weights[5][17]
Xshadow_weights_reg[3][17] DFFSXL $PINS D=HFSNET_315 CK=ZCTSNET_400
+ SN=HFSNET_375 QN=shadow_weights[3][17]
Xshadow_weights_reg[2][17] DFFSXL $PINS D=HFSNET_315 CK=ZCTSNET_399
+ SN=HFSNET_361 QN=shadow_weights[2][17]
Xshadow_weights_reg[0][17] DFFSXL $PINS D=HFSNET_315 CK=net1660 SN=HFSNET_358
+ QN=shadow_weights[0][17]
Xaccumulator_reg[22] DFFSXL $PINS D=HFSNET_10 CK=net1771 SN=HFSNET_351
+ QN=accumulator[22]
Xavg_rounded_r_reg[22] DFFSXL $PINS D=n873 CK=net1816 SN=HFSNET_363
+ QN=avg_rounded_r[22]
Xcalc_result_r_reg[16] DFFSXL $PINS D=n843 CK=net1826 SN=HFSNET_363
+ QN=calc_result_r[16]
Xshadow_weights_reg[19][16] DFFSXL $PINS D=HFSNET_314 CK=ZCTSNET_397
+ SN=HFSNET_369 QN=shadow_weights[19][16]
Xshadow_weights_reg[14][16] DFFSXL $PINS D=HFSNET_314 CK=ZCTSNET_392
+ SN=HFSNET_374 QN=shadow_weights[14][16]
Xshadow_weights_reg[13][16] DFFSXL $PINS D=HFSNET_314 CK=ZCTSNET_391
+ SN=HFSNET_361 QN=shadow_weights[13][16]
Xshadow_weights_reg[12][16] DFFSXL $PINS D=HFSNET_314 CK=ZCTSNET_390
+ SN=HFSNET_374 QN=shadow_weights[12][16]
Xshadow_weights_reg[10][16] DFFSXL $PINS D=HFSNET_314 CK=ZCTSNET_388
+ SN=HFSNET_356 QN=shadow_weights[10][16]
Xshadow_weights_reg[9][16] DFFSXL $PINS D=HFSNET_314 CK=ZCTSNET_406
+ SN=HFSNET_373 QN=shadow_weights[9][16]
Xshadow_weights_reg[8][16] DFFSXL $PINS D=HFSNET_314 CK=net1701 SN=HFSNET_356
+ QN=shadow_weights[8][16]
Xshadow_weights_reg[7][16] DFFSXL $PINS D=HFSNET_314 CK=ZCTSNET_404
+ SN=HFSNET_361 QN=shadow_weights[7][16]
Xshadow_weights_reg[6][16] DFFSX1 $PINS D=HFSNET_314 CK=ZCTSNET_403
+ SN=HFSNET_367 QN=shadow_weights[6][16]
Xshadow_weights_reg[5][16] DFFSXL $PINS D=HFSNET_314 CK=ZCTSNET_402
+ SN=HFSNET_374 QN=shadow_weights[5][16]
Xshadow_weights_reg[2][16] DFFSXL $PINS D=HFSNET_314 CK=ZCTSNET_399
+ SN=HFSNET_361 QN=shadow_weights[2][16]
Xshadow_weights_reg[1][16] DFFSXL $PINS D=HFSNET_314 CK=ZCTSNET_398
+ SN=HFSNET_376 QN=shadow_weights[1][16]
Xshadow_weights_reg[0][16] DFFSXL $PINS D=HFSNET_314 CK=net1660 SN=HFSNET_367
+ QN=shadow_weights[0][16]
Xaccumulator_reg[21] DFFSX1 $PINS D=HFSNET_9 CK=net1771 SN=HFSNET_354
+ QN=accumulator[21]
Xavg_rounded_r_reg[21] DFFSXL $PINS D=n874 CK=net1816 SN=HFSNET_365
+ QN=avg_rounded_r[21]
Xcalc_result_r_reg[15] DFFSXL $PINS D=n844 CK=net1826 SN=HFSNET_365
+ QN=calc_result_r[15]
Xshadow_weights_reg[19][15] DFFSXL $PINS D=HFSNET_313 CK=ZCTSNET_397
+ SN=HFSNET_359 QN=shadow_weights[19][15]
Xshadow_weights_reg[14][15] DFFSXL $PINS D=HFSNET_313 CK=ZCTSNET_392
+ SN=HFSNET_373 QN=shadow_weights[14][15]
Xshadow_weights_reg[13][15] DFFSXL $PINS D=HFSNET_313 CK=ZCTSNET_391
+ SN=HFSNET_360 QN=shadow_weights[13][15]
Xshadow_weights_reg[12][15] DFFSXL $PINS D=HFSNET_313 CK=ZCTSNET_390
+ SN=HFSNET_379 QN=shadow_weights[12][15]
Xshadow_weights_reg[10][15] DFFSXL $PINS D=HFSNET_313 CK=ZCTSNET_388
+ SN=HFSNET_356 QN=shadow_weights[10][15]
Xshadow_weights_reg[9][15] DFFSXL $PINS D=HFSNET_313 CK=ZCTSNET_406
+ SN=HFSNET_375 QN=shadow_weights[9][15]
Xshadow_weights_reg[8][15] DFFSXL $PINS D=HFSNET_313 CK=net1701 SN=HFSNET_356
+ QN=shadow_weights[8][15]
Xshadow_weights_reg[7][15] DFFSXL $PINS D=HFSNET_313 CK=ZCTSNET_404
+ SN=HFSNET_358 QN=shadow_weights[7][15]
Xshadow_weights_reg[5][15] DFFSXL $PINS D=HFSNET_313 CK=ZCTSNET_402
+ SN=HFSNET_373 QN=shadow_weights[5][15]
Xshadow_weights_reg[3][15] DFFSXL $PINS D=HFSNET_313 CK=ZCTSNET_400
+ SN=HFSNET_358 QN=shadow_weights[3][15]
Xshadow_weights_reg[2][15] DFFSXL $PINS D=HFSNET_313 CK=ZCTSNET_399
+ SN=HFSNET_369 QN=shadow_weights[2][15]
Xshadow_weights_reg[1][15] DFFSXL $PINS D=HFSNET_313 CK=ZCTSNET_398
+ SN=HFSNET_358 QN=shadow_weights[1][15]
Xshadow_weights_reg[0][15] DFFSXL $PINS D=HFSNET_313 CK=net1660 SN=HFSNET_369
+ QN=shadow_weights[0][15]
Xsar_code_reg[0] DFFSX1 $PINS D=n773 CK=clk SN=HFSNET_380 Q=n2185
+ QN=protected_sar_code[0]
Xsar_code_reg[4] DFFSX1 $PINS D=n769 CK=ZCTSNET_384 SN=HFSNET_372 Q=n2190
+ QN=protected_sar_code[4]
Xsar_code_reg[5] DFFSX1 $PINS D=n768 CK=ZCTSNET_384 SN=HFSNET_372 Q=n2191
+ QN=protected_sar_code[5]
Xsar_code_reg[13] DFFSX1 $PINS D=n760 CK=ZCTSNET_384 SN=HFSNET_372 Q=n2188
+ QN=protected_sar_code[13]
Xsar_code_reg[17] DFFSXL $PINS D=n756 CK=ZCTSNET_384 SN=HFSNET_372
+ QN=sar_code[17]
Xsar_code_reg[18] DFFSXL $PINS D=n755 CK=ZCTSNET_384 SN=HFSNET_372
+ QN=sar_code[18]
Xtemp_acc_reg[18] DFFSXL $PINS D=n2329 CK=n2326 SN=HFSNET_353 Q=n2205
+ QN=temp_acc[18]
Xtemp_acc_reg[19] DFFSXL $PINS D=n2330 CK=n2326 SN=HFSNET_364 Q=n2203
+ QN=temp_acc[19]
Xtemp_acc_reg[20] DFFSXL $PINS D=n2331 CK=n2326 SN=HFSNET_364 Q=n2204
+ QN=temp_acc[20]
Xtemp_acc_reg[21] DFFSXL $PINS D=n2332 CK=n2326 SN=HFSNET_364 Q=n2206
+ QN=temp_acc[21]
Xmeas_val_p_reg[21] DFFSXL $PINS D=n902 CK=net1801 SN=HFSNET_364
+ QN=meas_val_p[21]
Xtemp_acc_reg[22] DFFSXL $PINS D=n2333 CK=n2326 SN=HFSNET_364 Q=n2207
+ QN=temp_acc[22]
Xmeas_val_p_reg[22] DFFSXL $PINS D=n901 CK=net1801 SN=HFSNET_351
+ QN=meas_val_p[22]
Xtemp_acc_reg[23] DFFSXL $PINS D=n2334 CK=n2326 SN=HFSNET_351 Q=n2213
+ QN=temp_acc[23]
Xmeas_val_p_reg[23] DFFSXL $PINS D=n900 CK=net1801 SN=HFSNET_351
+ QN=meas_val_p[23]
Xtemp_acc_reg[24] DFFSXL $PINS D=n2335 CK=n2326 SN=HFSNET_351 Q=n2212
+ QN=temp_acc[24]
Xmeas_val_p_reg[24] DFFSXL $PINS D=n899 CK=net1801 SN=HFSNET_351
+ QN=meas_val_p[24]
Xtemp_acc_reg[25] DFFSXL $PINS D=n2336 CK=n2326 SN=HFSNET_351 Q=n2211
+ QN=temp_acc[25]
Xmeas_val_p_reg[25] DFFSXL $PINS D=n898 CK=net1801 SN=HFSNET_351
+ QN=meas_val_p[25]
Xtemp_acc_reg[26] DFFSXL $PINS D=n2337 CK=n2326 SN=rst_n Q=n2210
+ QN=temp_acc[26]
Xmeas_val_p_reg[26] DFFSXL $PINS D=n897 CK=net1801 SN=HFSNET_351
+ QN=meas_val_p[26]
Xtemp_acc_reg[27] DFFSXL $PINS D=n2338 CK=n2326 SN=rst_n Q=n2209
+ QN=temp_acc[27]
Xmeas_val_p_reg[27] DFFSXL $PINS D=n896 CK=net1801 SN=HFSNET_351
+ QN=meas_val_p[27]
Xtemp_acc_reg[28] DFFSXL $PINS D=n2339 CK=n2326 SN=HFSNET_351 Q=n2208
+ QN=temp_acc[28]
Xmeas_val_n_reg[28] DFFSXL $PINS D=n895 CK=net1806 SN=HFSNET_351
+ QN=meas_val_n[28]
Xmeas_val_n_reg[27] DFFSXL $PINS D=n896 CK=net1806 SN=HFSNET_351
+ QN=meas_val_n[27]
Xmeas_val_n_reg[26] DFFSXL $PINS D=n897 CK=net1806 SN=HFSNET_351
+ QN=meas_val_n[26]
Xmeas_val_n_reg[25] DFFSXL $PINS D=n898 CK=net1806 SN=HFSNET_351
+ QN=meas_val_n[25]
Xmeas_val_n_reg[24] DFFSXL $PINS D=n899 CK=net1806 SN=HFSNET_351
+ QN=meas_val_n[24]
Xmeas_val_n_reg[23] DFFSXL $PINS D=n900 CK=net1806 SN=HFSNET_351
+ QN=meas_val_n[23]
Xmeas_val_n_reg[22] DFFSXL $PINS D=n901 CK=net1806 SN=HFSNET_351
+ QN=meas_val_n[22]
Xmeas_val_n_reg[21] DFFSXL $PINS D=n902 CK=net1806 SN=HFSNET_364
+ QN=meas_val_n[21]
Xmeas_val_n_reg[1] DFFSXL $PINS D=n922 CK=net1806 SN=HFSNET_352
+ QN=meas_val_n[1]
Xmeas_val_n_reg[0] DFFSXL $PINS D=n923 CK=net1806 SN=HFSNET_352
+ QN=meas_val_n[0]
Xoverrange_acc_reg DFFSX1 $PINS D=n826 CK=clk SN=HFSNET_381 QN=overrange_acc
Xorr_r_reg DFFSXL $PINS D=n893 CK=net1821 SN=HFSNET_381 QN=orr_r
Xwr_idx_r_reg[2] DFFSXL $PINS D=N1787 CK=net1821 SN=HFSNET_365 Q=wr_idx_r[2]
+ QN=n2159
Xshadow_weights_reg[2][10] DFFSXL $PINS D=calc_result_r[10] CK=ZCTSNET_399
+ SN=HFSNET_356 Q=shadow_weights[2][10]
Xshadow_weights_reg[0][8] DFFSX1 $PINS D=calc_result_r[8] CK=net1660
+ SN=HFSNET_369 Q=shadow_weights[0][8]
Xshadow_weights_reg[1][9] DFFSXL $PINS D=calc_result_r[9] CK=ZCTSNET_398
+ SN=HFSNET_358 Q=shadow_weights[1][9]
Xshadow_weights_reg[5][13] DFFSXL $PINS D=gre_a_INV_6_54 CK=ZCTSNET_402
+ SN=HFSNET_379 Q=shadow_weights[5][13]
Xshadow_weights_reg[4][12] DFFSXL $PINS D=gre_a_INV_6_55 CK=ZCTSNET_401
+ SN=HFSNET_379 Q=shadow_weights[4][12]
Xclk_gate_temp_acc_reg_0
+ SNPS_CLOCK_GATE_HIGH_sar_calib_ctrl_serial_20_30_16_32_5_256_1_1_1_2 $PINS
+ CLK=clk EN=n2328 ENCLK=n2326 TE=VSS ZCTSNET_1=ZCTSNET_411
Xcomp_out_r_reg DFFSX1 $PINS D=n825 CK=clk SN=HFSNET_380 Q=n2233
Xtemp_acc_reg[16] DFFSXL $PINS D=n2324 CK=n2326 SN=HFSNET_353 Q=n2232
+ QN=temp_acc[16]
Xtemp_acc_reg[17] DFFSXL $PINS D=n2325 CK=n2326 SN=HFSNET_353 Q=n2231
+ QN=temp_acc[17]
Xtemp_acc_reg[7] DFFSXL $PINS D=n2315 CK=n2326 SN=HFSNET_362 Q=n2230
+ QN=temp_acc[7]
Xtemp_acc_reg[15] DFFSXL $PINS D=n2323 CK=n2326 SN=HFSNET_352 Q=n2229
+ QN=temp_acc[15]
Xtemp_acc_reg[4] DFFSX1 $PINS D=n2312 CK=n2326 SN=HFSNET_362 Q=n2228
+ QN=temp_acc[4]
Xtemp_acc_reg[10] DFFSXL $PINS D=n2318 CK=n2326 SN=HFSNET_352 Q=n2227
+ QN=temp_acc[10]
Xtemp_acc_reg[12] DFFSXL $PINS D=n2320 CK=n2326 SN=HFSNET_352 Q=n2226
+ QN=temp_acc[12]
Xtemp_acc_reg[14] DFFSXL $PINS D=n2322 CK=n2326 SN=HFSNET_352 Q=n2225
+ QN=temp_acc[14]
Xtemp_acc_reg[6] DFFSX1 $PINS D=n2314 CK=n2326 SN=HFSNET_362 Q=n2224
+ QN=temp_acc[6]
Xtemp_acc_reg[8] DFFSXL $PINS D=n2316 CK=n2326 SN=HFSNET_362 Q=n2223
+ QN=temp_acc[8]
Xtemp_acc_reg[1] DFFSXL $PINS D=n2309 CK=n2326 SN=HFSNET_362 Q=n2221
+ QN=temp_acc[1]
Xtemp_acc_reg[3] DFFSX1 $PINS D=n2311 CK=n2326 SN=HFSNET_362 Q=n2220
+ QN=temp_acc[3]
Xtemp_acc_reg[11] DFFSXL $PINS D=n2319 CK=n2326 SN=HFSNET_352 Q=n2219
+ QN=temp_acc[11]
Xtemp_acc_reg[13] DFFSXL $PINS D=n2321 CK=n2326 SN=HFSNET_352 Q=n2218
+ QN=temp_acc[13]
Xtemp_acc_reg[2] DFFSX1 $PINS D=n2310 CK=n2326 SN=HFSNET_362 Q=n2217
+ QN=temp_acc[2]
Xtemp_acc_reg[5] DFFSX1 $PINS D=n2313 CK=n2326 SN=HFSNET_352 Q=n2216
+ QN=temp_acc[5]
Xtemp_acc_reg[29] DFFSXL $PINS D=n2340 CK=n2326 SN=HFSNET_351 Q=n2214
+ QN=temp_acc[29]
Xaccumulator_reg[35] DFFSXL $PINS D=n929 CK=net1771 SN=HFSNET_354 Q=n2201
+ QN=accumulator[35]
Xaccumulator_reg[34] DFFSXL $PINS D=n930 CK=net1771 SN=HFSNET_365 Q=n2200
+ QN=accumulator[34]
Xaccumulator_reg[33] DFFSXL $PINS D=n931 CK=net1771 SN=HFSNET_365 Q=n2198
+ QN=accumulator[33]
Xsar_ptr_reg[2] DFFSX1 $PINS D=n793 CK=net1781 SN=HFSNET_379 Q=n2197
+ QN=sar_ptr[2]
Xaccumulator_reg[32] DFFSXL $PINS D=n932 CK=net1771 SN=HFSNET_365 Q=n2196
+ QN=accumulator[32]
Xaccumulator_reg[31] DFFSXL $PINS D=n933 CK=net1771 SN=HFSNET_365 Q=n2195
+ QN=accumulator[31]
Xaccumulator_reg[30] DFFSXL $PINS D=HFSNET_66 CK=net1771 SN=HFSNET_365 Q=n2194
+ QN=accumulator[30]
Xmeas_val_n_reg[29] DFFSXL $PINS D=n894 CK=net1806 SN=HFSNET_351 Q=n2193
Xsar_code_reg[19] DFFSXL $PINS D=n754 CK=ZCTSNET_384 SN=HFSNET_380 Q=n2192
+ QN=protected_sar_code[19]
Xcalc_cnt_reg[2] DFFSXL $PINS D=n971 CK=net1811 SN=HFSNET_380 Q=n2176
+ QN=calc_cnt[2]
Xcalc_cnt_reg[1] DFFSXL $PINS D=n972 CK=net1811 SN=HFSNET_380 Q=n2174
+ QN=calc_cnt[1]
Xcalc_cnt_reg[0] DFFSXL $PINS D=n973 CK=net1811 SN=HFSNET_380 Q=n2173
+ QN=calc_cnt[0]
Xshadow_weights_reg[17][29] DFFSXL $PINS D=HFSNET_323 CK=ZCTSNET_395
+ SN=HFSNET_363 Q=n2170 QN=shadow_weights[17][29]
Xmeas_val_p_reg[29] DFFSXL $PINS D=n894 CK=net1801 SN=HFSNET_351 Q=n2169
Xwr_idx_r_reg[0] DFFSXL $PINS D=n892 CK=net1821 SN=HFSNET_365 Q=n2162
+ QN=wr_idx_r[0]
Xcalib_done_pulse_reg DFFSX1 $PINS D=n823 CK=clk SN=HFSNET_380
+ QN=calib_done_pulse
Xw_wr_en_reg DFFSX1 $PINS D=n815 CK=ZCTSNET_408 SN=HFSNET_365 QN=w_wr_en
Xw_wr_addr_reg[0] DFFSXL $PINS D=HFSNET_246 CK=net1791 SN=HFSNET_369
+ QN=w_wr_addr[0]
Xw_wr_data_reg[11] DFFSXL $PINS D=gre_a_INV_1788_54 CK=net1796 SN=HFSNET_357
+ QN=w_wr_data[11]
Xw_wr_data_reg[10] DFFSXL $PINS D=HFSNET_301 CK=net1796 SN=HFSNET_360
+ QN=w_wr_data[10]
Xw_wr_data_reg[9] DFFSXL $PINS D=n69 CK=net1796 SN=HFSNET_361 QN=w_wr_data[9]
Xw_wr_data_reg[8] DFFSXL $PINS D=HFSNET_296 CK=net1796 SN=HFSNET_361
+ QN=w_wr_data[8]
Xw_wr_data_reg[7] DFFSXL $PINS D=HFSNET_341 CK=net1796 SN=HFSNET_357
+ QN=w_wr_data[7]
Xw_wr_data_reg[6] DFFSXL $PINS D=HFSNET_339 CK=net1796 SN=HFSNET_357
+ QN=w_wr_data[6]
Xw_wr_data_reg[5] DFFSXL $PINS D=HFSNET_337 CK=net1796 SN=HFSNET_368
+ QN=w_wr_data[5]
Xw_wr_data_reg[4] DFFSXL $PINS D=HFSNET_336 CK=net1796 SN=HFSNET_358
+ QN=w_wr_data[4]
Xw_wr_data_reg[3] DFFSXL $PINS D=HFSNET_332 CK=net1796 SN=HFSNET_357
+ QN=w_wr_data[3]
Xw_wr_data_reg[2] DFFSXL $PINS D=HFSNET_327 CK=net1796 SN=HFSNET_358
+ QN=w_wr_data[2]
Xw_wr_data_reg[1] DFFSXL $PINS D=HFSNET_317 CK=net1796 SN=HFSNET_358
+ QN=w_wr_data[1]
Xw_wr_data_reg[0] DFFSXL $PINS D=HFSNET_311 CK=net1796 SN=HFSNET_358
+ QN=w_wr_data[0]
Xw_wr_addr_reg[4] DFFSXL $PINS D=n65 CK=net1791 SN=HFSNET_369 QN=w_wr_addr[4]
Xw_wr_addr_reg[3] DFFSXL $PINS D=n2160 CK=net1791 SN=HFSNET_369 QN=w_wr_addr[3]
Xw_wr_addr_reg[2] DFFSXL $PINS D=HFSNET_290 CK=net1791 SN=HFSNET_369
+ QN=w_wr_addr[2]
Xw_wr_addr_reg[1] DFFSXL $PINS D=n2177 CK=net1791 SN=HFSNET_369 QN=w_wr_addr[1]
Xw_wr_data_reg[14] DFFSXL $PINS D=HFSNET_312 CK=net1796 SN=HFSNET_357
+ QN=w_wr_data[14]
Xw_wr_data_reg[13] DFFSXL $PINS D=gre_a_INV_1970_54 CK=net1796 SN=HFSNET_357
+ QN=w_wr_data[13]
Xw_wr_data_reg[12] DFFSXL $PINS D=gre_a_INV_1896_55 CK=net1796 SN=HFSNET_357
+ QN=w_wr_data[12]
Xw_wr_data_reg[29] DFFSXL $PINS D=HFSNET_323 CK=net1791 SN=HFSNET_368
+ QN=w_wr_data[29]
Xw_wr_data_reg[28] DFFSX1 $PINS D=n2306 CK=net1791 SN=HFSNET_368
+ QN=w_wr_data[28]
Xw_wr_data_reg[27] DFFSXL $PINS D=n2305 CK=net1791 SN=HFSNET_368
+ QN=w_wr_data[27]
Xw_wr_data_reg[26] DFFSXL $PINS D=n71 CK=net1791 SN=HFSNET_367 QN=w_wr_data[26]
Xw_wr_data_reg[25] DFFSXL $PINS D=HFSNET_322 CK=net1791 SN=HFSNET_369
+ QN=w_wr_data[25]
Xw_wr_data_reg[24] DFFSXL $PINS D=HFSNET_321 CK=net1791 SN=HFSNET_369
+ QN=w_wr_data[24]
Xw_wr_data_reg[23] DFFSXL $PINS D=HFSNET_320 CK=net1791 SN=HFSNET_368
+ QN=w_wr_data[23]
Xw_wr_data_reg[22] DFFSXL $PINS D=HFSNET_319 CK=net1791 SN=HFSNET_368
+ QN=w_wr_data[22]
Xw_wr_data_reg[21] DFFSXL $PINS D=HFSNET_318 CK=net1791 SN=HFSNET_368
+ QN=w_wr_data[21]
Xw_wr_data_reg[20] DFFSXL $PINS D=n2299 CK=net1791 SN=HFSNET_368
+ QN=w_wr_data[20]
Xw_wr_data_reg[19] DFFSXL $PINS D=n2298 CK=net1791 SN=HFSNET_368
+ QN=w_wr_data[19]
Xw_wr_data_reg[18] DFFSXL $PINS D=HFSNET_316 CK=net1791 SN=HFSNET_369
+ QN=w_wr_data[18]
Xw_wr_data_reg[17] DFFSXL $PINS D=HFSNET_315 CK=net1791 SN=HFSNET_369
+ QN=w_wr_data[17]
Xw_wr_data_reg[16] DFFSXL $PINS D=HFSNET_314 CK=net1796 SN=HFSNET_361
+ QN=w_wr_data[16]
Xw_wr_data_reg[15] DFFSXL $PINS D=HFSNET_313 CK=net1796 SN=HFSNET_361
+ QN=w_wr_data[15]
Xcalib_done_reg DFFSX1 $PINS D=n774 CK=net1761 SN=HFSNET_371 QN=calib_done
Xcalib_mode_en_reg DFFSX1 $PINS D=n968 CK=net1761 SN=HFSNET_381
+ QN=calib_mode_en
Xshadow_weights_reg[17][17] DFFSXL $PINS D=HFSNET_315 CK=ZCTSNET_395
+ SN=HFSNET_356 QN=shadow_weights[17][17]
Xaccumulator_reg[20] DFFSXL $PINS D=n944 CK=net1776 SN=HFSNET_364
+ QN=accumulator[20]
Xmeas_val_n_reg[20] DFFSXL $PINS D=n903 CK=net1806 SN=HFSNET_364
+ QN=meas_val_n[20]
Xshadow_weights_reg[17][16] DFFSXL $PINS D=HFSNET_314 CK=ZCTSNET_395
+ SN=HFSNET_356 QN=shadow_weights[17][16]
Xmeas_val_n_reg[19] DFFSXL $PINS D=n904 CK=net1806 SN=HFSNET_364
+ QN=meas_val_n[19]
Xmeas_val_p_reg[0] DFFSXL $PINS D=n923 CK=net1801 SN=HFSNET_352
+ QN=meas_val_p[0]
Xaccumulator_reg[0] DFFSXL $PINS D=n962 CK=net1776 SN=HFSNET_352
+ QN=accumulator[0]
Xmeas_val_p_reg[3] DFFSXL $PINS D=n920 CK=net1801 SN=HFSNET_352
+ QN=meas_val_p[3]
Xmeas_val_n_reg[3] DFFSXL $PINS D=n920 CK=net1806 SN=HFSNET_352
+ QN=meas_val_n[3]
Xmeas_val_p_reg[1] DFFSXL $PINS D=n922 CK=net1801 SN=HFSNET_352
+ QN=meas_val_p[1]
Xmeas_val_p_reg[11] DFFSXL $PINS D=n912 CK=net1801 SN=HFSNET_353
+ QN=meas_val_p[11]
Xmeas_val_n_reg[11] DFFSXL $PINS D=n912 CK=net1806 SN=HFSNET_353
+ QN=meas_val_n[11]
Xshadow_weights_reg[17][15] DFFSXL $PINS D=HFSNET_313 CK=ZCTSNET_395
+ SN=HFSNET_356 QN=shadow_weights[17][15]
Xaccumulator_reg[11] DFFSXL $PINS D=n952 CK=net1776 SN=HFSNET_364
+ QN=accumulator[11]
Xaccumulator_reg[1] DFFSXL $PINS D=n961 CK=net1776 SN=HFSNET_352
+ QN=accumulator[1]
Xshadow_weights_reg[17][7] DFFSXL $PINS D=HFSNET_341 CK=ZCTSNET_395
+ SN=HFSNET_359 QN=shadow_weights[17][7]
Xmeas_val_p_reg[10] DFFSXL $PINS D=n913 CK=net1801 SN=HFSNET_352
+ QN=meas_val_p[10]
Xmeas_val_n_reg[10] DFFSXL $PINS D=n913 CK=net1806 SN=HFSNET_364
+ QN=meas_val_n[10]
Xaccumulator_reg[10] DFFSXL $PINS D=n953 CK=net1776 SN=HFSNET_364
+ QN=accumulator[10]
Xmeas_val_p_reg[6] DFFSXL $PINS D=n917 CK=net1801 SN=HFSNET_364
+ QN=meas_val_p[6]
Xmeas_val_p_reg[14] DFFSXL $PINS D=n909 CK=net1801 SN=HFSNET_353
+ QN=meas_val_p[14]
Xmeas_val_n_reg[6] DFFSXL $PINS D=n917 CK=net1806 SN=HFSNET_353
+ QN=meas_val_n[6]
Xmeas_val_n_reg[14] DFFSXL $PINS D=n909 CK=net1806 SN=HFSNET_353
+ QN=meas_val_n[14]
Xaccumulator_reg[6] DFFSXL $PINS D=n957 CK=net1776 SN=HFSNET_364
+ QN=accumulator[6]
Xaccumulator_reg[14] DFFSXL $PINS D=n950 CK=net1776 SN=HFSNET_353
+ QN=accumulator[14]
Xmeas_val_p_reg[13] DFFSXL $PINS D=n910 CK=net1801 SN=HFSNET_353
+ QN=meas_val_p[13]
Xmeas_val_p_reg[7] DFFSXL $PINS D=n916 CK=net1801 SN=HFSNET_352
+ QN=meas_val_p[7]
Xmeas_val_n_reg[13] DFFSXL $PINS D=n910 CK=net1806 SN=HFSNET_353
+ QN=meas_val_n[13]
Xmeas_val_n_reg[7] DFFSXL $PINS D=n916 CK=net1806 SN=HFSNET_352
+ QN=meas_val_n[7]
Xaccumulator_reg[13] DFFSXL $PINS D=n818 CK=net1776 SN=HFSNET_364
+ QN=accumulator[13]
Xaccumulator_reg[7] DFFSXL $PINS D=n956 CK=net1776 SN=HFSNET_352
+ QN=accumulator[7]
Xmeas_val_n_reg[4] DFFSXL $PINS D=n919 CK=net1806 SN=HFSNET_352
+ QN=meas_val_n[4]
Xmeas_val_p_reg[4] DFFSXL $PINS D=n919 CK=net1801 SN=HFSNET_353
+ QN=meas_val_p[4]
Xaccumulator_reg[12] DFFSXL $PINS D=n951 CK=net1776 SN=HFSNET_364
+ QN=accumulator[12]
Xmeas_val_n_reg[12] DFFSXL $PINS D=n911 CK=net1806 SN=HFSNET_353
+ QN=meas_val_n[12]
Xmeas_val_p_reg[12] DFFSXL $PINS D=n911 CK=net1801 SN=HFSNET_353
+ QN=meas_val_p[12]
Xmeas_val_n_reg[9] DFFSXL $PINS D=n914 CK=net1806 SN=HFSNET_364
+ QN=meas_val_n[9]
Xmeas_val_p_reg[9] DFFSXL $PINS D=n914 CK=net1801 SN=HFSNET_364
+ QN=meas_val_p[9]
Xaccumulator_reg[18] DFFSXL $PINS D=n946 CK=net1776 SN=HFSNET_364
+ QN=accumulator[18]
Xmeas_val_n_reg[5] DFFSXL $PINS D=n918 CK=net1806 SN=HFSNET_352
+ QN=meas_val_n[5]
Xmeas_val_p_reg[5] DFFSXL $PINS D=n918 CK=net1801 SN=HFSNET_353
+ QN=meas_val_p[5]
Xaccumulator_reg[15] DFFSXL $PINS D=n949 CK=net1776 SN=HFSNET_364
+ QN=accumulator[15]
Xtemp_acc_reg[9] DFFSXL $PINS D=n2317 CK=n2326 SN=HFSNET_362 Q=n2215
+ QN=temp_acc[9]
Xmeas_val_p_reg[18] DFFSXL $PINS D=n905 CK=net1801 SN=HFSNET_353
+ QN=meas_val_p[18]
Xaccumulator_reg[8] DFFSXL $PINS D=n955 CK=net1776 SN=HFSNET_352
+ QN=accumulator[8]
Xmeas_val_p_reg[8] DFFSXL $PINS D=n915 CK=net1801 SN=HFSNET_353
+ QN=meas_val_p[8]
Xmeas_val_p_reg[15] DFFSXL $PINS D=n908 CK=net1801 SN=HFSNET_353
+ QN=meas_val_p[15]
Xmeas_val_n_reg[2] DFFSXL $PINS D=n921 CK=net1806 SN=HFSNET_353
+ QN=meas_val_n[2]
Xmeas_val_p_reg[2] DFFSXL $PINS D=n921 CK=net1801 SN=HFSNET_352
+ QN=meas_val_p[2]
Xaccumulator_reg[16] DFFSXL $PINS D=n948 CK=net1776 SN=HFSNET_364
+ QN=accumulator[16]
Xmeas_val_p_reg[16] DFFSXL $PINS D=n907 CK=net1801 SN=HFSNET_353
+ QN=meas_val_p[16]
Xaccumulator_reg[17] DFFSXL $PINS D=n947 CK=net1776 SN=HFSNET_364
+ QN=accumulator[17]
Xmeas_val_p_reg[17] DFFSXL $PINS D=n906 CK=net1801 SN=HFSNET_364
+ QN=meas_val_p[17]
Xmeas_val_p_reg[19] DFFSXL $PINS D=n904 CK=net1801 SN=HFSNET_364
+ QN=meas_val_p[19]
Xmeas_val_n_reg[15] DFFSXL $PINS D=n908 CK=net1806 SN=HFSNET_353
+ QN=meas_val_n[15]
Xtemp_acc_reg[0] DFFSXL $PINS D=n2308 CK=n2326 SN=HFSNET_362 Q=n2222
+ QN=temp_acc[0]
Xstate_reg[2] DFFSX1 $PINS D=n819 CK=clk SN=HFSNET_380 Q=n68 QN=state[2]
Xshadow_weights_reg[15][15] DFFSXL $PINS D=HFSNET_313 CK=ZCTSNET_393
+ SN=HFSNET_356 QN=shadow_weights[15][15]
Xshadow_weights_reg[11][15] DFFSXL $PINS D=HFSNET_313 CK=ZCTSNET_389
+ SN=HFSNET_375 QN=shadow_weights[11][15]
Xshadow_weights_reg[4][15] DFFSXL $PINS D=HFSNET_313 CK=ZCTSNET_401
+ SN=HFSNET_373 QN=shadow_weights[4][15]
Xshadow_weights_reg[18][15] DFFSXL $PINS D=HFSNET_313 CK=net1751 SN=HFSNET_355
+ QN=shadow_weights[18][15]
Xshadow_weights_reg[16][15] DFFSXL $PINS D=HFSNET_313 CK=ZCTSNET_394
+ SN=HFSNET_355 QN=shadow_weights[16][15]
Xshadow_weights_reg[15][16] DFFSXL $PINS D=HFSNET_314 CK=ZCTSNET_393
+ SN=HFSNET_357 QN=shadow_weights[15][16]
Xshadow_weights_reg[11][16] DFFSXL $PINS D=HFSNET_314 CK=ZCTSNET_389
+ SN=HFSNET_378 QN=shadow_weights[11][16]
Xshadow_weights_reg[4][16] DFFSXL $PINS D=HFSNET_314 CK=ZCTSNET_401
+ SN=HFSNET_373 QN=shadow_weights[4][16]
Xshadow_weights_reg[18][16] DFFSXL $PINS D=HFSNET_314 CK=net1751 SN=HFSNET_355
+ QN=shadow_weights[18][16]
Xshadow_weights_reg[16][16] DFFSXL $PINS D=HFSNET_314 CK=ZCTSNET_394
+ SN=HFSNET_355 QN=shadow_weights[16][16]
Xshadow_weights_reg[15][17] DFFSXL $PINS D=HFSNET_315 CK=ZCTSNET_393
+ SN=HFSNET_357 QN=shadow_weights[15][17]
Xshadow_weights_reg[11][17] DFFSXL $PINS D=HFSNET_315 CK=ZCTSNET_389
+ SN=HFSNET_376 QN=shadow_weights[11][17]
Xshadow_weights_reg[4][17] DFFSXL $PINS D=HFSNET_315 CK=ZCTSNET_401
+ SN=HFSNET_378 QN=shadow_weights[4][17]
Xshadow_weights_reg[18][17] DFFSXL $PINS D=HFSNET_315 CK=net1751 SN=HFSNET_355
+ QN=shadow_weights[18][17]
Xshadow_weights_reg[16][17] DFFSXL $PINS D=HFSNET_315 CK=ZCTSNET_394
+ SN=HFSNET_355 QN=shadow_weights[16][17]
Xshadow_weights_reg[15][29] DFFSXL $PINS D=HFSNET_323 CK=ZCTSNET_393
+ SN=HFSNET_367 QN=shadow_weights[15][29]
Xshadow_weights_reg[11][29] DFFSXL $PINS D=HFSNET_323 CK=ZCTSNET_389
+ SN=HFSNET_378 QN=shadow_weights[11][29]
Xshadow_weights_reg[4][29] DFFSXL $PINS D=HFSNET_323 CK=ZCTSNET_401
+ SN=HFSNET_378 QN=shadow_weights[4][29]
Xshadow_weights_reg[18][29] DFFSXL $PINS D=HFSNET_323 CK=net1751 SN=HFSNET_363
+ QN=shadow_weights[18][29]
Xshadow_weights_reg[16][29] DFFSXL $PINS D=HFSNET_323 CK=ZCTSNET_394
+ SN=HFSNET_363 QN=shadow_weights[16][29]
Xshadow_weights_reg[15][7] DFFSXL $PINS D=HFSNET_341 CK=ZCTSNET_393
+ SN=HFSNET_360 QN=shadow_weights[15][7]
Xshadow_weights_reg[11][7] DFFSXL $PINS D=HFSNET_341 CK=ZCTSNET_389
+ SN=HFSNET_375 QN=shadow_weights[11][7]
Xshadow_weights_reg[4][7] DFFSXL $PINS D=HFSNET_341 CK=ZCTSNET_401
+ SN=HFSNET_378 QN=shadow_weights[4][7]
Xshadow_weights_reg[18][7] DFFSXL $PINS D=HFSNET_341 CK=net1751 SN=HFSNET_362
+ QN=shadow_weights[18][7]
Xshadow_weights_reg[16][7] DFFSXL $PINS D=HFSNET_341 CK=ZCTSNET_394
+ SN=HFSNET_362 QN=shadow_weights[16][7]
Xcalc_result_r_reg[26] DFFSX2 $PINS D=n833 CK=net1826 SN=HFSNET_363 Q=n71
Xshadow_weights_reg[15][26] DFFSXL $PINS D=n71 CK=ZCTSNET_393 SN=HFSNET_370
+ QN=shadow_weights[15][26]
Xshadow_weights_reg[11][26] DFFSXL $PINS D=HFSNET_299 CK=ZCTSNET_389
+ SN=HFSNET_379 QN=shadow_weights[11][26]
Xshadow_weights_reg[4][26] DFFSXL $PINS D=HFSNET_299 CK=ZCTSNET_401
+ SN=HFSNET_379 QN=shadow_weights[4][26]
Xshadow_weights_reg[18][26] DFFSXL $PINS D=n71 CK=net1751 SN=HFSNET_366
+ QN=shadow_weights[18][26]
Xshadow_weights_reg[16][26] DFFSXL $PINS D=n71 CK=ZCTSNET_394 SN=HFSNET_366
+ QN=shadow_weights[16][26]
Xshadow_weights_reg[15][18] DFFSXL $PINS D=HFSNET_316 CK=ZCTSNET_393
+ SN=HFSNET_360 QN=shadow_weights[15][18]
Xshadow_weights_reg[11][18] DFFSXL $PINS D=HFSNET_316 CK=ZCTSNET_389
+ SN=HFSNET_376 QN=shadow_weights[11][18]
Xshadow_weights_reg[4][18] DFFSXL $PINS D=HFSNET_316 CK=ZCTSNET_401
+ SN=HFSNET_368 QN=shadow_weights[4][18]
Xshadow_weights_reg[18][18] DFFSXL $PINS D=HFSNET_316 CK=net1751 SN=HFSNET_354
+ QN=shadow_weights[18][18]
Xshadow_weights_reg[16][18] DFFSXL $PINS D=HFSNET_316 CK=ZCTSNET_394
+ SN=HFSNET_369 QN=shadow_weights[16][18]
Xshadow_weights_reg[15][19] DFFSXL $PINS D=n2298 CK=ZCTSNET_393 SN=HFSNET_369
+ QN=shadow_weights[15][19]
Xshadow_weights_reg[11][19] DFFSXL $PINS D=n2298 CK=ZCTSNET_389 SN=HFSNET_368
+ QN=shadow_weights[11][19]
Xshadow_weights_reg[4][19] DFFSXL $PINS D=n2298 CK=ZCTSNET_401 SN=HFSNET_368
+ QN=shadow_weights[4][19]
Xshadow_weights_reg[18][19] DFFSXL $PINS D=n2298 CK=net1751 SN=HFSNET_363
+ QN=shadow_weights[18][19]
Xshadow_weights_reg[16][19] DFFSXL $PINS D=n2298 CK=ZCTSNET_394 SN=HFSNET_363
+ QN=shadow_weights[16][19]
Xshadow_weights_reg[15][20] DFFSXL $PINS D=n2299 CK=ZCTSNET_393 SN=HFSNET_367
+ QN=shadow_weights[15][20]
Xshadow_weights_reg[11][20] DFFSXL $PINS D=n2299 CK=ZCTSNET_389 SN=HFSNET_374
+ QN=shadow_weights[11][20]
Xshadow_weights_reg[4][20] DFFSXL $PINS D=n2299 CK=ZCTSNET_401 SN=HFSNET_368
+ QN=shadow_weights[4][20]
Xshadow_weights_reg[18][20] DFFSXL $PINS D=n2299 CK=net1751 SN=HFSNET_365
+ QN=shadow_weights[18][20]
Xshadow_weights_reg[16][20] DFFSXL $PINS D=n2299 CK=ZCTSNET_394 SN=HFSNET_366
+ QN=shadow_weights[16][20]
Xshadow_weights_reg[15][21] DFFSXL $PINS D=HFSNET_318 CK=ZCTSNET_393
+ SN=HFSNET_380 QN=shadow_weights[15][21]
Xshadow_weights_reg[11][21] DFFSXL $PINS D=HFSNET_318 CK=ZCTSNET_389
+ SN=HFSNET_379 QN=shadow_weights[11][21]
Xshadow_weights_reg[4][21] DFFSXL $PINS D=HFSNET_318 CK=ZCTSNET_401
+ SN=HFSNET_373 QN=shadow_weights[4][21]
Xshadow_weights_reg[18][21] DFFSXL $PINS D=HFSNET_318 CK=net1751 SN=HFSNET_365
+ QN=shadow_weights[18][21]
Xshadow_weights_reg[16][21] DFFSXL $PINS D=HFSNET_318 CK=ZCTSNET_394
+ SN=HFSNET_366 QN=shadow_weights[16][21]
Xshadow_weights_reg[15][22] DFFSXL $PINS D=HFSNET_319 CK=ZCTSNET_393
+ SN=HFSNET_367 QN=shadow_weights[15][22]
Xshadow_weights_reg[11][22] DFFSXL $PINS D=HFSNET_319 CK=ZCTSNET_389
+ SN=HFSNET_379 QN=shadow_weights[11][22]
Xshadow_weights_reg[4][22] DFFSXL $PINS D=HFSNET_319 CK=ZCTSNET_401
+ SN=HFSNET_373 QN=shadow_weights[4][22]
Xshadow_weights_reg[18][22] DFFSXL $PINS D=HFSNET_319 CK=net1751 SN=HFSNET_363
+ QN=shadow_weights[18][22]
Xshadow_weights_reg[16][22] DFFSXL $PINS D=HFSNET_319 CK=ZCTSNET_394
+ SN=HFSNET_363 QN=shadow_weights[16][22]
Xshadow_weights_reg[15][23] DFFSXL $PINS D=HFSNET_320 CK=ZCTSNET_393
+ SN=HFSNET_367 QN=shadow_weights[15][23]
Xshadow_weights_reg[11][23] DFFSXL $PINS D=HFSNET_320 CK=ZCTSNET_389
+ SN=HFSNET_374 QN=shadow_weights[11][23]
Xshadow_weights_reg[4][23] DFFSXL $PINS D=HFSNET_320 CK=ZCTSNET_401
+ SN=HFSNET_370 QN=shadow_weights[4][23]
Xshadow_weights_reg[18][23] DFFSXL $PINS D=HFSNET_320 CK=net1751 SN=HFSNET_363
+ QN=shadow_weights[18][23]
Xshadow_weights_reg[16][23] DFFSXL $PINS D=HFSNET_320 CK=ZCTSNET_394
+ SN=HFSNET_363 QN=shadow_weights[16][23]
Xshadow_weights_reg[15][24] DFFSXL $PINS D=HFSNET_321 CK=ZCTSNET_393
+ SN=HFSNET_370 QN=shadow_weights[15][24]
Xshadow_weights_reg[11][24] DFFSXL $PINS D=HFSNET_321 CK=ZCTSNET_389
+ SN=HFSNET_368 QN=shadow_weights[11][24]
Xshadow_weights_reg[4][24] DFFSXL $PINS D=HFSNET_321 CK=ZCTSNET_401
+ SN=HFSNET_370 QN=shadow_weights[4][24]
Xshadow_weights_reg[18][24] DFFSXL $PINS D=HFSNET_321 CK=net1751 SN=HFSNET_365
+ QN=shadow_weights[18][24]
Xshadow_weights_reg[16][24] DFFSXL $PINS D=HFSNET_321 CK=ZCTSNET_394
+ SN=HFSNET_363 QN=shadow_weights[16][24]
Xshadow_weights_reg[15][25] DFFSXL $PINS D=HFSNET_322 CK=ZCTSNET_393
+ SN=HFSNET_380 QN=shadow_weights[15][25]
Xshadow_weights_reg[11][25] DFFSXL $PINS D=HFSNET_322 CK=ZCTSNET_389
+ SN=HFSNET_374 QN=shadow_weights[11][25]
Xshadow_weights_reg[4][25] DFFSXL $PINS D=HFSNET_322 CK=ZCTSNET_401
+ SN=HFSNET_379 QN=shadow_weights[4][25]
Xshadow_weights_reg[18][25] DFFSXL $PINS D=HFSNET_322 CK=net1751 SN=HFSNET_365
+ QN=shadow_weights[18][25]
Xshadow_weights_reg[16][25] DFFSXL $PINS D=HFSNET_322 CK=ZCTSNET_394
+ SN=HFSNET_366 QN=shadow_weights[16][25]
Xshadow_weights_reg[15][27] DFFSXL $PINS D=n2305 CK=ZCTSNET_393 SN=HFSNET_370
+ QN=shadow_weights[15][27]
Xshadow_weights_reg[11][27] DFFSXL $PINS D=n2305 CK=ZCTSNET_389 SN=HFSNET_379
+ QN=shadow_weights[11][27]
Xshadow_weights_reg[4][27] DFFSXL $PINS D=n2305 CK=ZCTSNET_401 SN=HFSNET_373
+ QN=shadow_weights[4][27]
Xshadow_weights_reg[18][27] DFFSXL $PINS D=n2305 CK=net1751 SN=HFSNET_366
+ QN=shadow_weights[18][27]
Xshadow_weights_reg[16][27] DFFSXL $PINS D=n2305 CK=ZCTSNET_394 SN=HFSNET_366
+ QN=shadow_weights[16][27]
Xshadow_weights_reg[15][28] DFFSXL $PINS D=n2306 CK=ZCTSNET_393 SN=HFSNET_370
+ QN=shadow_weights[15][28]
Xshadow_weights_reg[11][28] DFFSXL $PINS D=n2306 CK=ZCTSNET_389 SN=HFSNET_379
+ QN=shadow_weights[11][28]
Xshadow_weights_reg[4][28] DFFSXL $PINS D=n2306 CK=ZCTSNET_401 SN=HFSNET_368
+ QN=shadow_weights[4][28]
Xshadow_weights_reg[18][28] DFFSXL $PINS D=n2306 CK=net1751 SN=HFSNET_363
+ QN=shadow_weights[18][28]
Xshadow_weights_reg[16][28] DFFSXL $PINS D=n2306 CK=ZCTSNET_394 SN=HFSNET_366
+ QN=shadow_weights[16][28]
Xshadow_weights_reg[11][14] DFFSXL $PINS D=HFSNET_312 CK=ZCTSNET_389
+ SN=HFSNET_376 QN=shadow_weights[11][14]
Xshadow_weights_reg[4][14] DFFSXL $PINS D=HFSNET_312 CK=ZCTSNET_401
+ SN=HFSNET_377 QN=shadow_weights[4][14]
Xshadow_weights_reg[18][14] DFFSXL $PINS D=HFSNET_312 CK=net1751 SN=HFSNET_362
+ QN=shadow_weights[18][14]
Xshadow_weights_reg[16][14] DFFSXL $PINS D=HFSNET_312 CK=ZCTSNET_394
+ SN=HFSNET_362 QN=shadow_weights[16][14]
Xshadow_weights_reg[17][14] DFFSXL $PINS D=HFSNET_312 CK=ZCTSNET_395
+ SN=HFSNET_355 QN=shadow_weights[17][14]
Xshadow_weights_reg[11][0] DFFSXL $PINS D=HFSNET_311 CK=ZCTSNET_389
+ SN=HFSNET_376 QN=shadow_weights[11][0]
Xshadow_weights_reg[4][0] DFFSXL $PINS D=HFSNET_311 CK=ZCTSNET_401
+ SN=HFSNET_368 QN=shadow_weights[4][0]
Xshadow_weights_reg[18][0] DFFSXL $PINS D=HFSNET_311 CK=net1751 SN=HFSNET_355
+ QN=shadow_weights[18][0]
Xshadow_weights_reg[16][0] DFFSXL $PINS D=HFSNET_311 CK=ZCTSNET_394
+ SN=HFSNET_355 QN=shadow_weights[16][0]
Xshadow_weights_reg[17][0] DFFSXL $PINS D=HFSNET_311 CK=ZCTSNET_395
+ SN=HFSNET_359 QN=shadow_weights[17][0]
Xshadow_weights_reg[11][1] DFFSXL $PINS D=HFSNET_317 CK=ZCTSNET_389
+ SN=HFSNET_376 QN=shadow_weights[11][1]
Xshadow_weights_reg[4][1] DFFSXL $PINS D=HFSNET_317 CK=ZCTSNET_401
+ SN=HFSNET_378 QN=shadow_weights[4][1]
Xshadow_weights_reg[18][1] DFFSXL $PINS D=HFSNET_317 CK=net1751 SN=HFSNET_355
+ QN=shadow_weights[18][1]
Xshadow_weights_reg[16][1] DFFSXL $PINS D=HFSNET_317 CK=ZCTSNET_394
+ SN=HFSNET_362 QN=shadow_weights[16][1]
Xshadow_weights_reg[17][1] DFFSXL $PINS D=HFSNET_317 CK=ZCTSNET_395
+ SN=HFSNET_359 QN=shadow_weights[17][1]
Xshadow_weights_reg[11][2] DFFSXL $PINS D=HFSNET_327 CK=ZCTSNET_389
+ SN=HFSNET_376 QN=shadow_weights[11][2]
Xshadow_weights_reg[4][2] DFFSXL $PINS D=HFSNET_327 CK=ZCTSNET_401
+ SN=HFSNET_378 QN=shadow_weights[4][2]
Xshadow_weights_reg[18][2] DFFSXL $PINS D=HFSNET_327 CK=net1751 SN=HFSNET_362
+ QN=shadow_weights[18][2]
Xshadow_weights_reg[16][2] DFFSXL $PINS D=HFSNET_327 CK=ZCTSNET_394
+ SN=HFSNET_355 QN=shadow_weights[16][2]
Xshadow_weights_reg[17][2] DFFSXL $PINS D=HFSNET_327 CK=ZCTSNET_395
+ SN=HFSNET_359 QN=shadow_weights[17][2]
Xshadow_weights_reg[11][3] DFFSXL $PINS D=HFSNET_332 CK=ZCTSNET_389
+ SN=HFSNET_376 QN=shadow_weights[11][3]
Xshadow_weights_reg[4][3] DFFSXL $PINS D=HFSNET_332 CK=ZCTSNET_401
+ SN=HFSNET_378 QN=shadow_weights[4][3]
Xshadow_weights_reg[18][3] DFFSXL $PINS D=HFSNET_332 CK=net1751 SN=HFSNET_362
+ QN=shadow_weights[18][3]
Xshadow_weights_reg[16][3] DFFSXL $PINS D=HFSNET_332 CK=ZCTSNET_394
+ SN=HFSNET_359 QN=shadow_weights[16][3]
Xshadow_weights_reg[17][3] DFFSXL $PINS D=HFSNET_332 CK=ZCTSNET_395
+ SN=HFSNET_359 QN=shadow_weights[17][3]
Xshadow_weights_reg[11][4] DFFSXL $PINS D=HFSNET_336 CK=ZCTSNET_389
+ SN=HFSNET_377 QN=shadow_weights[11][4]
Xshadow_weights_reg[4][4] DFFSXL $PINS D=HFSNET_336 CK=ZCTSNET_401
+ SN=HFSNET_377 QN=shadow_weights[4][4]
Xshadow_weights_reg[18][4] DFFSXL $PINS D=HFSNET_336 CK=net1751 SN=HFSNET_355
+ QN=shadow_weights[18][4]
Xshadow_weights_reg[16][4] DFFSXL $PINS D=HFSNET_336 CK=ZCTSNET_394
+ SN=HFSNET_355 QN=shadow_weights[16][4]
Xshadow_weights_reg[17][4] DFFSXL $PINS D=HFSNET_336 CK=ZCTSNET_395
+ SN=HFSNET_355 QN=shadow_weights[17][4]
Xshadow_weights_reg[11][5] DFFSXL $PINS D=HFSNET_337 CK=ZCTSNET_389
+ SN=HFSNET_375 QN=shadow_weights[11][5]
Xshadow_weights_reg[4][5] DFFSXL $PINS D=HFSNET_337 CK=ZCTSNET_401
+ SN=HFSNET_378 QN=shadow_weights[4][5]
Xshadow_weights_reg[18][5] DFFSXL $PINS D=HFSNET_337 CK=net1751 SN=HFSNET_362
+ QN=shadow_weights[18][5]
Xshadow_weights_reg[16][5] DFFSXL $PINS D=HFSNET_337 CK=ZCTSNET_394
+ SN=HFSNET_362 QN=shadow_weights[16][5]
Xshadow_weights_reg[17][5] DFFSXL $PINS D=HFSNET_337 CK=ZCTSNET_395
+ SN=HFSNET_359 QN=shadow_weights[17][5]
Xshadow_weights_reg[11][6] DFFSXL $PINS D=HFSNET_339 CK=ZCTSNET_389
+ SN=HFSNET_376 QN=shadow_weights[11][6]
Xshadow_weights_reg[4][6] DFFSXL $PINS D=HFSNET_339 CK=ZCTSNET_401
+ SN=HFSNET_377 QN=shadow_weights[4][6]
Xshadow_weights_reg[18][6] DFFSXL $PINS D=HFSNET_339 CK=net1751 SN=HFSNET_362
+ QN=shadow_weights[18][6]
Xshadow_weights_reg[16][6] DFFSXL $PINS D=HFSNET_339 CK=ZCTSNET_394
+ SN=HFSNET_355 QN=shadow_weights[16][6]
Xshadow_weights_reg[17][6] DFFSXL $PINS D=HFSNET_339 CK=ZCTSNET_395
+ SN=HFSNET_359 QN=shadow_weights[17][6]
Xcalc_result_r_reg[8] DFFSX2 $PINS D=n851 CK=net1826 SN=HFSNET_355 Q=n70
+ QN=calc_result_r[8]
Xshadow_weights_reg[11][8] DFFSXL $PINS D=HFSNET_296 CK=ZCTSNET_389
+ SN=HFSNET_376 QN=shadow_weights[11][8]
Xshadow_weights_reg[4][8] DFFSXL $PINS D=n70 CK=ZCTSNET_401 SN=HFSNET_378
+ QN=shadow_weights[4][8]
Xshadow_weights_reg[18][8] DFFSXL $PINS D=HFSNET_295 CK=net1751 SN=HFSNET_362
+ QN=shadow_weights[18][8]
Xshadow_weights_reg[16][8] DFFSXL $PINS D=HFSNET_296 CK=ZCTSNET_394
+ SN=HFSNET_362 QN=shadow_weights[16][8]
Xshadow_weights_reg[17][8] DFFSXL $PINS D=HFSNET_296 CK=ZCTSNET_395
+ SN=HFSNET_359 QN=shadow_weights[17][8]
Xcalc_result_r_reg[9] DFFSX4 $PINS D=n850 CK=net1826 SN=HFSNET_363 Q=n69
+ QN=calc_result_r[9]
Xshadow_weights_reg[11][9] DFFSXL $PINS D=n69 CK=ZCTSNET_389 SN=HFSNET_376
+ QN=shadow_weights[11][9]
Xshadow_weights_reg[4][9] DFFSXL $PINS D=n69 CK=ZCTSNET_401 SN=HFSNET_368
+ QN=shadow_weights[4][9]
Xshadow_weights_reg[18][9] DFFSXL $PINS D=n69 CK=net1751 SN=HFSNET_355
+ QN=shadow_weights[18][9]
Xshadow_weights_reg[16][9] DFFSXL $PINS D=n69 CK=ZCTSNET_394 SN=HFSNET_355
+ QN=shadow_weights[16][9]
Xshadow_weights_reg[17][9] DFFSXL $PINS D=n69 CK=ZCTSNET_395 SN=HFSNET_359
+ QN=shadow_weights[17][9]
Xshadow_weights_reg[15][12] DFFSXL $PINS D=gre_a_INV_1896_55 CK=ZCTSNET_393
+ SN=HFSNET_357 QN=shadow_weights[15][12]
Xshadow_weights_reg[11][12] DFFSXL $PINS D=gre_a_INV_1896_55 CK=ZCTSNET_389
+ SN=HFSNET_374 QN=shadow_weights[11][12]
Xshadow_weights_reg[18][12] DFFSXL $PINS D=gre_a_INV_1896_55 CK=net1751
+ SN=HFSNET_355 QN=shadow_weights[18][12]
Xshadow_weights_reg[16][12] DFFSXL $PINS D=gre_a_INV_1896_55 CK=ZCTSNET_394
+ SN=HFSNET_356 QN=shadow_weights[16][12]
Xshadow_weights_reg[17][12] DFFSXL $PINS D=gre_a_INV_1896_55 CK=ZCTSNET_395
+ SN=HFSNET_363 QN=shadow_weights[17][12]
Xshadow_weights_reg[11][13] DFFSXL $PINS D=gre_a_INV_1970_54 CK=ZCTSNET_389
+ SN=HFSNET_375 QN=shadow_weights[11][13]
Xshadow_weights_reg[4][13] DFFSXL $PINS D=gre_a_INV_1970_54 CK=ZCTSNET_401
+ SN=HFSNET_379 QN=shadow_weights[4][13]
Xshadow_weights_reg[18][13] DFFSXL $PINS D=gre_a_INV_1970_54 CK=net1751
+ SN=HFSNET_355 QN=shadow_weights[18][13]
Xshadow_weights_reg[16][13] DFFSXL $PINS D=gre_a_INV_1970_54 CK=ZCTSNET_394
+ SN=HFSNET_356 QN=shadow_weights[16][13]
Xshadow_weights_reg[17][13] DFFSXL $PINS D=gre_a_INV_1970_54 CK=ZCTSNET_395
+ SN=HFSNET_359 QN=shadow_weights[17][13]
Xshadow_weights_reg[11][10] DFFSXL $PINS D=HFSNET_301 CK=ZCTSNET_389
+ SN=HFSNET_378 QN=shadow_weights[11][10]
Xshadow_weights_reg[4][10] DFFSXL $PINS D=HFSNET_301 CK=ZCTSNET_401
+ SN=HFSNET_377 QN=shadow_weights[4][10]
Xshadow_weights_reg[18][10] DFFSXL $PINS D=HFSNET_301 CK=net1751 SN=HFSNET_362
+ QN=shadow_weights[18][10]
Xshadow_weights_reg[16][10] DFFSXL $PINS D=HFSNET_301 CK=ZCTSNET_394
+ SN=HFSNET_362 QN=shadow_weights[16][10]
Xshadow_weights_reg[17][10] DFFSXL $PINS D=HFSNET_301 CK=ZCTSNET_395
+ SN=HFSNET_359 QN=shadow_weights[17][10]
Xshadow_weights_reg[11][11] DFFSXL $PINS D=gre_a_INV_1788_54 CK=ZCTSNET_389
+ SN=HFSNET_377 QN=shadow_weights[11][11]
Xshadow_weights_reg[4][11] DFFSXL $PINS D=gre_a_INV_1788_54 CK=ZCTSNET_401
+ SN=HFSNET_368 QN=shadow_weights[4][11]
Xshadow_weights_reg[18][11] DFFSXL $PINS D=gre_a_INV_1788_54 CK=net1751
+ SN=HFSNET_355 QN=shadow_weights[18][11]
Xshadow_weights_reg[16][11] DFFSXL $PINS D=gre_a_INV_1788_54 CK=ZCTSNET_394
+ SN=HFSNET_359 QN=shadow_weights[16][11]
Xshadow_weights_reg[17][11] DFFSXL $PINS D=gre_a_INV_1788_54 CK=ZCTSNET_395
+ SN=HFSNET_359 QN=shadow_weights[17][11]
Xcalc_cnt_reg[3] DFFSX1 $PINS D=n970 CK=net1811 SN=HFSNET_380 Q=n2175
+ QN=calc_cnt[3]
Xcalc_cnt_reg[4] DFFSX1 $PINS D=n969 CK=net1811 SN=HFSNET_380 Q=n2161
+ QN=calc_cnt[4]
Xwr_idx_r_reg[1] DFFSX2 $PINS D=N1786 CK=net1821 SN=HFSNET_355 Q=wr_idx_r[1]
+ QN=n2177
Xtarget_bit_reg[2] DFFSX2 $PINS D=N1491 CK=net1766 SN=HFSNET_381
+ Q=target_bit[2] QN=n2179
Xtarget_bit_reg[4] DFFSX2 $PINS D=n827 CK=net1766 SN=HFSNET_381 Q=n2178
+ QN=target_bit[4]
Xtarget_bit_reg[3] DFFSX2 $PINS D=n828 CK=net1766 SN=HFSNET_381 Q=n2202
+ QN=target_bit[3]
Xoverrange_bits_reg[10] DFFSX2 $PINS D=n707 CK=net1766 SN=rst_n
+ QN=overrange_bits[10]
Xoverrange_bits_reg[11] DFFSX2 $PINS D=n706 CK=net1766 SN=rst_n
+ QN=overrange_bits[11]
Xoverrange_bits_reg[12] DFFSX2 $PINS D=n705 CK=net1766 SN=rst_n
+ QN=overrange_bits[12]
Xoverrange_bits_reg[13] DFFSX2 $PINS D=n704 CK=net1766 SN=rst_n
+ QN=overrange_bits[13]
Xoverrange_bits_reg[14] DFFSX2 $PINS D=n703 CK=net1766 SN=rst_n
+ QN=overrange_bits[14]
Xoverrange_bits_reg[15] DFFSX2 $PINS D=n702 CK=net1766 SN=rst_n
+ QN=overrange_bits[15]
Xwr_idx_r_reg[3] DFFSX2 $PINS D=n891 CK=net1821 SN=HFSNET_365 Q=n2160
+ QN=wr_idx_r[3]
Xtarget_bit_reg[1] DFFSX2 $PINS D=N1490 CK=net1766 SN=HFSNET_381
+ Q=target_bit[1] QN=n2158
Xoverrange_bits_reg[0] DFFSX2 $PINS D=n717 CK=net1766 SN=HFSNET_381
+ QN=overrange_bits[0]
Xoverrange_bits_reg[1] DFFSX2 $PINS D=n716 CK=net1766 SN=HFSNET_381
+ QN=overrange_bits[1]
Xoverrange_bits_reg[2] DFFSXL $PINS D=n715 CK=net1766 SN=HFSNET_381
+ QN=aps_rename_4_
Xmeas_val_n_reg[18] DFFSXL $PINS D=n905 CK=net1806 SN=HFSNET_353
+ QN=meas_val_n[18]
Xmeas_val_n_reg[8] DFFSXL $PINS D=n915 CK=net1806 SN=HFSNET_353
+ QN=meas_val_n[8]
Xmeas_val_n_reg[16] DFFSXL $PINS D=n907 CK=net1806 SN=HFSNET_364
+ QN=meas_val_n[16]
Xmeas_val_n_reg[17] DFFSXL $PINS D=n906 CK=net1806 SN=HFSNET_364
+ QN=meas_val_n[17]
Xoverrange_bits_reg[7] DFFSXL $PINS D=n710 CK=net1766 SN=HFSNET_381
+ QN=aps_rename_3_
Xtarget_bit_reg[0] DFFSX2 $PINS D=n829 CK=net1766 SN=HFSNET_381 Q=n2163
+ QN=target_bit[0]
Xmeas_val_p_reg[20] DFFSXL $PINS D=n903 CK=net1801 SN=HFSNET_364
+ QN=meas_val_p[20]
Xwr_idx_r_reg[4] DFFSX2 $PINS D=n890 CK=net1821 SN=HFSNET_365 Q=n65
+ QN=wr_idx_r[4]
Xstate_reg[0] DFFSX1 $PINS D=n821 CK=clk SN=HFSNET_380 Q=n2171 QN=state[0]
Xcalib_overrange_reg DFFSX1 $PINS D=n698 CK=ZCTSNET_408 SN=HFSNET_381
+ QN=calib_overrange
Xoverrange_bits_reg[6] DFFSX1 $PINS D=n711 CK=net1766 SN=rst_n
+ QN=overrange_bits[6]
Xoverrange_bits_reg[8] DFFSX2 $PINS D=n709 CK=net1766 SN=rst_n
+ QN=overrange_bits[8]
Xoverrange_bits_reg[16] DFFSX1 $PINS D=n701 CK=net1766 SN=rst_n
+ QN=overrange_bits[16]
Xoverrange_bits_reg[17] DFFSXL $PINS D=n700 CK=net1766 SN=HFSNET_381
+ QN=aps_rename_2_
Xoverrange_bits_reg[18] DFFSXL $PINS D=n699 CK=net1766 SN=HFSNET_381
+ QN=aps_rename_1_
Xoverrange_bits_reg[19] DFFSX1 $PINS D=n697 CK=net1761 SN=HFSNET_381
+ QN=overrange_bits[19]
Xoverrange_bits_reg[3] DFFSX2 $PINS D=n714 CK=net1766 SN=rst_n
+ QN=overrange_bits[3]
Xoverrange_bits_reg[4] DFFSX2 $PINS D=n713 CK=net1766 SN=rst_n
+ QN=overrange_bits[4]
Xoverrange_bits_reg[5] DFFSX2 $PINS D=n712 CK=net1766 SN=rst_n
+ QN=overrange_bits[5]
Xoverrange_bits_reg[9] DFFSX2 $PINS D=n708 CK=net1766 SN=rst_n
+ QN=overrange_bits[9]
Xsar_code_reg[15] DFFSX1 $PINS D=n758 CK=ZCTSNET_384 SN=HFSNET_372 Q=n2182
+ QN=protected_sar_code[15]
Xsar_code_reg[7] DFFSX1 $PINS D=n766 CK=ZCTSNET_384 SN=HFSNET_372 Q=n2180
+ QN=protected_sar_code[7]
Xsar_code_reg[9] DFFSX1 $PINS D=n764 CK=ZCTSNET_384 SN=HFSNET_380 Q=n2167
+ QN=protected_sar_code[9]
Xsar_code_reg[11] DFFSX1 $PINS D=n762 CK=ZCTSNET_384 SN=HFSNET_372 Q=n2164
+ QN=protected_sar_code[11]
Xsar_code_reg[2] DFFSX1 $PINS D=n771 CK=ZCTSNET_384 SN=HFSNET_372 Q=n2165
+ QN=protected_sar_code[2]
Xsar_code_reg[6] DFFSX1 $PINS D=n767 CK=ZCTSNET_384 SN=HFSNET_380 Q=n2168
+ QN=protected_sar_code[6]
Xsar_code_reg[10] DFFSX1 $PINS D=n763 CK=ZCTSNET_384 SN=HFSNET_380 Q=n2166
+ QN=protected_sar_code[10]
Xsar_code_reg[1] DFFSX1 $PINS D=n772 CK=ZCTSNET_384 SN=HFSNET_372 Q=n2186
+ QN=protected_sar_code[1]
Xsar_ptr_reg[0] DFFSX1 $PINS D=n791 CK=net1781 SN=HFSNET_380 Q=n2199
+ QN=sar_ptr[0]
Xsar_ptr_reg[1] DFFSXL $PINS D=n792 CK=net1781 SN=HFSNET_380 QN=sar_ptr[1]
Xsar_code_reg[3] DFFSX1 $PINS D=n770 CK=ZCTSNET_384 SN=HFSNET_372 Q=n2181
+ QN=protected_sar_code[3]
Xsar_code_reg[8] DFFSX1 $PINS D=n765 CK=ZCTSNET_384 SN=HFSNET_372 Q=n2183
+ QN=protected_sar_code[8]
Xsar_code_reg[14] DFFSXL $PINS D=n759 CK=ZCTSNET_384 SN=HFSNET_380 Q=n2184
+ QN=protected_sar_code[14]
Xavg_cnt_reg[4] DFFSXL $PINS D=n963 CK=net1771 SN=HFSNET_351 QN=avg_cnt[4]
Xavg_rounded_r_reg[13] DFFSXL $PINS D=n882 CK=net1821 SN=HFSNET_354
+ QN=avg_rounded_r[13]
Xavg_rounded_r_reg[8] DFFSXL $PINS D=n887 CK=net1821 SN=HFSNET_354
+ QN=avg_rounded_r[8]
Xshadow_weights_reg[2][4] DFFSXL $PINS D=HFSNET_336 CK=ZCTSNET_399
+ SN=HFSNET_360 QN=shadow_weights[2][4]
Xshadow_weights_reg[3][0] DFFSXL $PINS D=HFSNET_311 CK=ZCTSNET_400
+ SN=HFSNET_358 QN=shadow_weights[3][0]
Xshadow_weights_reg[7][9] DFFSXL $PINS D=n69 CK=ZCTSNET_404 SN=HFSNET_377
+ QN=shadow_weights[7][9]
Xshadow_weights_reg[10][6] DFFSXL $PINS D=HFSNET_339 CK=ZCTSNET_388
+ SN=HFSNET_360 QN=shadow_weights[10][6]
Xshadow_weights_reg[14][3] DFFSXL $PINS D=HFSNET_332 CK=ZCTSNET_392
+ SN=HFSNET_374 QN=shadow_weights[14][3]
Xshadow_weights_reg[0][11] DFFSXL $PINS D=gre_a_INV_1788_54 CK=net1660
+ SN=HFSNET_357 QN=shadow_weights[0][11]
Xshadow_weights_reg[5][7] DFFSXL $PINS D=HFSNET_341 CK=ZCTSNET_402
+ SN=HFSNET_378 QN=shadow_weights[5][7]
Xshadow_weights_reg[8][4] DFFSXL $PINS D=HFSNET_336 CK=net1701 SN=HFSNET_360
+ QN=shadow_weights[8][4]
Xshadow_weights_reg[12][1] DFFSXL $PINS D=HFSNET_317 CK=ZCTSNET_390
+ SN=HFSNET_378 QN=shadow_weights[12][1]
Xshadow_weights_reg[1][10] DFFSXL $PINS D=HFSNET_301 CK=ZCTSNET_398
+ SN=HFSNET_375 QN=shadow_weights[1][10]
Xshadow_weights_reg[9][6] DFFSXL $PINS D=HFSNET_339 CK=ZCTSNET_406
+ SN=HFSNET_376 QN=shadow_weights[9][6]
Xshadow_weights_reg[9][14] DFFSXL $PINS D=HFSNET_312 CK=ZCTSNET_406
+ SN=HFSNET_377 QN=shadow_weights[9][14]
Xshadow_weights_reg[12][13] DFFSXL $PINS D=gre_a_INV_1970_54 CK=ZCTSNET_390
+ SN=HFSNET_374 QN=shadow_weights[12][13]
Xshadow_weights_reg[12][12] DFFSXL $PINS D=gre_a_INV_1896_55 CK=ZCTSNET_390
+ SN=HFSNET_379 QN=shadow_weights[12][12]
Xwait_cnt_reg[2] DFFSXL $PINS D=n925 CK=ZCTSNET_384 SN=HFSNET_380
+ QN=wait_cnt[2]
Xshadow_weights_reg[2][29] DFFSXL $PINS D=HFSNET_323 CK=ZCTSNET_399
+ SN=HFSNET_369 QN=shadow_weights[2][29]
Xshadow_weights_reg[5][28] DFFSXL $PINS D=n2306 CK=ZCTSNET_402 SN=HFSNET_373
+ QN=shadow_weights[5][28]
Xshadow_weights_reg[7][27] DFFSXL $PINS D=n2305 CK=ZCTSNET_404 SN=HFSNET_373
+ QN=shadow_weights[7][27]
Xshadow_weights_reg[8][26] DFFSXL $PINS D=n71 CK=net1701 SN=HFSNET_366
+ QN=shadow_weights[8][26]
Xshadow_weights_reg[10][25] DFFSXL $PINS D=HFSNET_322 CK=ZCTSNET_388
+ SN=HFSNET_366 QN=shadow_weights[10][25]
Xshadow_weights_reg[13][24] DFFSXL $PINS D=HFSNET_321 CK=ZCTSNET_391
+ SN=HFSNET_370 QN=shadow_weights[13][24]
Xshadow_weights_reg[19][23] DFFSXL $PINS D=HFSNET_320 CK=ZCTSNET_397
+ SN=HFSNET_363 QN=shadow_weights[19][23]
Xaccumulator_reg[28] DFFSXL $PINS D=HFSNET_68 CK=net1771 SN=HFSNET_365
+ QN=accumulator[28]
Xshadow_weights_reg[2][22] DFFSXL $PINS D=HFSNET_319 CK=ZCTSNET_399
+ SN=HFSNET_367 QN=shadow_weights[2][22]
Xshadow_weights_reg[6][21] DFFSXL $PINS D=HFSNET_318 CK=ZCTSNET_403
+ SN=HFSNET_367 QN=shadow_weights[6][21]
Xshadow_weights_reg[9][20] DFFSXL $PINS D=n2299 CK=ZCTSNET_406 SN=HFSNET_374
+ QN=shadow_weights[9][20]
Xshadow_weights_reg[13][19] DFFSXL $PINS D=n2298 CK=ZCTSNET_391 SN=HFSNET_369
+ QN=shadow_weights[13][19]
Xshadow_weights_reg[19][18] DFFSXL $PINS D=HFSNET_316 CK=ZCTSNET_397
+ SN=HFSNET_369 QN=shadow_weights[19][18]
Xaccumulator_reg[23] DFFSXL $PINS D=HFSNET_11 CK=net1771 SN=HFSNET_354
+ QN=accumulator[23]
Xshadow_weights_reg[1][17] DFFSXL $PINS D=HFSNET_315 CK=ZCTSNET_398
+ SN=HFSNET_375 QN=shadow_weights[1][17]
Xshadow_weights_reg[3][16] DFFSXL $PINS D=HFSNET_314 CK=ZCTSNET_400
+ SN=HFSNET_373 QN=shadow_weights[3][16]
Xshadow_weights_reg[6][15] DFFSXL $PINS D=HFSNET_313 CK=ZCTSNET_403
+ SN=HFSNET_369 QN=shadow_weights[6][15]
Xmeas_val_p_reg[28] DFFSXL $PINS D=n895 CK=net1801 SN=HFSNET_351
+ QN=meas_val_p[28]
Xshadow_weights_reg[3][11] DFFSXL $PINS D=gre_a_INV_302_54 CK=ZCTSNET_400
+ SN=HFSNET_358 Q=shadow_weights[3][11]
Xstate_reg[1] DFFSX1 $PINS D=n816 CK=clk SN=HFSNET_371 Q=n67 QN=state[1]
Xsar_ptr_reg[4] DFFSXL $PINS D=n820 CK=net1781 SN=HFSNET_380 QN=sar_ptr[4]
Xsar_code_reg[16] DFFSX1 $PINS D=n757 CK=ZCTSNET_384 SN=HFSNET_380 Q=n2189
+ QN=protected_sar_code[16]
Xsar_code_reg[12] DFFSX1 $PINS D=n761 CK=ZCTSNET_384 SN=HFSNET_380 Q=n2187
+ QN=protected_sar_code[12]
Xsar_ptr_reg[3] DFFSXL $PINS D=n794 CK=net1781 SN=HFSNET_379 Q=n1 QN=sar_ptr[3]
XU3 OAI221XL $PINS A0=N1841 A1=overrange_bits[1] B0=n2138 B1=n2157 C0=n640
+ Y=n716
XU4 OAI221XL $PINS A0=N1842 A1=overrange_bits[0] B0=HFSNET_261 B1=n2157 C0=n640
+ Y=n717
XU5 OAI221XL $PINS A0=N1838 A1=overrange_bits[4] B0=HFSNET_253 B1=n2157 C0=n640
+ Y=n713
XU6 OAI221XL $PINS A0=N1840 A1=overrange_bits[2] B0=n2139 B1=n2157 C0=n640
+ Y=n715
XU7 OAI221XL $PINS A0=N1839 A1=overrange_bits[3] B0=HFSNET_275 B1=n2157 C0=n640
+ Y=n714
XU8 AND2X1 $PINS A=n1991 B=n1990 Y=n2009
XU9 OR2X1 $PINS A=n1989 B=n1988 Y=n1996
XU10 OAI21XL $PINS A0=n1693 A1=n2076 B0=n315 Y=n1696
XHFSINV_1604_607 INVX4 $PINS A=n55 Y=HFSNET_345
XU12 AOI21XL $PINS A0=n1552 A1=n1551 B0=n1550 Y=n1578
XU13 INVXL $PINS A=n829 Y=n559
XU14 NOR2X1 $PINS A=n665 B=n664 Y=N1823
XU16 INVXL $PINS A=N1822 Y=n815
XU17 NOR2XL $PINS A=sar_ptr[0] B=sar_ptr[1] Y=n2112
XU18 OAI21XL $PINS A0=n739 A1=n738 B0=n737 Y=n981
XU19 OAI21XL $PINS A0=n1113 A1=n1112 B0=n1111 Y=n1224
XU20 OAI21XL $PINS A0=n1839 A1=n1849 B0=n1840 Y=n1828
XU21 CLKINVX3 $PINS A=n1322 Y=n1687
XU23 OAI21XL $PINS A0=n547 A1=n551 B0=n552 Y=n492
XU24 OAI21XL $PINS A0=n218 A1=n101 B0=n100 Y=n110
XU25 OAI21XL $PINS A0=n449 A1=n447 B0=n450 Y=n467
XU26 OAI21XL $PINS A0=n159 A1=n215 B0=n160 Y=n145
XU27 OAI21XL $PINS A0=n524 A1=n532 B0=n525 Y=n591
XU28 OAI21XL $PINS A0=n111 A1=n155 B0=n112 Y=n103
XU29 OAI21XL $PINS A0=n337 A1=n336 B0=n335 Y=n359
XU30 INVXL $PINS A=n618 Y=n557
XU31 OAI21XL $PINS A0=n168 A1=n172 B0=n169 Y=n174
XU32 XOR2XL $PINS A=n218 B=n217 Y=n1904
XctmTdsLR_1_965 NAND2BXL $PINS AN=n218 B=n144 Y=tmp_net209
XU34 XNOR2XL $PINS A=n213 B=n212 Y=n1913
XU35 XNOR2XL $PINS A=n185 B=n184 Y=n1949
XU36 XNOR2XL $PINS A=n283 B=n270 Y=n272
XU37 XNOR2XL $PINS A=n264 B=n259 Y=n1716
XctmTdsLR_2_966 NAND2BXL $PINS AN=n145 B=tmp_net209 Y=n167
XU39 XOR2XL $PINS A=n1792 B=n1791 Y=n1796
XU40 XNOR2XL $PINS A=n1552 B=n1496 Y=n1497
XctmTdsLR_1_2030 XOR2X1 $PINS A=tmp_net208 B=tmp_net444 Y=n1021
XU42 OAI221XL $PINS A0=N1837 A1=overrange_bits[5] B0=HFSNET_273 B1=n2157
+ C0=n640 Y=n712
XU43 INVXL $PINS A=N1823 Y=n823
XHFSINV_10161_614 CLKINVX4 $PINS A=HFSNET_382 Y=HFSNET_352
XHFSINV_10018_615 INVX3 $PINS A=HFSNET_382 Y=HFSNET_353
XHFSINV_3239_610 INVX4 $PINS A=n1875 Y=HFSNET_348
XU47 NAND2XL $PINS A=n1556 B=HFSNET_347 Y=n930
XctmTdsLR_1_2010 OAI21XL $PINS A0=n1466 A1=n1414 B0=tmp_net433 Y=n1415
XU49 NAND2XL $PINS A=n1497 B=HFSNET_347 Y=n931
XU50 NAND2XL $PINS A=n1625 B=n1875 Y=n2339
XU51 XOR2X1 $PINS A=n1565 B=n1564 Y=n1567
XctmTdsLR_4_1929_roptpi_2088 AND2XL $PINS A=HFSNET_345 B=n2215 Y=tmp_net388
XU54 INVXL $PINS A=n276 Y=n277
XctmTdsLR_1_699 AOI22XL $PINS A0=n1662 A1=shadow_weights[9][26]
+ B0=gre_a_INV_6610_58 B1=shadow_weights[11][26] Y=tmp_net31
XctmTdsLR_1_1857_roptpi_2089 NAND2XL $PINS A=n813 B=n811 Y=tmp_net213
XctmTdsLR_1_1959 NAND3XL $PINS A=tmp_net191 B=n1036 C=tmp_net406 Y=HFSNET_132
XU58 XOR2X1 $PINS A=n1821 B=n1820 Y=n1826
XU59 NOR2XL $PINS A=n1716 B=gre_a_INV_2586_58 Y=n1717
XU60 OAI21XL $PINS A0=n1852 A1=n1781 B0=n1780 Y=n1807
XU61 NAND2XL $PINS A=n1499 B=n1388 Y=n1503
XU62 OAI21XL $PINS A0=n1762 A1=n1771 B0=n1763 Y=n1750
XU63 OAI21XL $PINS A0=n1508 A1=n1525 B0=n1509 Y=n1568
XU64 NAND2XL $PINS A=n1835 B=shadow_weights[18][15] Y=n1831
XU65 AOI211XL $PINS A0=HFSNET_345 A1=n2225 B0=n1845 C0=HFSNET_348 Y=n1846
XU66 NOR2XL $PINS A=HFSNET_155 B=temp_acc[27] Y=n1607
XU67 NAND2XL $PINS A=HFSNET_128 B=temp_acc[1] Y=n737
XU68 INVXL $PINS A=n2119 Y=n2122
XU69 INVXL $PINS A=n2093 Y=n2096
XU70 AOI211XL $PINS A0=HFSNET_345 A1=n2218 B0=n1854 C0=HFSNET_348 Y=n1855
XU71 AOI211XL $PINS A0=HFSNET_345 A1=n2226 B0=n1866 C0=HFSNET_348 Y=n1867
XU72 INVXL $PINS A=n1917 Y=n1930
XctmTdsLR_1_693 NAND2XL $PINS A=n440 B=HFSNET_347 Y=HFSNET_10
XU74 NOR2XL $PINS A=n1908 B=n1899 Y=n220
XU75 NAND2XL $PINS A=n1894 B=HFSNET_244 Y=n1890
XU76 AOI211XL $PINS A0=HFSNET_345 A1=n2216 B0=n1932 C0=HFSNET_348 Y=n1933
XHFSINV_9538_616 CLKINVX4 $PINS A=HFSNET_382 Y=HFSNET_354
XU78 OR2XL $PINS A=n1931 B=shadow_weights[18][5] Y=n1928
XHFSINV_8799_617 CLKINVX4 $PINS A=HFSNET_382 Y=HFSNET_355
XU80 INVXL $PINS A=n1626 Y=n1628
XctmTdsLR_3_2083_roptpi_2090 AND4XL $PINS A=tmp_net17 B=tmp_net19 C=tmp_net20
+ D=tmp_net18 Y=tmp_net470
XU82 NOR2XL $PINS A=n1949 B=shadow_weights[18][3] Y=n1944
XU83 NAND2XL $PINS A=n1875 B=n1985 Y=n2068
XHFSINV_7962_618 CLKINVX4 $PINS A=HFSNET_382 Y=HFSNET_356
XHFSINV_7345_619 CLKINVX8 $PINS A=HFSNET_382 Y=HFSNET_357
XU86 AOI21XL $PINS A0=n399 A1=n591 B0=n398 Y=n400
XHFSINV_2011_608 CLKINVX8 $PINS A=n292 Y=HFSNET_346
XU88 AOI22XL $PINS A0=gre_a_INV_5313_58 A1=protected_sar_code[12] B0=n1669
+ B1=protected_sar_code[8] Y=n1675_CDR2
XctmTdsLR_1_906 OAI2BB1XL $PINS A0N=n192 A1N=n200 B0=n190 Y=tmp_net170
XHFSINV_7499_620 CLKINVX8 $PINS A=HFSNET_382 Y=HFSNET_358
XHFSINV_7042_621 CLKINVX4 $PINS A=HFSNET_382 Y=HFSNET_359
XHFSINV_6657_622 INVX4 $PINS A=HFSNET_382 Y=HFSNET_360
XHFSINV_6844_623 CLKINVX8 $PINS A=HFSNET_382 Y=HFSNET_361
Xgre_a_INV_302_inst_2154 INVXL $PINS A=gre_a_INV_1788_54 Y=gre_a_INV_302_54
XU95 INVXL $PINS A=n581 Y=n582
XU96 INVXL $PINS A=n508 Y=n509
XU97 OR2XL $PINS A=n463 B=n462 Y=n510
XU98 NAND2XL $PINS A=n393 B=n392 Y=n525
XU99 INVXL $PINS A=n106 Y=n118
XU100 INVXL $PINS A=n140 Y=n90
XU101 INVXL $PINS A=n131 Y=n126
XU102 NAND2XL $PINS A=n371 B=n370 Y=n480
XHFSINV_6480_624 CLKINVX4 $PINS A=HFSNET_382 Y=HFSNET_362
XU104 OR2XL $PINS A=temp_acc[17] B=shadow_weights[17][17] Y=n128
XU105 NAND2XL $PINS A=temp_acc[19] B=shadow_weights[17][19] Y=n136
XU106 OR2XL $PINS A=temp_acc[20] B=shadow_weights[17][20] Y=n242
XU107 OR2XL $PINS A=temp_acc[24] B=shadow_weights[17][24] Y=n252
XU108 OR2XL $PINS A=temp_acc[22] B=shadow_weights[17][22] Y=n233
XU109 NAND2XL $PINS A=temp_acc[5] B=shadow_weights[17][5] Y=n194
XU110 NAND2XL $PINS A=temp_acc[18] B=shadow_weights[17][18] Y=n140
XU111 NOR2XL $PINS A=n2171 B=state[1] Y=n654
XU112 XOR2X1 $PINS A=n1495 B=n1147 Y=n1148
XU113 NOR2XL $PINS A=n293 B=gre_a_INV_2586_58 Y=n294
XU114 NOR2XL $PINS A=n272 B=gre_a_INV_2586_58 Y=n273
XU115 AOI21XL $PINS A0=n1800 A1=n1798 B0=n1787 Y=n1792
XU116 NOR2XL $PINS A=n1708 B=gre_a_INV_2586_58 Y=n1709
XU117 INVXL $PINS A=n1712 Y=n260
XU118 OAI21XL $PINS A0=n1423 A1=n1422 B0=n1421 Y=n1442
XU119 AOI211XL $PINS A0=HFSNET_345 A1=n2211 B0=n1726 C0=HFSNET_348 Y=n1727
XU120 AOI211XL $PINS A0=HFSNET_345 A1=n2212 B0=n1737 C0=HFSNET_348 Y=n1738
XU121 OAI21XL $PINS A0=n1780 A1=n229 B0=n228 Y=n230
XU122 NOR2XL $PINS A=n1233 B=n1422 Y=n1236
XU124 AOI211XL $PINS A0=HFSNET_345 A1=n2229 B0=n1836 C0=HFSNET_348 Y=n1837
XU125 OR2XL $PINS A=HFSNET_157 B=temp_acc[28] Y=n1632
XctmTdsLR_2_907 XNOR2X1 $PINS A=tmp_net170 B=n196 Y=n1931
XU127 INVXL $PINS A=n1760 Y=n1772
XU130 NOR2XL $PINS A=n1835 B=gre_a_INV_2586_58 Y=n1836
XU131 OAI21XL $PINS A0=n1426 A1=n1443 B0=n1427 Y=n1486
XU132 NOR2XL $PINS A=HFSNET_166 B=temp_acc[25] Y=n1530
XU133 NOR2XL $PINS A=HFSNET_171 B=temp_acc[12] Y=n1424
XU134 NOR2XL $PINS A=copt_gre_net_480 B=temp_acc[14] Y=n1490
XU135 OR2XL $PINS A=n2131 B=n2100 Y=n318
XU136 AOI211XL $PINS A0=HFSNET_345 A1=n2203 B0=n1794 C0=HFSNET_348 Y=n1795
XU137 AOI211XL $PINS A0=HFSNET_345 A1=n2231 B0=n1814 C0=HFSNET_348 Y=n1816
XU138 AOI211XL $PINS A0=HFSNET_345 A1=n2230 B0=n1914 C0=HFSNET_348 Y=n1915
XU139 AOI211XL $PINS A0=HFSNET_345 A1=n2227 B0=n1887 C0=HFSNET_348 Y=n1888
XU140 NOR2XL $PINS A=n1793 B=gre_a_INV_2586_58 Y=n1794
XU141 INVXL $PINS A=n1786 Y=n1798
XU142 AOI211XL $PINS A0=HFSNET_345 A1=n2232 B0=n1824 C0=HFSNET_348 Y=n1825
XU143 NOR2XL $PINS A=n1801 B=gre_a_INV_2586_58 Y=n1802
XU144 AOI211XL $PINS A0=HFSNET_345 A1=n2223 B0=n1905 C0=HFSNET_348 Y=n1906
XU145 NOR2XL $PINS A=n1823 B=gre_a_INV_2586_58 Y=n1824
XU146 NAND2XL $PINS A=n2099 B=sar_ptr[2] Y=n2110
XU147 NOR2XL $PINS A=n1886 B=gre_a_INV_2586_58 Y=n1887
XU148 OAI21XL $PINS A0=n521 A1=n520 B0=n519 Y=n531
XU149 NAND2XL $PINS A=n1656 B=n1982 Y=N1608
XHFSINV_6348_625 CLKINVX8 $PINS A=HFSNET_382 Y=HFSNET_363
XHFSINV_10702_626 CLKINVX4 $PINS A=HFSNET_382 Y=HFSNET_364
XHFSINV_1575_628 CLKINVX8 $PINS A=HFSNET_382 Y=HFSNET_366
XHFSINV_717_629 CLKINVX4 $PINS A=HFSNET_382 Y=HFSNET_367
XHFSINV_1073_630 CLKINVX8 $PINS A=HFSNET_382 Y=HFSNET_368
XHFSINV_907_631 CLKINVX8 $PINS A=HFSNET_382 Y=HFSNET_369
XHFSINV_555_632 CLKINVX8 $PINS A=HFSNET_382 Y=HFSNET_370
XHFSINV_4293_634 CLKINVX2 $PINS A=HFSNET_382 Y=HFSNET_372
XU158 AOI211XL $PINS A0=HFSNET_345 A1=n2221 B0=HFSNET_348 C0=n1966 Y=n1967
XU159 AOI211XL $PINS A0=HFSNET_345 A1=n2222 B0=HFSNET_348 C0=n1973 Y=n1975
XHFSINV_2284_635 CLKINVX8 $PINS A=HFSNET_382 Y=HFSNET_373
XU161 OR2XL $PINS A=n1939 B=shadow_weights[18][4] Y=n1936
XU162 CLKINVX2 $PINS A=n2118 Y=n2134
XHFSINV_2457_636 CLKINVX8 $PINS A=HFSNET_382 Y=HFSNET_374
XHFSINV_2739_637 CLKINVX4 $PINS A=HFSNET_382 Y=HFSNET_375
XHFSINV_2589_638 CLKINVX4 $PINS A=HFSNET_382 Y=HFSNET_376
XHFSINV_2970_639 CLKINVX8 $PINS A=HFSNET_382 Y=HFSNET_377
XHFSINV_3411_640 CLKINVX4 $PINS A=HFSNET_382 Y=HFSNET_378
XU168 OR2XL $PINS A=n1957 B=shadow_weights[18][2] Y=n1954
Xgre_a_INV_6610_inst_2186 CLKINVX8 $PINS A=n1305 Y=gre_a_INV_6610_58
XHFSINV_2119_641 CLKINVX8 $PINS A=HFSNET_382 Y=HFSNET_379
XU171 NAND2XL $PINS A=n579 B=wait_cnt[4] Y=n474
XU172 INVXL $PINS A=n2032 Y=n2012
XU173 AND2X1 $PINS A=n55 B=n2163 Y=n1735
XctmTdsLR_1_967 NAND2XL $PINS A=n126 B=n128 Y=tmp_net210
Xgre_a_INV_5313_inst_2188 CLKINVX8 $PINS A=n1301 Y=gre_a_INV_5313_58
XU177 INVX4 $PINS A=n1320 Y=n1290
Xropt_mt_inst_2191 BUFXL $PINS A=n1192_CDR1 Y=ropt_net_504
XU179 CLKINVX3 $PINS A=n1308 Y=n1278
XHFSINV_4670_642 CLKINVX4 $PINS A=HFSNET_382 Y=HFSNET_380
XctmTdsLR_1_648 NAND2BXL $PINS AN=HFSNET_285 B=n102 Y=tmp_net1
XctmTdsLR_2_649 NAND2BXL $PINS AN=n103 B=tmp_net1 Y=n119
XctmTdsLR_1_650 NAND2XL $PINS A=n2058 B=protected_sar_code[1] Y=tmp_net2
XctmTdsLR_2_651 OAI221XL $PINS A0=n2049 A1=n2181 B0=n2046 B1=n2183 C0=tmp_net2
+ Y=n2064_CDR2
Xgre_a_INV_6625_inst_2189 CLKINVX8 $PINS A=n993 Y=gre_a_INV_6625_58
XU186 INVXL $PINS A=n692 Y=n693
Xgre_a_INV_1788_inst_2155 INVX4 $PINS A=calc_result_r[11] Y=gre_a_INV_1788_54
XU188 NOR2XL $PINS A=n2073 B=n2031 Y=n2032
XU189 INVXL $PINS A=n811 Y=n812
XctmTdsLR_1_652 OAI211XL $PINS A0=HFSNET_127 A1=temp_acc[0] B0=n738 C0=n1875
+ Y=n2308
XctmTdsLR_1_653 AOI222XL $PINS A0=n1686 A1=shadow_weights[6][23] B0=n1687
+ B1=shadow_weights[2][23] C0=ZBUF_20020_1 C1=shadow_weights[0][23] Y=tmp_net3
Xgre_a_INV_6238_inst_2187 CLKINVX8 $PINS A=n1297 Y=gre_a_INV_6238_58
XHFSINV_1142_609 CLKINVX8 $PINS A=n322 Y=HFSNET_347
XU194 NOR2X1 $PINS A=n824 B=n2194 Y=n1081
XU195 INVXL $PINS A=n241 Y=n91
XU196 NOR2XL $PINS A=n718 B=n696 Y=n805
XU197 OR2XL $PINS A=n420 B=n419 Y=n434
XU198 INVXL $PINS A=n2112 Y=n2100
XU200 INVXL $PINS A=n261 Y=n262
XU201 NOR2XL $PINS A=n586 B=n585 Y=n643
XU202 NAND2BXL $PINS AN=wait_cnt[2] B=n1984 Y=n580
XU203 NOR2XL $PINS A=n513 B=n512 Y=n562
XU204 INVXL $PINS A=n250 Y=n251
XU205 INVXL $PINS A=n232 Y=n92
XctmTdsLR_2_654 NAND2XL $PINS A=n1319 B=shadow_weights[13][23] Y=tmp_net4
XctmTdsLR_3_655 NAND4XL $PINS A=tmp_net3 B=n1382_CDR2 C=n1379 D=tmp_net4
+ Y=HFSNET_161
XctmTdsLR_1_656 INVXL $PINS A=n550 Y=tmp_net5
XctmTdsLR_2_657 OAI21XL $PINS A0=tmp_net5 A1=n546 B0=n547 Y=tmp_net6
XctmTdsLR_1_1936 OAI21XL $PINS A0=n1893 A1=n1892 B0=tmp_net393 Y=n1897
XctmTdsLR_1_659 OAI2BB1XL $PINS A0N=n501 A1N=n550 B0=n499 Y=tmp_net7
XctmTdsLR_2_660 XNOR2X1 $PINS A=tmp_net7 B=n505 Y=n507
XctmTdsLR_1_661 NAND2BXL $PINS AN=n594 B=n590 Y=tmp_net8
XU214 NAND2XL $PINS A=n654 B=n297 Y=n968
XU215 NOR2XL $PINS A=target_bit[0] B=n2179 Y=n2006
XU216 NAND2XL $PINS A=temp_acc[22] B=shadow_weights[17][22] Y=n232
XU217 OR2XL $PINS A=n2198 B=accumulator[32] Y=n1551
XU218 NOR2XL $PINS A=temp_acc[19] B=shadow_weights[17][19] Y=n135
XU219 NAND2XL $PINS A=temp_acc[24] B=shadow_weights[17][24] Y=n250
XU220 NAND2XL $PINS A=temp_acc[20] B=shadow_weights[17][20] Y=n241
XU221 NAND2XL $PINS A=temp_acc[25] B=shadow_weights[17][25] Y=n256
XU222 OR2XL $PINS A=n2195 B=accumulator[30] Y=n1144
XU223 NOR2XL $PINS A=temp_acc[27] B=shadow_weights[17][27] Y=n268
XU224 NAND2XL $PINS A=temp_acc[21] B=shadow_weights[17][21] Y=n237
XU225 NAND2XL $PINS A=temp_acc[23] B=shadow_weights[17][23] Y=n95
XU226 OR2XL $PINS A=temp_acc[28] B=shadow_weights[17][28] Y=n282
XU227 NOR2XL $PINS A=temp_acc[21] B=shadow_weights[17][21] Y=n236
XctmTdsLR_2_662 NAND2BXL $PINS AN=n591 B=tmp_net8 Y=n604
XU229 NAND2XL $PINS A=n1575 B=n1875 Y=n2333
XU230 NAND2XL $PINS A=n1605 B=n1875 Y=n2338
XctmTdsLR_1_2067 AOI21XL $PINS A0=n1922 A1=n1921 B0=tmp_net463 Y=n1926
XU232 NAND2XL $PINS A=n1567 B=n1875 Y=n2323
XU233 NAND2XL $PINS A=n1528 B=n1875 Y=n2331
XU234 NAND2XL $PINS A=n1522 B=n1875 Y=n2330
XU235 NAND2XL $PINS A=n1492 B=n1875 Y=n2322
XU236 NAND2XL $PINS A=n1548 B=n1875 Y=n2337
XU237 NAND2XL $PINS A=n1513 B=n1875 Y=n2332
XU238 NAND2XL $PINS A=n1148 B=HFSNET_347 Y=n932
XU239 NAND2XL $PINS A=n1431 B=n1875 Y=n2321
XctmTdsLR_1_2044 OAI21XL $PINS A0=n1938 A1=n1937 B0=tmp_net451 Y=n1943
XU241 AOI21XL $PINS A0=n1570 A1=n1569 B0=n1568 Y=n1574
XU242 NAND2XL $PINS A=n1462 B=n1875 Y=n2334
XU243 NAND2XL $PINS A=n1455 B=n1875 Y=n2325
XU244 AOI21XL $PINS A0=n1560 A1=n1559 B0=n1558 Y=n1565
XctmTdsLR_2_939_roptpi_2091 AND2XL $PINS A=n1319 B=shadow_weights[13][6]
+ Y=tmp_net192
XU246 NAND2XL $PINS A=n1502 B=n1875 Y=n2329
XctmTdsLR_2_2068 NOR2XL $PINS A=n1922 B=n1921 Y=tmp_net463
XU248 NAND2XL $PINS A=n1484 B=n1875 Y=n2336
XctmTdsLR_1_2069 AOI21XL $PINS A0=n1574 A1=n1573 B0=tmp_net464 Y=n1575
XctmTdsLR_2_2045 NAND2XL $PINS A=n1938 B=n1937 Y=tmp_net451
XU251 NAND2XL $PINS A=n1446 B=n1875 Y=n2320
XU253 NAND2XL $PINS A=n1084 B=HFSNET_347 Y=n933
XU254 NAND2XL $PINS A=n1441 B=n1875 Y=n2319
XU255 NAND2XL $PINS A=n1415 B=n1875 Y=n2335
XctmTdsLR_1_1926 OR4XL $PINS A=tmp_net387 B=n1895 C=HFSNET_348 D=tmp_net388
+ Y=n914
XctmTdsLR_2_2070 NOR2XL $PINS A=n1574 B=n1573 Y=tmp_net464
XctmTdsLR_1_682 OAI2BB1XL $PINS A0N=n118 A1N=n119 B0=n116 Y=tmp_net22
XU261 NAND2XL $PINS A=n1132 B=n1875 Y=n2318
XU262 NAND2XL $PINS A=n1141 B=n1875 Y=n2315
XU263 NAND2XL $PINS A=n1420 B=n1875 Y=n2324
XctmTdsLR_1_980 NAND2BXL $PINS AN=n521 B=n466 Y=tmp_net217
XU265 XOR2XL $PINS A=n1531 B=n1483 Y=n1484
XU266 XNOR2XL $PINS A=n1715 B=n1714 Y=n1719
XZBUF_2_inst_2092 BUFXL $PINS A=tmp_net100 Y=ZBUF_2_0
XctmTdsLR_2_981 NAND2BXL $PINS AN=n467 B=tmp_net217 Y=n539
Xgre_a_INV_6_inst_2156 INVXL $PINS A=gre_a_INV_1970_54 Y=gre_a_INV_6_54
XU270 NAND2XL $PINS A=n1109 B=n1875 Y=n2317
XU271 XNOR2XL $PINS A=n1145 B=n1083 Y=n1084
XU272 XOR2XL $PINS A=n1489 B=n1445 Y=n1446
XctmTdsLR_2_2011 NAND2XL $PINS A=n1466 B=n1414 Y=tmp_net433
XctmTdsLR_2_968 OAI211XL $PINS A0=n125 A1=n89 B0=tmp_net210 C0=n127 Y=n143
XctmTdsLR_2_683 XNOR2X1 $PINS A=tmp_net22 B=n123 Y=n1835
XU277 AOI211XL $PINS A0=HFSNET_345 A1=n2209 B0=n1709 C0=HFSNET_348 Y=n1710
XctmTdsLR_1_1975 NAND2XL $PINS A=tmp_net414 B=n617 Y=tmp_net342
XU279 AOI21XL $PINS A0=HFSNET_293 A1=n1457 B0=n1456 Y=n1461
XU280 NAND2XL $PINS A=n1090 B=n1875 Y=n2314
XctmTdsLR_2_1927 NOR2XL $PINS A=n1897 B=HFSNET_346 Y=tmp_net387
XctmTdsLR_1_982 NAND2XL $PINS A=n492 B=n495 Y=tmp_net218
XctmTdsLR_2_2031 NOR2BX1 $PINS AN=n1052 B=n1054 Y=tmp_net444
XU284 XOR2XL $PINS A=n1082 B=n974 Y=n975
XU285 AOI21XL $PINS A0=n1466 A1=n1465 B0=n1464 Y=n1531
XctmTdsLR_1_2046 AOI21XL $PINS A0=tmp_net219 A1=tmp_net419 B0=tmp_net453 Y=n431
XU287 NAND2XL $PINS A=n1079 B=n1875 Y=n2316
XU288 NAND2XL $PINS A=n1021 B=n1875 Y=n2313
Xgre_a_INV_2893_inst_2182 INVX4 $PINS A=n729 Y=gre_a_INV_2893_58
XctmTdsLR_1_2012 OAI21XL $PINS A0=tmp_net21 A1=n1453 B0=tmp_net435 Y=n1455
XU291 XOR2XL $PINS A=n1135 B=n1089 Y=n1090
XctmTdsLR_1_2071 OAI21XL $PINS A0=n1560 A1=n1491 B0=tmp_net465 Y=n1492
XU293 NAND2XL $PINS A=n803 B=n1875 Y=n2311
XHFSINV_250_554 INVXL $PINS A=n1417 Y=HFSNET_293
XU295 NAND2XL $PINS A=n1713 B=n1712 Y=n1714
XctmTdsLR_1_969 MX2XL $PINS A=n725 B=n663 S0=comp_out_rr Y=HFSNET_117
XU297 XOR2XL $PINS A=n1423 B=n1078 Y=n1079
XctmTdsLR_1_970 AOI222XL $PINS A0=n1686 A1=shadow_weights[6][22] B0=n1687
+ B1=shadow_weights[2][22] C0=ZBUF_20020_1 C1=shadow_weights[0][22] Y=tmp_net211
XU299 XNOR2XL $PINS A=n1774 B=n1773 Y=n1778
XU300 AOI21XL $PINS A0=n1774 A1=n1751 B0=n1750 Y=n1755
XctmTdsLR_2_983 OAI211XL $PINS A0=n455 A1=n418 B0=tmp_net218 C0=n494 Y=n435
XU303 AOI211XL $PINS A0=HFSNET_345 A1=n2210 B0=n1717 C0=HFSNET_348 Y=n1718
XctmTdsLR_1_1916 OAI21XL $PINS A0=n1903 A1=n1902 B0=tmp_net383 Y=n1907
XU305 NAND2XL $PINS A=n1000 B=n1875 Y=n2312
XU306 NAND2XL $PINS A=n778 B=n1875 Y=n2310
XU307 XNOR2XL $PINS A=n1087 B=n999 Y=n1000
XctmTdsLR_2_971 NAND2XL $PINS A=n1319 B=shadow_weights[13][22] Y=tmp_net212
XU309 NAND2XL $PINS A=n1457 B=n1459 Y=n1398
XctmTdsLR_1_1737 AOI221XL $PINS A0=gre_a_INV_6625_58 A1=shadow_weights[15][15]
+ B0=ZBUF_20020_1 B1=shadow_weights[0][15] C0=tmp_net261 Y=tmp_net262
XU311 NAND2XL $PINS A=n691 B=n1875 Y=n2309
XctmTdsLR_1_1997 AOI21XL $PINS A0=HFSNET_285 A1=n157 B0=tmp_net427 Y=n1865
XctmTdsLR_1_848 NAND2XL $PINS A=gre_a_INV_2893_58 B=accumulator[6] Y=HFSNET_3
Xgre_a_INV_1970_inst_2157 CLKINVX8 $PINS A=calc_result_r[13]
+ Y=gre_a_INV_1970_54
XU316 XOR2XL $PINS A=n806 B=n720 Y=n721
XctmTdsLR_1_829 NOR2BXL $PINS AN=n733 B=n732 Y=n651
XctmTdsLR_1_832 AOI222XL $PINS A0=n1686 A1=shadow_weights[6][25] B0=n1687
+ B1=shadow_weights[2][25] C0=ZBUF_20020_1 C1=shadow_weights[0][25] Y=tmp_net123
XU322 XOR2XL $PINS A=n690 B=n738 Y=n691
XctmTdsLR_2_1917 NAND2XL $PINS A=tmp_net382 B=n1900 Y=n1902
XU324 INVXL $PINS A=n1504 Y=n1505
XctmTdsLR_2_1976 INVXL $PINS A=n631 Y=tmp_net414
Xgre_a_INV_6_inst_2158 INVXL $PINS A=gre_a_INV_1896_55 Y=gre_a_INV_6_55
XU327 NOR2XL $PINS A=n1725 B=gre_a_INV_2586_58 Y=n1726
XU328 AOI21XL $PINS A0=n1807 A1=n1819 B0=n1806 Y=n1812
XU329 INVXL $PINS A=n1503 Y=n1506
XctmTdsLR_2_1960 AOI21XL $PINS A0=gre_a_INV_6625_58 A1=shadow_weights[15][6]
+ B0=tmp_net192 Y=tmp_net406
XU332 NAND2XL $PINS A=n1002 B=n1053 Y=n999
XU334 NAND2XL $PINS A=n1449 B=n1447 Y=n1419
XU337 XOR2XL $PINS A=n644 B=n588 Y=n589
Xgre_a_INV_1896_inst_2159 INVX4 $PINS A=calc_result_r[12] Y=gre_a_INV_1896_55
XctmTdsLR_2_1727 AND4X2 $PINS A=n1209_CDR2 B=tmp_net252 C=tmp_net253
+ D=ZBUF_2_53 Y=tmp_net254
XU340 NAND2XL $PINS A=n1434 B=n1432 Y=n1131
XU343 INVXL $PINS A=n1224 Y=n1114
XctmTdsLR_1_1966 AOI21XL $PINS A0=n1582 A1=tmp_net409 B0=tmp_net410 Y=n1583
XU345 AOI211XL $PINS A0=HFSNET_345 A1=n2213 B0=n1746 C0=HFSNET_348 Y=n1747
XU347 XOR2XL $PINS A=n1852 B=n1851 Y=n1856
XctmTdsLR_3_972 NAND4X1 $PINS A=HFSNET_75 B=tmp_net211 C=tmp_net212 D=n1365
+ Y=HFSNET_165
XctmTdsLR_1_805 AOI21XL $PINS A0=n1779 A1=n1827 B0=n1828 Y=tmp_net106
XU354 NOR2XL $PINS A=n1736 B=gre_a_INV_2586_58 Y=n1737
XU355 NAND2XL $PINS A=n1086 B=n1058 Y=n1060
XU357 INVXL $PINS A=n981 Y=n779
XctmTdsLR_2_2072 NAND2XL $PINS A=n1560 B=n1491 Y=tmp_net465
XctmTdsLR_1_1889 NAND2X2 $PINS A=n573 B=n315 Y=n2133
XctmTdsLR_2_806 XOR2X1 $PINS A=tmp_net106 B=n1833 Y=n1838
XU368 NAND2XL $PINS A=n1586 B=n1584 Y=n1547
XU369 AOI21XL $PINS A0=n1783 A1=n227 B0=n226 Y=n228
XU372 NAND2XL $PINS A=n1572 B=n1571 Y=n1573
XctmTdsLR_2_1998 NOR2XL $PINS A=HFSNET_285 B=n157 Y=tmp_net427
XU375 NOR2XL $PINS A=n976 B=n979 Y=n982
XU377 INVXL $PINS A=n1463 Y=n1464
XU379 INVXL $PINS A=n1584 Y=n1585
XctmTdsLR_1_1740 NAND3XL $PINS A=n2178 B=n2158 C=target_bit[3] Y=n2024
XU383 NOR2XL $PINS A=n1745 B=gre_a_INV_2586_58 Y=n1746
XU386 NAND2XL $PINS A=n1465 B=n1463 Y=n1414
XU387 AOI211XL $PINS A0=HFSNET_345 A1=n2207 B0=n1757 C0=HFSNET_348 Y=n1758
XU388 NAND2XL $PINS A=n1753 B=n1751 Y=n247
Xgre_a_INV_8759_inst_2185 CLKINVX8 $PINS A=n1299 Y=gre_a_INV_8759_58
XU391 NAND2XL $PINS A=n1459 B=n1458 Y=n1460
XZBUF_2_inst_2097 BUFXL $PINS A=n1358_CDR2 Y=ZBUF_2_26
XctmTdsLR_1_684 AOI211XL $PINS A0=n732 A1=n733 B0=n735 C0=n731 Y=n822
XU396 INVXL $PINS A=n1418 Y=n1449
XU397 NAND2XL $PINS A=n1632 B=n1630 Y=n1624
XU398 NAND2XL $PINS A=n1753 B=n1752 Y=n1754
XU400 INVXL $PINS A=n1163 Y=n1434
XU402 XNOR2XL $PINS A=n584 B=n566 Y=n567
XctmTdsLR_1_2032 OAI21XL $PINS A0=n1512 A1=n1511 B0=tmp_net445 Y=n1513
XU405 INVXL $PINS A=n1022 Y=n1002
XctmTdsLR_2_1761 AND4X4 $PINS A=tmp_net67 B=tmp_net68 C=tmp_net65 D=tmp_net66
+ Y=tmp_net275
XctmTdsLR_2_833 NAND2XL $PINS A=n1319 B=shadow_weights[13][25] Y=tmp_net124
XU409 NAND2XL $PINS A=n1832 B=n1831 Y=n1833
XU410 NOR2XL $PINS A=n1756 B=gre_a_INV_2586_58 Y=n1757
XU413 AOI21XL $PINS A0=n2127 A1=n2134 B0=n2133 Y=n2126
XU414 OR2XL $PINS A=HFSNET_158 B=temp_acc[24] Y=n1465
XU415 NAND2XL $PINS A=HFSNET_158 B=temp_acc[24] Y=n1463
XU416 NAND2XL $PINS A=n1756 B=shadow_weights[18][22] Y=n1752
XU417 XOR2XL $PINS A=n563 B=n515 Y=n516
XU418 AOI21XL $PINS A0=n2130 A1=n2134 B0=n2133 Y=n2129
XU419 OR2XL $PINS A=HFSNET_161 B=temp_acc[23] Y=n1459
XU420 NAND2XL $PINS A=HFSNET_161 B=temp_acc[23] Y=n1458
XU421 NAND2XL $PINS A=HFSNET_136 B=temp_acc[11] Y=n1437
XU422 NAND2XL $PINS A=HFSNET_166 B=temp_acc[25] Y=n1529
XU423 NAND2XL $PINS A=HFSNET_165 B=temp_acc[22] Y=n1571
XU424 NAND2XL $PINS A=HFSNET_162 B=temp_acc[21] Y=n1509
XU425 XOR2XL $PINS A=n1912 B=n1911 Y=n1916
XU426 XOR2XL $PINS A=n609 B=n608 Y=n610
XU427 INVXL $PINS A=n1486 Y=n1487
XU428 NAND2XL $PINS A=ZBUF_24_19 B=temp_acc[26] Y=n1584
XU429 AOI21XL $PINS A0=n2124 A1=n2134 B0=n2133 Y=n2123
XU430 OR2XL $PINS A=ZBUF_24_19 B=temp_acc[26] Y=n1586
XU431 NAND2XL $PINS A=HFSNET_131 B=temp_acc[5] Y=n1052
XU433 NAND2XL $PINS A=HFSNET_157 B=temp_acc[28] Y=n1630
XU434 NAND2XL $PINS A=HFSNET_164 B=temp_acc[17] Y=n1451
XU435 NAND2XL $PINS A=HFSNET_133 B=temp_acc[7] Y=n1137
XU436 AOI21XL $PINS A0=n2121 A1=n2134 B0=n2133 Y=n2120
XU437 NAND2XL $PINS A=HFSNET_159 B=temp_acc[19] Y=n1518
XU438 AOI211X4 $PINS A0=n2070 A1=protected_sar_code[0] B0=n2069 C0=n2068
+ Y=n2071
XU439 INVXL $PINS A=n1485 Y=n1488
XU440 NAND2XL $PINS A=HFSNET_130 B=temp_acc[3] Y=n977
XU441 NAND2XL $PINS A=HFSNET_155 B=temp_acc[27] Y=n1606
XU442 NAND2XL $PINS A=n1772 B=n1771 Y=n1773
XU443 AOI21XL $PINS A0=n2095 A1=n2134 B0=n2133 Y=n2094
XU444 NAND2XL $PINS A=n1485 B=n1231 Y=n1233
XU445 AOI21XL $PINS A0=n1231 A1=n1486 B0=n1230 Y=n1232
XU446 AOI21XL $PINS A0=n2098 A1=n2134 B0=n2133 Y=n2097
XU448 NAND2XL $PINS A=HFSNET_134 B=temp_acc[9] Y=n1111
XU449 INVXL $PINS A=n1831 Y=n225
XU450 AOI211XL $PINS A0=HFSNET_345 A1=n2206 B0=n1768 C0=HFSNET_348 Y=n1769
XctmTdsLR_1_986 NAND2XL $PINS A=n975 B=HFSNET_347 Y=HFSNET_66
XctmTdsLR_1_987 OAI2BB1XL $PINS A0N=n1444 A1N=n1442 B0=n1443 Y=tmp_net220
XU455 NOR2XL $PINS A=n2128 B=n2122 Y=n2121
XctmTdsLR_1_849 NAND2XL $PINS A=gre_a_INV_2893_58 B=accumulator[11] Y=HFSNET_8
XctmTdsLR_1_912 AOI222XL $PINS A0=n1292 A1=shadow_weights[2][13] B0=n1291
+ B1=shadow_weights[13][13] C0=n1290 C1=shadow_weights[6][13] Y=tmp_net173
XU459 NOR2XL $PINS A=n2096 B=n2132 Y=n2098
XU460 AOI21XL $PINS A0=n2187 A1=n2114 B0=n2133 Y=n2113
XU461 AOI211XL $PINS A0=HFSNET_345 A1=n2204 B0=n1776 C0=HFSNET_348 Y=n1777
XU463 NAND2XL $PINS A=n222 B=n1859 Y=n224
XctmTdsLR_2_2013 NAND2XL $PINS A=tmp_net434 B=n1451 Y=n1453
XU465 NOR2XL $PINS A=n2096 B=n2128 Y=n2095
XctmTdsLR_2_2033 NAND2XL $PINS A=n1512 B=n1511 Y=tmp_net445
XctmTdsLR_2_913 OAI2BB1XL $PINS A0N=shadow_weights[0][13] A1N=ZBUF_20020_1
+ B0=tmp_net173 Y=tmp_net174
XU468 NAND2XL $PINS A=n1767 B=shadow_weights[18][21] Y=n1763
XU469 AOI31XL $PINS A0=n2067 A1=n2066_CDR2 A2=n2065_CDR2
+ B0=protected_sar_code[0] Y=n2069
XctmTdsLR_1_976 OAI2BB1XL $PINS A0N=n1434 A1N=n1435 B0=n1432 Y=tmp_net215
XU472 NOR2XL $PINS A=n2128 B=n2131 Y=n2130
XU473 AOI21XL $PINS A0=n2188 A1=n2117 B0=n2133 Y=n2116
XU474 AOI21XL $PINS A0=n222 A1=n1858 B0=n221 Y=n223
XU475 NOR2XL $PINS A=n1767 B=gre_a_INV_2586_58 Y=n1768
XU476 NOR2XL $PINS A=n2132 B=n2131 Y=n2136
XU477 INVXL $PINS A=n1557 Y=n1558
XU478 INVXL $PINS A=n1490 Y=n1559
XctmTdsLR_1_1853 CLKINVX8 $PINS A=tmp_net342 Y=ZBUF_20020_1
XU481 INVXL $PINS A=n1424 Y=n1444
XU482 NOR2XL $PINS A=n2125 B=n2131 Y=n2127
XU483 AOI21XL $PINS A0=n1930 A1=n1928 B0=n1918 Y=n1922
XU484 AOI21XL $PINS A0=n2191 A1=n2092 B0=n2133 Y=n2091
XU485 XNOR2XL $PINS A=n1930 B=n1929 Y=n1934
Xgre_a_INV_2586_inst_2181 CLKINVX8 $PINS A=n1735 Y=gre_a_INV_2586_58
XctmTdsLR_1_663 NAND2XL $PINS A=n1918 B=n1920 Y=tmp_net9
XU488 NAND2XL $PINS A=n1782 B=n227 Y=n229
XctmTdsLR_3_914 AOI21XL $PINS A0=gre_a_INV_6625_58 A1=shadow_weights[15][13]
+ B0=tmp_net174 Y=tmp_net175
XctmTdsLR_1_2034 OAI21XL $PINS A0=n1521 A1=n1520 B0=tmp_net446 Y=n1522
XctmTdsLR_2_1984 NOR2BXL $PINS AN=n427 B=n426 Y=tmp_net419
XctmTdsLR_1_978 OAI2BB1XL $PINS A0N=n1632 A1N=n1633 B0=n1630 Y=tmp_net216
XctmTdsLR_1_2073 AOI21XL $PINS A0=n1516 A1=n1501 B0=tmp_net467 Y=n1502
XU494 XNOR2XL $PINS A=n511 B=n464 Y=n465
XU495 AOI21XL $PINS A0=n604 A1=n603 B0=n602 Y=n609
XctmTdsLR_1_850 OR3XL $PINS A=n614 B=calc_cnt[3] C=calc_cnt[4] Y=n1210
XctmTdsLR_3_2014 INVXL $PINS A=n1450 Y=tmp_net434
XU498 AOI21XL $PINS A0=n2190 A1=n2090 B0=n2133 Y=n2089
XU499 NOR2XL $PINS A=n2132 B=n2122 Y=n2124
XU501 NAND2XL $PINS A=n1891 B=n1890 Y=n1892
XctmTdsLR_1_1890 AND4XL $PINS A=n1151_CDR2 B=ZBUF_2_46 C=n1159 D=tmp_net195
+ Y=tmp_net363
XU503 AOI21XL $PINS A0=n2081 A1=n2134 B0=n2133 Y=n2080
XctmTdsLR_1_1985 OAI21XL $PINS A0=n352 A1=n351 B0=tmp_net421 Y=n353
XU505 NAND2XL $PINS A=HFSNET_172 B=temp_acc[8] Y=n1112
XU506 NOR4BX1 $PINS AN=n1336_CDR2 B=n1335_CDR2 C=n1334_CDR2 D=HFSNET_53
+ Y=n1340_CDR2
XctmTdsLR_1_685 NAND2XL $PINS A=n422 B=HFSNET_347 Y=HFSNET_9
XU510 NAND2XL $PINS A=n2112 B=n2093 Y=n2090
XU512 NAND2XL $PINS A=n2093 B=n2115 Y=n2092
XU514 NOR4BX1 $PINS AN=n1350_CDR1 B=n1349_CDR1 C=n1348_CDR1 D=n1347_CDR1
+ Y=n1354_CDR1
XU515 NAND2XL $PINS A=HFSNET_173 B=temp_acc[15] Y=n1562
XU516 NAND2XL $PINS A=copt_gre_net_480 B=temp_acc[14] Y=n1557
XU517 NAND2XL $PINS A=HFSNET_171 B=temp_acc[12] Y=n1443
XU518 XOR2XL $PINS A=n594 B=n534 Y=n535
XU519 NOR4BX1 $PINS AN=n1378_CDR2 B=n1377_CDR2 C=n1376_CDR1 D=HFSNET_88
+ Y=n1382_CDR2
XU520 NAND2XL $PINS A=n1798 B=n1797 Y=n1799
XU521 XOR2XL $PINS A=n490 B=n489 Y=n491
XU522 NAND2XL $PINS A=HFSNET_168 B=temp_acc[13] Y=n1427
XU524 AOI21XL $PINS A0=n2083 A1=n2134 B0=n2133 Y=n2082
XU525 AOI211XL $PINS A0=HFSNET_345 A1=n2219 B0=n1876 C0=HFSNET_348 Y=n1877
XctmTdsLR_1_851 NAND2XL $PINS A=gre_a_INV_2893_58 B=accumulator[18] Y=HFSNET_2
XU527 AOI21XL $PINS A0=n2088 A1=n2134 B0=n2133 Y=n2087
XU528 AOI21XL $PINS A0=n2085 A1=n2134 B0=n2133 Y=n2084
XU530 NAND2XL $PINS A=n1819 B=n1818 Y=n1820
XU531 XOR2XL $PINS A=n461 B=n439 Y=n440
XU532 NAND2XL $PINS A=n2115 B=n2119 Y=n2117
XctmTdsLR_3_1728 AOI22XL $PINS A0=gre_a_INV_6238_58 A1=shadow_weights[1][15]
+ B0=n1266 B1=shadow_weights[3][15] Y=tmp_net252
XU535 NOR2XL $PINS A=n1844 B=gre_a_INV_2586_58 Y=n1845
XctmTdsLR_1_686 AOI222XL $PINS A0=n1290 A1=shadow_weights[6][3] B0=n1292
+ B1=shadow_weights[2][3] C0=ZBUF_20020_1 C1=shadow_weights[0][3] Y=tmp_net23
XU537 NAND4XL $PINS A=n1692_CDR2 B=n1691_CDR2 C=n1690_CDR2 D=n1689 Y=n1694
XU538 XOR2XL $PINS A=n544 B=n543 Y=n545
XU539 NOR4BX1 $PINS AN=n1618_CDR1 B=n1617_CDR1 C=n1616_CDR1 D=n1615_CDR2
+ Y=n1622_CDR2
XctmTdsLR_4_915 NAND2X1 $PINS A=ropt_net_504 B=tmp_net175 Y=HFSNET_168
XU542 NOR2XL $PINS A=n1775 B=gre_a_INV_2586_58 Y=n1776
XU543 AOI21XL $PINS A0=n2102 A1=n2134 B0=n2133 Y=n2101
XU544 NAND2XL $PINS A=n1844 B=shadow_weights[18][14] Y=n1840
XU545 AOI21XL $PINS A0=n2104 A1=n2134 B0=n2133 Y=n2103
XU546 NAND2XL $PINS A=n2112 B=n2119 Y=n2114
XU547 XOR2XL $PINS A=n497 B=n496 Y=n498
XU548 AOI21XL $PINS A0=n2109 A1=n2134 B0=n2133 Y=n2108
XctmTdsLR_2_1763 AOI211XL $PINS A0=HFSNET_342 A1=shadow_weights[7][29]
+ B0=tmp_net276 C0=tmp_net277 Y=tmp_net278
XU550 AOI21XL $PINS A0=n2106 A1=n2134 B0=n2133 Y=n2105
XU551 INVXL $PINS A=n1797 Y=n1787
XU552 OAI2BB1XL $PINS A0N=shadow_weights[1][6] A1N=gre_a_INV_6238_58
+ B0=n1025_CDR1 Y=n1030_CDR2
XU553 NAND2XL $PINS A=n1813 B=shadow_weights[18][17] Y=n1809
XZCTSBUF_207_1337 BUFX12 $PINS A=net1786 Y=ZCTSNET_384
XU555 OAI2BB1XL $PINS A0N=shadow_weights[7][1] A1N=HFSNET_342 B0=n674_CDR1
+ Y=n681_CDR1
XU556 NOR2XL $PINS A=n1874 B=gre_a_INV_2586_58 Y=n1876
XU557 AOI21XL $PINS A0=n244 A1=n242 B0=n91 Y=n240
XU558 NOR2XL $PINS A=n1813 B=gre_a_INV_2586_58 Y=n1814
XU559 NOR2XL $PINS A=n2125 B=n2086 Y=n2083
XU560 OAI2BB1XL $PINS A0N=shadow_weights[3][10] A1N=n1266 B0=n1118_CDR2
+ Y=n1123_CDR2
XU561 XOR2XL $PINS A=n1948 B=n1947 Y=n1952
XU562 INVXL $PINS A=n1818 Y=n1806
XU563 NOR2XL $PINS A=n2128 B=n2086 Y=n2085
XctmTdsLR_1_1891 NAND3XL $PINS A=ZBUF_2_38 B=ZBUF_2_18 C=tmp_net364
+ Y=HFSNET_131
XU565 NAND2XL $PINS A=n1865 B=HFSNET_226 Y=n1861
XU566 NOR2XL $PINS A=n2132 B=n2086 Y=n2088
XU567 OAI2BB1XL $PINS A0N=shadow_weights[12][27] A1N=gre_a_INV_5313_58
+ B0=n1590_CDR2 Y=n1595_CDR2
XU568 AOI21XL $PINS A0=n539 A1=n538 B0=n537 Y=n544
XU569 OAI2BB1XL $PINS A0N=shadow_weights[7][28] A1N=HFSNET_342 B0=n1611_CDR1
+ Y=n1616_CDR1
XU571 NOR2XL $PINS A=n2132 B=n2107 Y=n2109
XctmTdsLR_4_2015 NAND2XL $PINS A=tmp_net21 B=n1453 Y=tmp_net435
XU573 NOR2XL $PINS A=n2128 B=n2107 Y=n2106
XU574 INVXL $PINS A=n1879 Y=n1891
XctmTdsLR_2_1810 NOR2BXL $PINS AN=n1360_CDR2 B=tmp_net309 Y=tmp_net310
XctmTdsLR_2_808 NAND2XL $PINS A=HFSNET_342 B=shadow_weights[7][0] Y=tmp_net107
XU578 NOR2XL $PINS A=n2125 B=n2107 Y=n2104
XU579 AOI21XL $PINS A0=n550 A1=n493 B0=n492 Y=n497
XU580 NAND2XL $PINS A=n1793 B=shadow_weights[18][19] Y=n1789
XctmTdsLR_3_1764 INVXL $PINS A=n1634_CDR1 Y=tmp_net276
XU582 OAI2BB1XL $PINS A0N=shadow_weights[12][19] A1N=gre_a_INV_5313_58
+ B0=n1307_CDR2 Y=n1316_CDR2
XU583 XNOR2XL $PINS A=n435 B=n421 Y=n422
XU584 NOR2XL $PINS A=n2100 B=n2107 Y=n2102
XctmTdsLR_3_1811 NAND4XL $PINS A=n1359_CDR1 B=tmp_net307 C=ZBUF_2_26
+ D=tmp_net308 Y=tmp_net309
XctmTdsLR_1_1858 AOI221XL $PINS A0=gre_a_INV_6625_58 A1=shadow_weights[15][29]
+ B0=n1319 B1=shadow_weights[13][29] C0=tmp_net344 Y=tmp_net345
XU587 AOI21XL $PINS A0=n550 A1=n486 B0=n485 Y=n490
XctmTdsLR_2_687 OAI2BB1XL $PINS A0N=shadow_weights[15][3] A1N=gre_a_INV_6625_58
+ B0=tmp_net23 Y=tmp_net24
XctmTdsLR_1_1741 NAND3XL $PINS A=target_bit[1] B=n2178 C=target_bit[3] Y=n2030
XU590 INVXL $PINS A=n531 Y=n594
XctmTdsLR_2_1859 OAI2BB1XL $PINS A0N=shadow_weights[2][29] A1N=n1687
+ B0=tmp_net343 Y=tmp_net344
XU592 INVXL $PINS A=n1805 Y=n1819
XU593 OAI2BB1XL $PINS A0N=shadow_weights[9][20] A1N=n1662 B0=n1329_CDR2
+ Y=n1334_CDR2
XU595 NOR2XL $PINS A=n2100 B=n2086 Y=n2081
XctmTdsLR_4_1812 AOI22XL $PINS A0=gre_a_INV_6610_58 A1=shadow_weights[11][22]
+ B0=n1662 B1=shadow_weights[9][22] Y=tmp_net307
XctmTdsLR_3_1860 AOI22XL $PINS A0=n1686 A1=shadow_weights[6][29]
+ B0=ZBUF_20020_1 B1=shadow_weights[0][29] Y=tmp_net343
XU598 NOR2XL $PINS A=n1853 B=gre_a_INV_2586_58 Y=n1854
XctmTdsLR_2_1937 NAND2XL $PINS A=n1893 B=n1892 Y=tmp_net393
XU600 OAI2BB1XL $PINS A0N=shadow_weights[14][16] A1N=n1270 B0=n1239_CDR2
+ Y=n1244_CDR2
XctmTdsLR_1_916 NAND3XL $PINS A=n1253_CDR1 B=n1252_CDR2 C=n1261_CDR2
+ Y=tmp_net176
XctmTdsLR_2_917 NAND4XL $PINS A=tmp_net166 B=n1262 C=tmp_net165 D=n1251_CDR2
+ Y=tmp_net177
XU603 OAI2BB1XL $PINS A0N=shadow_weights[7][4] A1N=HFSNET_342 B0=n985_CDR1
+ Y=n990_CDR1
XU604 OAI2BB1XL $PINS A0N=shadow_weights[11][24] A1N=gre_a_INV_6610_58
+ B0=n1401_CDR2 Y=n1406_CDR2
XU605 NOR2XL $PINS A=n1865 B=gre_a_INV_2586_58 Y=n1866
XU606 OAI2BB1XL $PINS A0N=shadow_weights[11][21] A1N=gre_a_INV_6610_58
+ B0=n1343_CDR1 Y=n1348_CDR1
XU607 AOI211XL $PINS A0=HFSNET_345 A1=n2205 B0=n1802 C0=HFSNET_348 Y=n1803
XctmTdsLR_4_1729 NAND2X1 $PINS A=gre_a_INV_8759_58 B=shadow_weights[4][15]
+ Y=tmp_net253
XU609 OAI2BB1XL $PINS A0N=shadow_weights[11][23] A1N=gre_a_INV_6610_58
+ B0=n1371_CDR1 Y=n1376_CDR1
XctmTdsLR_4_1765 NAND4XL $PINS A=tmp_net94 B=n1640_CDR1 C=n1644_CDR2
+ D=tmp_net93 Y=tmp_net277
XctmTdsLR_2_2074 NAND2XL $PINS A=tmp_net466 B=n1514 Y=n1501
XctmTdsLR_1_852 NAND2XL $PINS A=gre_a_INV_2893_58 B=accumulator[12] Y=HFSNET_7
XctmTdsLR_1_1766 NOR3X2 $PINS A=tmp_net279 B=tmp_net280 C=tmp_net281
+ Y=tmp_net201
XU615 AOI21XL $PINS A0=n531 A1=n533 B0=n523 Y=n528
XU617 NOR2XL $PINS A=n1894 B=gre_a_INV_2586_58 Y=n1895
XU618 NAND2XL $PINS A=gre_a_INV_6625_58 B=shadow_weights[15][22] Y=n1365
XU619 INVXL $PINS A=n455 Y=n550
XctmTdsLR_2_1892 AOI222XL $PINS A0=n1671 A1=shadow_weights[18][5] B0=n1673
+ B1=shadow_weights[17][5] C0=n1281 C1=shadow_weights[19][5] Y=tmp_net364
XctmTdsLR_1_1861 NAND3XL $PINS A=ZBUF_2_39 B=tmp_net349 C=ZBUF_2_54
+ Y=HFSNET_134
XU623 NAND2XL $PINS A=gre_a_INV_6625_58 B=shadow_weights[15][0] Y=n632
XctmTdsLR_1_697 OAI2BB1XL $PINS A0N=n1772 A1N=n1774 B0=n1771 Y=tmp_net30
XU625 NAND2XL $PINS A=gre_a_INV_6625_58 B=shadow_weights[15][10] Y=n1126
XU626 NAND2XL $PINS A=gre_a_INV_6625_58 B=protected_sar_code[15] Y=n1689
XU627 NAND2XL $PINS A=gre_a_INV_6625_58 B=shadow_weights[15][23] Y=n1379
XU628 OR2XL $PINS A=n1697 B=n1696 Y=N1614
XU629 NAND2XL $PINS A=gre_a_INV_6625_58 B=shadow_weights[15][24] Y=n1409
XctmTdsLR_1_1893 OR4X1 $PINS A=tmp_net365 B=tmp_net331 C=tmp_net328
+ D=tmp_net366 Y=HFSNET_133
XU632 NOR4BX1 $PINS AN=n1202_CDR2 B=n1201_CDR2 C=n1200_CDR1 D=copt_gre_net_475
+ Y=n1206_CDR2
XctmTdsLR_3_1918 INVXL $PINS A=n1899 Y=tmp_net382
XU634 NAND2XL $PINS A=gre_a_INV_6625_58 B=shadow_weights[15][12] Y=n1175
XctmTdsLR_5_1813 NAND2XL $PINS A=gre_a_INV_6238_58 B=shadow_weights[1][22]
+ Y=tmp_net308
XU637 NAND2XL $PINS A=gre_a_INV_6625_58 B=shadow_weights[15][11] Y=n1159
XctmTdsLR_2_1967 XOR2X1 $PINS A=n2201 B=accumulator[34] Y=tmp_net409
XU639 NAND2XL $PINS A=n1801 B=shadow_weights[18][18] Y=n1797
XU640 AOI211XL $PINS A0=HFSNET_345 A1=n2224 B0=n1924 C0=HFSNET_348 Y=n1925
XctmTdsLR_4_1919 NAND2XL $PINS A=n1903 B=n1902 Y=tmp_net383
XU643 NAND2XL $PINS A=gre_a_INV_6625_58 B=shadow_weights[15][16] Y=n1247
XU644 NAND2XL $PINS A=n1886 B=shadow_weights[18][10] Y=n1882
XctmTdsLR_1_1920 OAI21XL $PINS A0=n1435 A1=n1131 B0=tmp_net384 Y=n1132
XU646 NAND2XL $PINS A=n1913 B=shadow_weights[18][7] Y=n1909
XU647 NOR2XL $PINS A=n1913 B=gre_a_INV_2586_58 Y=n1914
XctmTdsLR_2_1767 NAND4XL $PINS A=n632 B=ZBUF_2_36 C=tmp_net264 D=tmp_net159
+ Y=tmp_net279
XU650 INVXL $PINS A=n1927 Y=n1918
XctmTdsLR_2_1738 NAND2XL $PINS A=tmp_net255 B=tmp_net260 Y=tmp_net261
XU652 NAND2XL $PINS A=n1928 B=n1920 Y=n205
XctmTdsLR_2_1921 NAND2XL $PINS A=n1435 B=n1131 Y=tmp_net384
XctmTdsLR_1_1922 OAI21XL $PINS A0=n802 A1=n801 B0=tmp_net385 Y=n803
XctmTdsLR_3_1768 INVXL $PINS A=tmp_net265 Y=tmp_net280
XU656 NAND2XL $PINS A=gre_a_INV_6625_58 B=shadow_weights[15][20] Y=n1337
XctmTdsLR_2_1923 NAND2XL $PINS A=n802 B=n801 Y=tmp_net385
XU658 NAND2XL $PINS A=gre_a_INV_6625_58 B=shadow_weights[15][2] Y=n750
XctmTdsLR_2_1894 AND2XL $PINS A=ZBUF_20020_1 B=shadow_weights[0][7]
+ Y=tmp_net365
XctmTdsLR_2_1986 NAND2XL $PINS A=tmp_net420 B=n355 Y=n351
XU661 NAND2XL $PINS A=gre_a_INV_6625_58 B=shadow_weights[15][17] Y=n1262
XU662 NAND2XL $PINS A=gre_a_INV_6625_58 B=shadow_weights[15][27] Y=n1598
XU663 NAND2XL $PINS A=gre_a_INV_6625_58 B=shadow_weights[15][25] Y=n1477
XctmTdsLR_2_664 OAI211XL $PINS A0=n1917 A1=n205 B0=tmp_net9 C0=n1919 Y=n1898
XctmTdsLR_3_2075 INVXL $PINS A=n1515 Y=tmp_net466
XU666 AOI21XL $PINS A0=n110 A1=n156 B0=n109 Y=n115
XU667 NOR3XL $PINS A=state[0] B=state[3] C=n657 Y=n662
XctmTdsLR_3_1739 AOI222XL $PINS A0=n1291 A1=shadow_weights[13][15] B0=n1290
+ B1=shadow_weights[6][15] C0=n1292 C1=shadow_weights[2][15] Y=tmp_net260
XU669 AOI211XL $PINS A0=HFSNET_345 A1=n2220 B0=n1950 C0=HFSNET_348 Y=n1951
XU670 AOI21XL $PINS A0=n134 A1=n132 B0=n126 Y=n130
XU671 OAI2BB1XL $PINS A0N=shadow_weights[7][13] A1N=HFSNET_342 B0=n1181_CDR2
+ Y=n1186_CDR2
XU672 NOR2XL $PINS A=n1923 B=gre_a_INV_2586_58 Y=n1924
XU673 NAND2XL $PINS A=n1904 B=shadow_weights[18][8] Y=n1900
XctmTdsLR_5_1730 NAND2XL $PINS A=HFSNET_342 B=shadow_weights[7][15]
+ Y=tmp_net255
XU676 OAI2BB1XL $PINS A0N=shadow_weights[7][12] A1N=HFSNET_342 B0=n1167_CDR1
+ Y=n1172_CDR1
XctmTdsLR_2_1862 AOI211X1 $PINS A0=gre_a_INV_6625_58 A1=shadow_weights[15][9]
+ B0=tmp_net346 C0=tmp_net348 Y=tmp_net349
XU678 OAI2BB1XL $PINS A0N=shadow_weights[1][14] A1N=gre_a_INV_6238_58
+ B0=n1195_CDR1 Y=n1200_CDR1
XU679 NOR2XL $PINS A=n1904 B=gre_a_INV_2586_58 Y=n1905
XU680 AOI211XL $PINS A0=HFSNET_345 A1=n2228 B0=n1940 C0=HFSNET_348 Y=n1942
XU681 INVXL $PINS A=n1935 Y=n189
XU682 NAND4XL $PINS A=n968 B=n1658 C=n1657 D=n823 Y=N1485
XU683 AOI211XL $PINS A0=HFSNET_345 A1=n2217 B0=n1958 C0=HFSNET_348 Y=n1959
XU684 NAND2XL $PINS A=n1923 B=shadow_weights[18][6] Y=n1919
XU685 NAND2XL $PINS A=n1931 B=shadow_weights[18][5] Y=n1927
XctmTdsLR_2_1743 AOI222XL $PINS A0=n1278 A1=shadow_weights[8][8] B0=n1277
+ B1=shadow_weights[10][8] C0=n1279 C1=shadow_weights[16][8] Y=tmp_net263
XctmTdsLR_2_698 XNOR2X1 $PINS A=tmp_net30 B=n1765 Y=n1770
XctmTdsLR_1_1924 AOI21XL $PINS A0=n1461 A1=n1460 B0=tmp_net386 Y=n1462
XZBUF_2_inst_1615 BUFX1 $PINS A=tmp_net61 Y=ZBUF_2_12
XctmTdsLR_2_1925 NOR2XL $PINS A=n1461 B=n1460 Y=tmp_net386
XctmTdsLR_1_1930 OAI21XL $PINS A0=tmp_net6 A1=n554 B0=tmp_net390 Y=n556
XU692 NAND2XL $PINS A=n1370_CDR2 B=n1369_CDR2 Y=n1377_CDR2
XctmTdsLR_4_1769 NAND4XL $PINS A=tmp_net107 B=tmp_net266 C=n621 D=n615
+ Y=tmp_net281
XctmTdsLR_3_1863 OAI2BB1XL $PINS A0N=shadow_weights[0][9] A1N=ZBUF_20020_1
+ B0=tmp_net43 Y=tmp_net346
XctmTdsLR_1_1999 OAI21XL $PINS A0=n604 A1=n596 B0=tmp_net428 Y=n597
XctmTdsLR_2_1931 NAND2XL $PINS A=tmp_net6 B=n554 Y=tmp_net390
XctmTdsLR_3_706 AOI222XL $PINS A0=n1280 A1=shadow_weights[18][7] B0=n1282
+ B1=shadow_weights[17][7] C0=shadow_weights[19][7] C1=n1281 Y=tmp_net37
XU699 NAND2XL $PINS A=n1682_CDR2 B=n1681_CDR2 Y=n1683_CDR2
XU700 NAND2XL $PINS A=n1304_CDR2 B=n1303_CDR2 Y=n1317_CDR2
XctmTdsLR_1_926 AOI222XL $PINS A0=n1686 A1=shadow_weights[6][24] B0=n1687
+ B1=shadow_weights[2][24] C0=ZBUF_20020_1 C1=shadow_weights[0][24] Y=tmp_net183
XctmTdsLR_4_1864 NAND2XL $PINS A=n1093 B=tmp_net347 Y=tmp_net348
XctmTdsLR_5_1865 AOI222XL $PINS A0=n1319 A1=shadow_weights[13][9] B0=n1290
+ B1=shadow_weights[6][9] C0=n1292 C1=shadow_weights[2][9] Y=tmp_net347
XU704 AOI2BB2XL $PINS B0=n2078 B1=n2077 A0N=n2076 A1N=n2075 Y=n793
XctmTdsLR_1_853 NAND2BXL $PINS AN=n1821 B=n1782 Y=tmp_net132
Xgre_a_INV_2154_inst_2178 INVX4 $PINS A=n1416 Y=gre_a_INV_2154_58
XctmTdsLR_2_1715 OAI2BB1XL $PINS A0N=n165 A1N=n167 B0=n164 Y=tmp_net244
XctmTdsLR_2_927 NAND2XL $PINS A=n1319 B=shadow_weights[13][24] Y=tmp_net184
XctmTdsLR_3_928 NAND4XL $PINS A=tmp_net183 B=n1409 C=n1408_CDR2 D=tmp_net184
+ Y=tmp_net185
XctmTdsLR_4_929 OR4X1 $PINS A=n1406_CDR2 B=HFSNET_100 C=tmp_net185 D=n1407_CDR2
+ Y=HFSNET_158
XU711 AOI22XL $PINS A0=n1670 A1=protected_sar_code[16] B0=n1668
+ B1=protected_sar_code[10] Y=n1691_CDR2
XctmTdsLR_3_1895 OAI2BB1XL $PINS A0N=shadow_weights[15][7]
+ A1N=gre_a_INV_6625_58 B0=tmp_net155 Y=tmp_net366
XctmTdsLR_2_1815 NAND2XL $PINS A=ZBUF_2_20 B=n1063 Y=tmp_net311
XctmTdsLR_3_1816 OAI2BB1XL $PINS A0N=shadow_weights[7][8] A1N=HFSNET_342
+ B0=n1062_CDR1 Y=tmp_net312
XZBUF_17_inst_1710 BUFX1 $PINS A=N1827 Y=ZBUF_17_0
XctmTdsLR_4_1817 NAND3XL $PINS A=n1064 B=ZBUF_2_51 C=n1071_CDR2 Y=tmp_net313
XctmTdsLR_1_1932 AOI21XL $PINS A0=n1707 A1=n1706 B0=tmp_net392 Y=n1711
XctmTdsLR_2_854 NAND2BXL $PINS AN=n1783 B=tmp_net132 Y=n1800
XctmTdsLR_1_855 AOI222XL $PINS A0=n1290 A1=shadow_weights[6][8] B0=ZBUF_20020_1
+ B1=shadow_weights[0][8] C0=n1292 C1=shadow_weights[2][8] Y=tmp_net133
XctmTdsLR_3_672 AOI222XL $PINS A0=shadow_weights[18][15] A1=n1280 B0=n1282
+ B1=shadow_weights[17][15] C0=shadow_weights[19][15] C1=n1281 Y=tmp_net15
XctmTdsLR_1_733 OAI2BB1XL $PINS A0N=n1891 A1N=n1893 B0=n1890 Y=tmp_net54
XctmTdsLR_1_691 NAND2XL $PINS A=n1753 B=n1750 Y=tmp_net27
XctmTdsLR_2_734 XNOR2XL $PINS A=n1884 B=tmp_net54 Y=n1889
XU725 NAND2XL $PINS A=n1328_CDR2 B=n1327_CDR1 Y=n1335_CDR2
XU726 AOI22XL $PINS A0=n1671 A1=sar_code[18] B0=n1673 B1=sar_code[17]
+ Y=n1690_CDR2
XU727 NAND2XL $PINS A=n1400_CDR2 B=n1399_CDR2 Y=n1407_CDR2
XctmTdsLR_1_735 NAND2XL $PINS A=n1278 B=shadow_weights[8][4] Y=tmp_net55
XctmTdsLR_2_1933 NAND2XL $PINS A=tmp_net391 B=n1704 Y=n1706
XctmTdsLR_2_736 NAND2XL $PINS A=n1277 B=shadow_weights[10][4] Y=tmp_net56
XU732 NAND2XL $PINS A=n1117 B=n1116 Y=n1124
XZBUF_4201_inst_2101 CLKBUFX2 $PINS A=n2030 Y=ZBUF_4201_28
XctmTdsLR_1_1744 NAND2XL $PINS A=ZBUF_20020_1 B=shadow_weights[0][0]
+ Y=tmp_net264
XctmTdsLR_1_1896 OAI2BB1XL $PINS A0N=shadow_weights[0][2] A1N=ZBUF_20020_1
+ B0=tmp_net368 Y=HFSNET_129
XctmTdsLR_1_930 NAND2XL $PINS A=n721 B=HFSNET_347 Y=HFSNET_68
XctmTdsLR_3_1934 INVXL $PINS A=n1703 Y=tmp_net391
XctmTdsLR_4_1935 NOR2XL $PINS A=n1707 B=n1706 Y=tmp_net392
XU739 NAND2XL $PINS A=n1939 B=shadow_weights[18][4] Y=n1935
XU740 NAND2XL $PINS A=n1024_CDR1 B=n1023_CDR2 Y=n1031_CDR2
XZCTSBUF_255_1341 CLKBUFX8 $PINS A=net1711 Y=ZCTSNET_388
XctmTdsLR_1_1938 OAI21XL $PINS A0=n1864 A1=n1863 B0=tmp_net395 Y=n1868
XctmTdsLR_3_737 AOI222XL $PINS A0=n1280 A1=shadow_weights[18][4] B0=n1282
+ B1=shadow_weights[17][4] C0=shadow_weights[19][4] C1=n1281 Y=tmp_net57
XctmTdsLR_3_1868 NAND3BXL $PINS AN=n681_CDR1 B=tmp_net286 C=n683_CDR1
+ Y=tmp_net350
XU746 INVXL $PINS A=n376 Y=n443
XctmTdsLR_2_1897 NOR4BBXL $PINS AN=tmp_net367 BN=n750 C=tmp_net321
+ D=copt_gre_net_482 Y=tmp_net368
XctmTdsLR_2_1745 AOI222XL $PINS A0=gre_a_INV_8759_58 A1=shadow_weights[4][0]
+ B0=gre_a_INV_5313_58 B1=shadow_weights[12][0] C0=n1292 C1=shadow_weights[2][0]
+ Y=tmp_net265
XctmTdsLR_1_840 NAND2XL $PINS A=n589 B=HFSNET_347 Y=HFSNET_70
XctmTdsLR_2_1939 NAND2XL $PINS A=tmp_net394 B=n1861 Y=n1863
XctmTdsLR_2_813 AOI222XL $PINS A0=HFSNET_342 A1=shadow_weights[7][5] B0=n1266
+ B1=shadow_weights[3][5] C0=gre_a_INV_6238_58 C1=shadow_weights[1][5]
+ Y=tmp_net111
XctmTdsLR_2_1819 NOR3XL $PINS A=tmp_net293 B=tmp_net271 C=tmp_net316
+ Y=tmp_net317
XctmTdsLR_3_1820 NAND3XL $PINS A=tmp_net314 B=tmp_net315 C=n1008_CDR1
+ Y=tmp_net316
XctmTdsLR_3_1940 INVXL $PINS A=n1860 Y=tmp_net394
XctmTdsLR_4_738 NAND2XL $PINS A=n1279 B=shadow_weights[16][4] Y=tmp_net58
XctmTdsLR_2_856 OAI2BB1XL $PINS A0N=shadow_weights[13][8] A1N=n1319
+ B0=tmp_net133 Y=tmp_net134
XU759 INVXL $PINS A=n1953 Y=n177
XU760 NAND2XL $PINS A=n984 B=n983_CDR1 Y=n991_CDR1
XctmTdsLR_1_938 AOI222X1 $PINS A0=n1290 A1=shadow_weights[6][6] B0=n1292
+ B1=shadow_weights[2][6] C0=ZBUF_20020_1 C1=shadow_weights[0][6] Y=tmp_net191
XctmTdsLR_4_1821 NAND2X1 $PINS A=gre_a_INV_5313_58 B=shadow_weights[12][5]
+ Y=tmp_net314
XU763 NAND2XL $PINS A=n1949 B=shadow_weights[18][3] Y=n1945
XctmTdsLR_3_1898 AOI222XL $PINS A0=n1290 A1=shadow_weights[6][2] B0=n1687
+ B1=shadow_weights[2][2] C0=n1319 C1=shadow_weights[13][2] Y=tmp_net367
XctmTdsLR_1_675 NAND2XL $PINS A=n1278 B=shadow_weights[8][16] Y=tmp_net17
XctmTdsLR_5_1822 NAND2XL $PINS A=gre_a_INV_8759_58 B=shadow_weights[4][5]
+ Y=tmp_net315
XctmTdsLR_1_1899 NAND3XL $PINS A=tmp_net369 B=tmp_net370 C=tmp_net373
+ Y=HFSNET_128
XU769 NAND2XL $PINS A=n1238_CDR2 B=n1237_CDR1 Y=n1245_CDR2
XctmTdsLR_3_1968 NOR2XL $PINS A=n1582 B=tmp_net409 Y=tmp_net410
XU771 NAND3XL $PINS A=n1676_CDR2 B=n1675_CDR2 C=n1674_CDR2 Y=n1684_CDR2
XctmTdsLR_2_676 NAND2XL $PINS A=n1277 B=shadow_weights[10][16] Y=tmp_net18
XctmTdsLR_3_677 AOI222XL $PINS A0=n1280 A1=shadow_weights[18][16] B0=n1282
+ B1=shadow_weights[17][16] C0=shadow_weights[19][16] C1=n1281 Y=tmp_net19
XctmTdsLR_4_678 NAND2XL $PINS A=n1279 B=shadow_weights[16][16] Y=tmp_net20
XZBUF_2_inst_2103 BUFXL $PINS A=n1635_CDR2 Y=ZBUF_2_30
XU776 AOI22XL $PINS A0=HFSNET_342 A1=shadow_weights[7][10] B0=gre_a_INV_6238_58
+ B1=shadow_weights[1][10] Y=n1125_CDR2
XctmTdsLR_1_941 AOI222XL $PINS A0=n1291 A1=shadow_weights[13][10] B0=n1290
+ B1=shadow_weights[6][10] C0=n1292 C1=shadow_weights[2][10] Y=tmp_net193
XU778 AOI22XL $PINS A0=n1660 A1=shadow_weights[3][25] B0=gre_a_INV_6238_58
+ B1=shadow_weights[1][25] Y=n1476_CDR1
XU779 AOI22XL $PINS A0=gre_a_INV_5313_58 A1=shadow_weights[12][25] B0=n1679
+ B1=shadow_weights[14][25] Y=n1467_CDR2
XctmTdsLR_2_1824 OAI2BB1XL $PINS A0N=shadow_weights[7][2] A1N=HFSNET_342
+ B0=copt_gre_net_474 Y=tmp_net318
XU781 AOI22XL $PINS A0=n1677 A1=shadow_weights[5][25] B0=gre_a_INV_8759_58
+ B1=shadow_weights[4][25] Y=n1468_CDR2
XU782 AOI22XL $PINS A0=gre_a_INV_8759_58 A1=shadow_weights[4][19] B0=n1660
+ B1=shadow_weights[3][19] Y=n1318_CDR2
XU783 AOI22XL $PINS A0=n1266 A1=shadow_weights[3][17] B0=gre_a_INV_6610_58
+ B1=shadow_weights[11][17] Y=n1261_CDR2
XU784 AOI22XL $PINS A0=n1668 A1=shadow_weights[10][25] B0=n1672
+ B1=shadow_weights[19][25] Y=n1472_CDR2
XctmTdsLR_3_1825 NAND4XL $PINS A=tmp_net319 B=ZBUF_2_31 C=tmp_net320
+ D=copt_gre_net_476 Y=tmp_net321
XctmTdsLR_2_942 NAND2XL $PINS A=ZBUF_20020_1 B=shadow_weights[0][10]
+ Y=tmp_net194
XU787 AOI22XL $PINS A0=gre_a_INV_6238_58 A1=shadow_weights[1][21] B0=n1660
+ B1=shadow_weights[3][21] Y=n1350_CDR1
XU788 AOI22XL $PINS A0=n1668 A1=shadow_weights[10][23] B0=n1669
+ B1=shadow_weights[8][23] Y=n1374_CDR1
XctmTdsLR_1_1731 OR4XL $PINS A=tmp_net251 B=tmp_net24 C=ZBUF_2_33 D=tmp_net258
+ Y=HFSNET_130
XctmTdsLR_4_1826 AOI22XL $PINS A0=n1266 A1=shadow_weights[3][2]
+ B0=gre_a_INV_5313_58 B1=shadow_weights[12][2] Y=tmp_net319
XctmTdsLR_5_1827 NAND2XL $PINS A=gre_a_INV_6238_58 B=shadow_weights[1][2]
+ Y=tmp_net320
XU792 AOI22XL $PINS A0=gre_a_INV_5313_58 A1=shadow_weights[12][10] B0=n1270
+ B1=shadow_weights[14][10] Y=n1116
XctmTdsLR_4_1941 NAND2XL $PINS A=n1864 B=n1863 Y=tmp_net395
XctmTdsLR_1_1942 AOI21XL $PINS A0=n1812 A1=n1811 B0=tmp_net397 Y=n1817
XctmTdsLR_3_943 NAND4X1 $PINS A=tmp_net194 B=n1129_CDR1 C=n1126 D=tmp_net193
+ Y=HFSNET_135
XctmTdsLR_3_1871 NAND3BXL $PINS AN=tmp_net318 B=ZBUF_2_32 C=n742_CDR1
+ Y=tmp_net352
XU797 AOI22XL $PINS A0=gre_a_INV_8759_58 A1=shadow_weights[4][23] B0=HFSNET_342
+ B1=shadow_weights[7][23] Y=n1369_CDR2
XU798 AOI22XL $PINS A0=n1660 A1=shadow_weights[3][23] B0=gre_a_INV_5313_58
+ B1=shadow_weights[12][23] Y=n1378_CDR2
XU799 AOI22X1 $PINS A0=n1679 A1=shadow_weights[14][23] B0=n1677
+ B1=shadow_weights[5][23] Y=n1370_CDR2
XctmTdsLR_2_1900 NAND2XL $PINS A=ZBUF_20020_1 B=shadow_weights[0][1]
+ Y=tmp_net369
XU801 AOI22X1 $PINS A0=n1266 A1=shadow_weights[3][3] B0=gre_a_INV_6238_58
+ B1=shadow_weights[1][3] Y=n789_CDR1
XctmTdsLR_2_692 OAI211XL $PINS A0=n1749 A1=n247 B0=tmp_net27 C0=n1752 Y=n1729
XctmTdsLR_2_1943 NAND2XL $PINS A=tmp_net396 B=n1809 Y=n1811
XU804 AOI22XL $PINS A0=n1669 A1=shadow_weights[8][26] B0=n1668
+ B1=shadow_weights[10][26] Y=n1537_CDR1
XctmTdsLR_1_820 AOI22XL $PINS A0=n1670 A1=shadow_weights[16][24] B0=n1673
+ B1=shadow_weights[17][24] Y=tmp_net117
XctmTdsLR_3_1944 INVXL $PINS A=n1808 Y=tmp_net396
XU808 AOI22XL $PINS A0=n1270 A1=shadow_weights[14][3] B0=gre_a_INV_5313_58
+ B1=shadow_weights[12][3] Y=n781_CDR2
XctmTdsLR_1_944 AOI222XL $PINS A0=n1291 A1=shadow_weights[13][11] B0=n1290
+ B1=shadow_weights[6][11] C0=n1292 C1=shadow_weights[2][11] Y=tmp_net195
XU810 NAND2XL $PINS A=n1957 B=shadow_weights[18][2] Y=n1953
XU811 AOI22XL $PINS A0=n1662 A1=shadow_weights[9][19] B0=gre_a_INV_6238_58
+ B1=shadow_weights[1][19] Y=n1304_CDR2
XU812 NAND2XL $PINS A=n1965 B=shadow_weights[18][1] Y=n1962
XU813 AOI22XL $PINS A0=gre_a_INV_8759_58 A1=shadow_weights[4][3] B0=n1268
+ B1=shadow_weights[5][3] Y=n780_CDR2
XU814 AOI22XL $PINS A0=n1268 A1=shadow_weights[5][17] B0=gre_a_INV_8759_58
+ B1=shadow_weights[4][17] Y=n1252_CDR2
XctmTdsLR_3_1874 NAND3BXL $PINS AN=n990_CDR1 B=tmp_net288 C=n992_CDR2
+ Y=tmp_net354
XU816 AOI22XL $PINS A0=gre_a_INV_8759_58 A1=shadow_weights[4][11] B0=n1268
+ B1=shadow_weights[5][11] Y=n1150_CDR1
XctmTdsLR_2_1829 NOR3XL $PINS A=tmp_net324 B=tmp_net325 C=tmp_net272
+ Y=tmp_net326
XU818 AOI22XL $PINS A0=n1270 A1=shadow_weights[14][4] B0=gre_a_INV_5313_58
+ B1=shadow_weights[12][4] Y=n983_CDR1
XctmTdsLR_2_821 AOI22XL $PINS A0=n1671 A1=shadow_weights[18][24] B0=n1672
+ B1=shadow_weights[19][24] Y=tmp_net118
XU820 AOI22XL $PINS A0=gre_a_INV_5313_58 A1=shadow_weights[12][20]
+ B0=gre_a_INV_6238_58 B1=shadow_weights[1][20] Y=n1328_CDR2
XU821 AOI22XL $PINS A0=n1278 A1=shadow_weights[8][3] B0=n1277
+ B1=shadow_weights[10][3] Y=n785_CDR1
XU822 AOI22XL $PINS A0=gre_a_INV_8759_58 A1=shadow_weights[4][4] B0=n1268
+ B1=shadow_weights[5][4] Y=n984
XctmTdsLR_3_1830 NAND4XL $PINS A=tmp_net322 B=tmp_net323 C=n1537_CDR1
+ D=n1535_CDR2 Y=tmp_net324
XU824 AOI22XL $PINS A0=HFSNET_342 A1=shadow_weights[7][20] B0=gre_a_INV_6610_58
+ B1=shadow_weights[11][20] Y=n1336_CDR2
XctmTdsLR_3_822 NAND3XL $PINS A=n1404_CDR1 B=tmp_net117 C=tmp_net118
+ Y=HFSNET_100
XU827 AOI22XL $PINS A0=n1668 A1=shadow_weights[10][24] B0=n1669
+ B1=shadow_weights[8][24] Y=n1404_CDR1
XU828 AOI22XL $PINS A0=gre_a_INV_6238_58 A1=shadow_weights[1][27] B0=n1660
+ B1=shadow_weights[3][27] Y=n1597_CDR2
XU829 AOI22XL $PINS A0=gre_a_INV_6238_58 A1=shadow_weights[1][4] B0=n1266
+ B1=shadow_weights[3][4] Y=n992_CDR2
XU830 AOI22XL $PINS A0=n1270 A1=shadow_weights[14][11] B0=gre_a_INV_5313_58
+ B1=shadow_weights[12][11] Y=n1149_CDR1
XU831 AOI22XL $PINS A0=n1278 A1=shadow_weights[8][5] B0=n1277
+ B1=shadow_weights[10][5] Y=n1008_CDR1
XU832 AOI22XL $PINS A0=n1660 A1=shadow_weights[3][24] B0=n1662
+ B1=shadow_weights[9][24] Y=n1408_CDR2
XU833 AOI22X1 $PINS A0=gre_a_INV_5313_58 A1=shadow_weights[12][17] B0=n1270
+ B1=shadow_weights[14][17] Y=n1251_CDR2
XctmTdsLR_4_1831 AOI222XL $PINS A0=n1671 A1=HFSNET_241 B0=n1673
+ B1=shadow_weights[17][26] C0=gre_a_INV_5313_58 C1=shadow_weights[12][26]
+ Y=tmp_net322
XU835 AOI22XL $PINS A0=n1268 A1=shadow_weights[5][10] B0=gre_a_INV_8759_58
+ B1=shadow_weights[4][10] Y=n1117
XU836 AOI22XL $PINS A0=gre_a_INV_8759_58 A1=shadow_weights[4][24] B0=n1679
+ B1=shadow_weights[14][24] Y=n1400_CDR2
XU837 AOI22XL $PINS A0=n1677 A1=shadow_weights[5][24] B0=gre_a_INV_6238_58
+ B1=shadow_weights[1][24] Y=n1399_CDR2
XctmTdsLR_4_1945 NOR2XL $PINS A=n1812 B=n1811 Y=tmp_net397
XU839 AOI22XL $PINS A0=n1270 A1=shadow_weights[14][6] B0=n1268
+ B1=shadow_weights[5][6] Y=n1023_CDR2
XU840 AOI22XL $PINS A0=gre_a_INV_8759_58 A1=shadow_weights[4][6]
+ B0=gre_a_INV_5313_58 B1=shadow_weights[12][6] Y=n1024_CDR1
XZCTSBUF_251_1342 BUFX12 $PINS A=net1716 Y=ZCTSNET_389
XU842 AOI22XL $PINS A0=gre_a_INV_6238_58 A1=shadow_weights[1][16] B0=HFSNET_342
+ B1=shadow_weights[7][16] Y=n1246_CDR2
XU843 AOI22X1 $PINS A0=n1277 A1=shadow_weights[10][18] B0=n1278
+ B1=shadow_weights[8][18] Y=n1285_CDR1
XU844 AOI22XL $PINS A0=HFSNET_342 A1=shadow_weights[7][6] B0=n1266
+ B1=shadow_weights[3][6] Y=n1032_CDR2
XctmTdsLR_5_1832 NAND2XL $PINS A=n1679 B=shadow_weights[14][26] Y=tmp_net323
XU846 AOI22X1 $PINS A0=n1266 A1=shadow_weights[3][16] B0=gre_a_INV_8759_58
+ B1=shadow_weights[4][16] Y=n1238_CDR2
XU847 AOI22XL $PINS A0=gre_a_INV_5313_58 A1=shadow_weights[12][18] B0=n1268
+ B1=shadow_weights[5][18] Y=n1272_CDR1
XctmTdsLR_2_945 NAND2XL $PINS A=ZBUF_20020_1 B=shadow_weights[0][11]
+ Y=tmp_net196
XU849 AOI22XL $PINS A0=gre_a_INV_8759_58 A1=shadow_weights[4][18] B0=n1270
+ B1=shadow_weights[14][18] Y=n1273_CDR2
XctmTdsLR_3_742 AOI222XL $PINS A0=HFSNET_225 A1=n1280 B0=shadow_weights[19][11]
+ B1=n1281 C0=n1282 C1=shadow_weights[17][11] Y=tmp_net61
XctmTdsLR_1_1946 AOI21XL $PINS A0=n240 A1=n239 B0=tmp_net399 Y=n1767
XZCTSBUF_247_1343 BUFX8 $PINS A=net1721 Y=ZCTSNET_390
XctmTdsLR_3_946 NAND4X1 $PINS A=tmp_net196 B=tmp_net363 C=tmp_net333
+ D=ZBUF_2_12 Y=HFSNET_136
XU855 AOI22XL $PINS A0=gre_a_INV_5313_58 A1=shadow_weights[12][16] B0=n1268
+ B1=shadow_weights[5][16] Y=n1237_CDR1
XU856 AOI22XL $PINS A0=n1270 A1=shadow_weights[14][9] B0=gre_a_INV_5313_58
+ B1=shadow_weights[12][9] Y=n1091
XctmTdsLR_3_1901 INVXL $PINS A=tmp_net350 Y=tmp_net370
XU858 AOI22XL $PINS A0=n1266 A1=shadow_weights[3][9] B0=n1268
+ B1=shadow_weights[5][9] Y=n1092_CDR1
XU859 AOI22XL $PINS A0=gre_a_INV_6238_58 A1=shadow_weights[1][9]
+ B0=gre_a_INV_8759_58 B1=shadow_weights[4][9] Y=n1100_CDR1
XU860 NAND2XL $PINS A=n346 B=avg_cnt[3] Y=n1978
XU861 AOI22XL $PINS A0=gre_a_INV_6238_58 A1=shadow_weights[1][1] B0=n1270
+ B1=shadow_weights[14][1] Y=n683_CDR1
XctmTdsLR_6_1833 INVXL $PINS A=tmp_net301 Y=tmp_net325
XctmTdsLR_2_1947 NAND2XL $PINS A=tmp_net398 B=n237 Y=n239
XctmTdsLR_1_823 NAND2XL $PINS A=n567 B=HFSNET_347 Y=HFSNET_71
XctmTdsLR_4_1902 AOI211XL $PINS A0=gre_a_INV_6625_58 A1=shadow_weights[15][1]
+ B0=HFSNET_20 C0=tmp_net372 Y=tmp_net373
XctmTdsLR_5_1903 OAI2BB1XL $PINS A0N=shadow_weights[13][1] A1N=n1319
+ B0=tmp_net371 Y=tmp_net372
XctmTdsLR_2_1835 NAND3XL $PINS A=ZBUF_2_13 B=tmp_net327 C=n1039_CDR1
+ Y=tmp_net328
XZCTSBUF_251_1344 BUFX8 $PINS A=net1726 Y=ZCTSNET_391
XctmTdsLR_1_680 OAI2BB1XL $PINS A0N=n1449 A1N=HFSNET_293 B0=n1447 Y=tmp_net21
XctmTdsLR_2_2035 NAND2XL $PINS A=n1521 B=n1520 Y=tmp_net446
XctmTdsLR_3_1948 INVXL $PINS A=n236 Y=tmp_net398
XU872 AOI22XL $PINS A0=n1274 A1=shadow_weights[9][4] B0=gre_a_INV_6610_58
+ B1=shadow_weights[11][4] Y=n985_CDR1
XU874 INVX4 $PINS A=n1300 Y=n1268
XU875 AOI22X2 $PINS A0=HFSNET_342 A1=shadow_weights[7][11] B0=n1274
+ B1=shadow_weights[9][11] Y=n1151_CDR2
XU876 AOI22XL $PINS A0=gre_a_INV_6610_58 A1=shadow_weights[11][1] B0=n1274
+ B1=shadow_weights[9][1] Y=n674_CDR1
XctmTdsLR_3_1836 NAND2XL $PINS A=HFSNET_342 B=shadow_weights[7][7] Y=tmp_net327
XU878 NAND2XL $PINS A=n315 B=n1416 Y=N1791
XU879 AOI22X1 $PINS A0=gre_a_INV_6610_58 A1=shadow_weights[11][7] B0=n1274
+ B1=shadow_weights[9][7] Y=n1039_CDR1
XctmTdsLR_1_709 AOI222XL $PINS A0=n1270 A1=shadow_weights[14][7] B0=n1268
+ B1=shadow_weights[5][7] C0=gre_a_INV_8759_58 C1=shadow_weights[4][7]
+ Y=tmp_net39
XU881 AOI22XL $PINS A0=n1274 A1=shadow_weights[9][6] B0=gre_a_INV_6610_58
+ B1=shadow_weights[11][6] Y=n1025_CDR1
XU882 CLKBUFX4 $PINS A=n1291 Y=n1319
XU883 INVX4 $PINS A=n1298 Y=n1266
XU884 CLKINVX3 $PINS A=n1322 Y=n1292
XU885 AOI22X1 $PINS A0=gre_a_INV_6610_58 A1=shadow_weights[11][3] B0=n1274
+ B1=shadow_weights[9][3] Y=n782
XU886 AOI22XL $PINS A0=gre_a_INV_6238_58 A1=shadow_weights[1][26] B0=HFSNET_342
+ B1=shadow_weights[7][26] Y=n1534_CDR1
XU887 AOI22XL $PINS A0=gre_a_INV_6238_58 A1=shadow_weights[1][23] B0=n1662
+ B1=shadow_weights[9][23] Y=n1371_CDR1
XctmTdsLR_3_949 NAND4X1 $PINS A=tmp_net278 B=tmp_net345 C=ZBUF_2_30
+ D=n1636_CDR2 Y=HFSNET_73
XU889 OAI2BB1X1 $PINS A0N=n1985 A1N=n1989 B0=n315 Y=N1692
XU890 AOI22XL $PINS A0=gre_a_INV_6238_58 A1=shadow_weights[1][17] B0=n1274
+ B1=shadow_weights[9][17] Y=n1253_CDR1
XU891 AOI22XL $PINS A0=n1274 A1=shadow_weights[9][2] B0=gre_a_INV_6610_58
+ B1=shadow_weights[11][2] Y=n742_CDR1
XU892 AOI22XL $PINS A0=HFSNET_342 A1=shadow_weights[7][24] B0=gre_a_INV_5313_58
+ B1=shadow_weights[12][24] Y=n1401_CDR2
XctmTdsLR_1_1879 INVXL $PINS A=tmp_net358 Y=ZBUF_24_19
XU894 NAND2XL $PINS A=n2034 B=n2006 Y=n2008
XU895 AOI22XL $PINS A0=gre_a_INV_6610_58 A1=shadow_weights[11][16] B0=n1274
+ B1=shadow_weights[9][16] Y=n1239_CDR2
XU896 AOI22XL $PINS A0=HFSNET_342 A1=shadow_weights[7][18] B0=n1266
+ B1=shadow_weights[3][18] Y=n1276_CDR2
XU897 AOI22X1 $PINS A0=n1274 A1=shadow_weights[9][10] B0=gre_a_INV_6610_58
+ B1=shadow_weights[11][10] Y=n1118_CDR2
XU898 INVX4 $PINS A=n1302 Y=n1270
XU899 AOI22X1 $PINS A0=gre_a_INV_6610_58 A1=shadow_weights[11][9] B0=n1274
+ B1=shadow_weights[9][9] Y=n1093
XU900 NAND3XL $PINS A=n968 B=n315 C=n322 Y=N1536
XU901 NAND2XL $PINS A=n1993 B=n1992 Y=n2004
XU902 INVXL $PINS A=n666 Y=n664
XU903 AOI22XL $PINS A0=gre_a_INV_6610_58 A1=shadow_weights[11][25] B0=n1662
+ B1=shadow_weights[9][25] Y=n1469_CDR1
XctmTdsLR_4_1837 NAND4XL $PINS A=ZBUF_2_50 B=tmp_net329 C=ZBUF_2_49
+ D=tmp_net330 Y=tmp_net331
XU905 CLKINVX3 $PINS A=n1309 Y=n1277
XU906 NAND2XL $PINS A=n156 B=n155 Y=n157
XU907 INVXL $PINS A=n174 Y=n180
XU908 INVX3 $PINS A=n1310 Y=n1279
XU915 NAND2XL $PINS A=n192 B=n190 Y=n188
XU918 INVX4 $PINS A=n1306 Y=n1274
XU919 NAND2XL $PINS A=n165 B=n164 Y=n166
XU920 INVXL $PINS A=n2024 Y=n2034
XU922 NAND2XL $PINS A=n199 B=n76 Y=n78
XU923 CLKINVX3 $PINS A=n1311 Y=n1281
XctmTdsLR_2_1880 AND4XL $PINS A=tmp_net326 B=n1534_CDR1 C=tmp_net300
+ D=tmp_net297 Y=tmp_net358
XctmTdsLR_1_711 AOI222XL $PINS A0=n1268 A1=shadow_weights[5][2]
+ B0=gre_a_INV_8759_58 B1=shadow_weights[4][2] C0=n1270 C1=shadow_weights[14][2]
+ Y=tmp_net40
XU927 NAND2XL $PINS A=n2009 B=n2010 Y=n2017
XU929 INVXL $PINS A=n487 Y=n411
XctmTdsLR_1_2016 OAI21XL $PINS A0=tmp_net215 A1=n1439 B0=tmp_net437 Y=n1441
XU933 INVXL $PINS A=n432 Y=n433
XU934 NAND2XL $PINS A=n118 B=n116 Y=n107
XU936 AOI21XL $PINS A0=n82 A1=n103 B0=n81 Y=n83
XZBUF_2_inst_1028 BUFX1 $PINS A=tmp_net37 Y=ZBUF_2_13
XU938 CLKINVX3 $PINS A=n675 Y=n1671
XU939 CLKINVX3 $PINS A=n676 Y=n1673
XU941 NAND2XL $PINS A=avg_cnt[2] B=n344 Y=n345
XU943 OR3X2 $PINS A=n1990 B=state[2] C=n2172 Y=n322
XU944 INVXL $PINS A=n2115 Y=n2125
XU946 NAND2XL $PINS A=n808 B=n807 Y=n811
XU947 NAND2XL $PINS A=n132 B=n128 Y=n89
XU948 OR2XL $PINS A=n808 B=n807 Y=n813
XU951 OR2XL $PINS A=n646 B=n645 Y=n694
XU952 NAND2XL $PINS A=n586 B=n585 Y=n642
XU953 NAND2XL $PINS A=n128 B=n127 Y=n129
XU954 NAND2XL $PINS A=n646 B=n645 Y=n692
XU955 NAND2XL $PINS A=n718 B=n696 Y=n804
XU956 NAND2XL $PINS A=n565 B=n564 Y=n581
XU957 NAND2XL $PINS A=n397 B=n396 Y=n606
XU958 OR2XL $PINS A=n565 B=n564 Y=n583
XU960 NAND2XL $PINS A=n513 B=n512 Y=n561
XU961 NAND2XL $PINS A=n132 B=n131 Y=n133
XU962 NAND2XL $PINS A=n463 B=n462 Y=n508
XU964 NAND2XL $PINS A=n410 B=n409 Y=n487
XU965 NAND2XL $PINS A=n437 B=n436 Y=n459
XU966 NOR2XL $PINS A=n437 B=n436 Y=n460
XU967 NAND2XL $PINS A=n420 B=n419 Y=n432
XU968 NAND2XL $PINS A=n413 B=n412 Y=n552
XU969 NAND2XL $PINS A=n415 B=n414 Y=n494
XctmTdsLR_2_2017 NAND2XL $PINS A=tmp_net436 B=n1437 Y=n1439
XU972 INVXL $PINS A=n155 Y=n109
XU973 INVXL $PINS A=n280 Y=n281
XU974 INVXL $PINS A=n108 Y=n156
XU977 INVXL $PINS A=n187 Y=n192
XctmTdsLR_6_1904 AOI22XL $PINS A0=n1290 A1=shadow_weights[6][1] B0=n1292
+ B1=shadow_weights[2][1] Y=tmp_net371
XU979 INVXL $PINS A=n1142 Y=n1143
XU982 NAND2XL $PINS A=n242 B=n241 Y=n243
XctmTdsLR_2_1732 OAI2BB1XL $PINS A0N=shadow_weights[7][3] A1N=HFSNET_342
+ B0=n780_CDR2 Y=tmp_net256
XU986 INVXL $PINS A=n148 Y=n165
XU988 INVXL $PINS A=n1549 Y=n1550
XU989 NAND2XL $PINS A=n824 B=n2194 Y=n1080
XU992 NAND2XL $PINS A=n2158 B=n2010 Y=n2072
XU993 NAND2XL $PINS A=N1822 B=n2162 Y=n829
XU994 NAND2XL $PINS A=n141 B=n140 Y=n142
XU996 INVXL $PINS A=n2020 Y=n2047
XctmTdsLR_4_1949 NOR2XL $PINS A=n240 B=n239 Y=tmp_net399
XctmTdsLR_3_715 AOI222X1 $PINS A0=HFSNET_244 A1=n1280 B0=n1282
+ B1=shadow_weights[17][9] C0=shadow_weights[19][9] C1=n1281 Y=tmp_net43
XU999 INVXL $PINS A=n1988 Y=n64
XU1000 INVXL $PINS A=n654 Y=n63
XU1001 NAND2XL $PINS A=temp_acc[7] B=shadow_weights[17][7] Y=n210
XU1002 NAND2XL $PINS A=temp_acc[11] B=shadow_weights[17][11] Y=n151
XU1003 NAND2XL $PINS A=temp_acc[13] B=shadow_weights[17][13] Y=n112
XU1004 NAND2XL $PINS A=temp_acc[15] B=shadow_weights[17][15] Y=n121
XU1005 OR2XL $PINS A=temp_acc[16] B=shadow_weights[17][16] Y=n132
XU1006 NAND2XL $PINS A=temp_acc[16] B=shadow_weights[17][16] Y=n131
XU1007 NAND2XL $PINS A=n2195 B=accumulator[30] Y=n1142
XU1008 NAND2XL $PINS A=temp_acc[17] B=shadow_weights[17][17] Y=n127
XU1009 OR2XL $PINS A=temp_acc[18] B=shadow_weights[17][18] Y=n141
XU1010 NOR2XL $PINS A=n2196 B=accumulator[31] Y=n1494
XU1011 NAND2XL $PINS A=n2196 B=accumulator[31] Y=n1493
XU1012 OR2X1 $PINS A=n319 B=state[1] Y=n729
XU1013 NAND2XL $PINS A=n2198 B=accumulator[32] Y=n1549
XU1014 NAND2XL $PINS A=n2200 B=accumulator[33] Y=n1576
XU1015 NAND2XL $PINS A=temp_acc[28] B=shadow_weights[17][28] Y=n280
XU1016 NAND2XL $PINS A=temp_acc[26] B=shadow_weights[17][26] Y=n261
XU1017 NAND2XL $PINS A=temp_acc[27] B=shadow_weights[17][27] Y=n267
XU1018 OR2XL $PINS A=temp_acc[26] B=shadow_weights[17][26] Y=n263
XctmTdsLR_5_1838 NAND2XL $PINS A=gre_a_INV_5313_58 B=shadow_weights[12][7]
+ Y=tmp_net329
XctmTdsLR_6_1839 AOI22XL $PINS A0=n1266 A1=shadow_weights[3][7]
+ B0=gre_a_INV_6238_58 B1=shadow_weights[1][7] Y=tmp_net330
XctmTdsLR_1_1950 AOI21XL $PINS A0=n139 A1=n138 B0=tmp_net401 Y=n1793
XctmTdsLR_1_1905 OR4X1 $PINS A=tmp_net134 B=tmp_net311 C=tmp_net313
+ D=tmp_net375 Y=HFSNET_172
XU1024 NAND3XL $PINS A=state[0] B=state[3] C=n68 Y=n319
XU1026 NOR2XL $PINS A=state[2] B=state[3] Y=n297
XU1027 NOR2XL $PINS A=target_bit[2] B=target_bit[0] Y=n2010
XU1028 OAI21X1 $PINS A0=n1857 A1=n224 B0=n223 Y=n1779
XU1029 OAI21XL $PINS A0=ZBUF_4201_28 A1=n2025 B0=n2029 Y=n57
XctmTdsLR_2_1951 NAND2XL $PINS A=tmp_net400 B=n136 Y=n138
XU1031 OAI21XL $PINS A0=n502 A1=n499 B0=n503 Y=n485
XU1032 NAND2XL $PINS A=n2173 B=calc_cnt[1] Y=n630
XU1033 OAI21XL $PINS A0=n1947 A1=n1944 B0=n1945 Y=n1938
XU1034 NAND2XL $PINS A=sar_ptr[1] B=n2199 Y=n2128
XU1035 NOR2X2 $PINS A=n2076 B=n474 Y=n2118
XctmTdsLR_1_718 NAND2XL $PINS A=n465 B=HFSNET_347 Y=HFSNET_11
XU1037 NAND2X2 $PINS A=n2020 B=n2158 Y=n2018
XU1038 OAI221XL $PINS A0=HFSNET_249 A1=overrange_bits[9] B0=N1833 B1=n2157
+ C0=n640 Y=n708
XU1039 NAND2XL $PINS A=n2009 B=n2033 Y=n2015
XU1040 OR2X4 $PINS A=n1989 B=n733 Y=n1875
XU1041 NOR2X1 $PINS A=n56 B=n1990 Y=n1989
XU1042 CLKINVX3 $PINS A=n676 Y=n1282
XU1043 CLKINVX3 $PINS A=n675 Y=n1280
XU1044 NAND2X1 $PINS A=calc_cnt[0] B=n2174 Y=n626
XctmTdsLR_2_1779 AND4XL $PINS A=tmp_net75 B=tmp_net76 C=tmp_net73 D=tmp_net74
+ Y=tmp_net286
XU1046 OAI21XL $PINS A0=n665 A1=n658 B0=N1822 Y=n1655
XU1047 NOR2X2 $PINS A=n67 B=n319 Y=N1822
XU1048 NOR2XL $PINS A=n580 B=wait_cnt[3] Y=n579
XHFSINV_123_506 INVXL $PINS A=N1826 Y=HFSNET_250
XU1050 NAND3XL $PINS A=n639 B=n638 C=start_calib Y=n659
XU1051 NOR2XL $PINS A=n68 B=n2172 Y=n638
XU1052 OAI21XL $PINS A0=n2073 A1=n2024 B0=n2053 Y=n2054
XU1053 OAI21XL $PINS A0=n2073 A1=ZBUF_4201_28 B0=n2178 Y=n2056
XU1054 NAND2X1 $PINS A=target_bit[0] B=target_bit[2] Y=n2073
XU1055 NOR2XL $PINS A=wait_cnt[1] B=wait_cnt[0] Y=n1984
XU1058 NAND2XL $PINS A=sar_ptr[0] B=sar_ptr[1] Y=n2132
XU1063 OAI21XL $PINS A0=n2179 A1=n2024 B0=n2053 Y=n2050
XU1064 AOI2BB1XL $PINS A0N=n2179 A1N=ZBUF_4201_28 B0=target_bit[4] Y=n2053
XctmTdsLR_3_1952 INVXL $PINS A=n135 Y=tmp_net400
XU1066 AND2X2 $PINS A=n55 B=target_bit[0] Y=n292
XU1067 OAI22XL $PINS A0=ZBUF_145_35 A1=n2000 B0=n2183 B1=n2011 Y=dac_p_force[8]
XU1068 OAI22XL $PINS A0=n2019 A1=n2012 B0=n2180 B1=n2011 Y=dac_p_force[7]
XU1069 OAI22XL $PINS A0=ZBUF_145_35 A1=n1999 B0=n2167 B1=n2011 Y=dac_p_force[9]
XU1070 OAI22X2 $PINS A0=n2000 A1=n2031 B0=n2011 B1=n2165 Y=dac_p_force[2]
XU1071 NAND2XL $PINS A=n2010 B=n1996 Y=n2000
XU1072 OAI22XL $PINS A0=ZBUF_4201_28 A1=n2000 B0=n2166 B1=n2011
+ Y=dac_p_force[10]
XU1073 OAI22XL $PINS A0=n2016 A1=n2180 B0=n2012 B1=n2011 Y=dac_n_force[7]
XU1074 OAI22XL $PINS A0=ZBUF_4201_28 A1=n1999 B0=n2164 B1=n2011
+ Y=dac_p_force[11]
XU1075 OAI22XL $PINS A0=n2002 A1=n2016 B0=gre_a_INV_2586_58 B1=n2007
+ Y=dac_n_force[18]
XU1076 OAI22X2 $PINS A0=n1999 A1=n2031 B0=n2007 B1=n2181 Y=dac_p_force[3]
XU1077 OAI22XL $PINS A0=n2019 A1=n2182 B0=ZBUF_4201_28 B1=n2013
+ Y=dac_n_force[15]
XU1078 OAI22XL $PINS A0=n2019 A1=n2188 B0=ZBUF_145_35 B1=n2013
+ Y=dac_n_force[13]
XU1079 OAI22XL $PINS A0=n2019 A1=n2184 B0=ZBUF_4201_28 B1=n2014
+ Y=dac_n_force[14]
XU1080 OAI22XL $PINS A0=n2016 A1=n2168 B0=n2031 B1=n2014 Y=dac_n_force[6]
XU1081 OAI22XL $PINS A0=n2016 A1=n2181 B0=n2015 B1=n2031 Y=dac_n_force[3]
XU1082 OAI22XL $PINS A0=n2016 A1=n2167 B0=ZBUF_145_35 B1=n2015 Y=dac_n_force[9]
XU1083 OAI22XL $PINS A0=n2019 A1=n2164 B0=ZBUF_4201_28 B1=n2015
+ Y=dac_n_force[11]
XU1084 OAI22X2 $PINS A0=n2007 A1=n2168 B0=n1998 B1=n2031 Y=dac_p_force[6]
XU1085 OAI22XL $PINS A0=n2016 A1=n2186 B0=n2018 B1=n2015 Y=dac_n_force[1]
XU1086 OAI22XL $PINS A0=n2016 A1=n2190 B0=n2018 B1=n2014 Y=dac_n_force[4]
XU1087 OAI22XL $PINS A0=n2016 A1=n2191 B0=n2018 B1=n2013 Y=dac_n_force[5]
XU1088 OAI22X2 $PINS A0=n2007 A1=n2186 B0=n1999 B1=n2018 Y=dac_p_force[1]
XU1089 NAND2XL $PINS A=n1996 B=n2033 Y=n1999
XU1090 OAI22X2 $PINS A0=n2007 A1=n2190 B0=n1998 B1=n2018 Y=dac_p_force[4]
XU1091 OAI22X2 $PINS A0=n2007 A1=n2191 B0=n1997 B1=n2018 Y=dac_p_force[5]
XU1092 OAI22XL $PINS A0=n2019 A1=n2185 B0=n2018 B1=n2017 Y=dac_n_force[0]
XU1093 CLKINVX2 $PINS A=n1996 Y=n2019
XU1094 OAI22XL $PINS A0=n2016 A1=n2165 B0=n2017 B1=n2031 Y=dac_n_force[2]
XU1095 OAI22XL $PINS A0=n2016 A1=n2183 B0=ZBUF_145_35 B1=n2017 Y=dac_n_force[8]
XU1096 OAI22XL $PINS A0=n2016 A1=n2166 B0=ZBUF_4201_28 B1=n2017
+ Y=dac_n_force[10]
XU1097 CLKINVX2 $PINS A=n1996 Y=n2016
XU1098 OAI22XL $PINS A0=n2185 A1=n2007 B0=n2000 B1=n2018 Y=dac_p_force[0]
XU1099 OAI22XL $PINS A0=n2002 A1=n2007 B0=n2016 B1=gre_a_INV_2586_58
+ Y=dac_p_force[18]
XU1100 NOR2BX1 $PINS AN=n1988 B=n2171 Y=n725
XU1101 NOR3XL $PINS A=n67 B=state[2] C=state[3] Y=n1988
XctmTdsLR_3_721 AOI222XL $PINS A0=n1280 A1=shadow_weights[18][8] B0=n1282
+ B1=shadow_weights[17][8] C0=shadow_weights[19][8] C1=n1281 Y=tmp_net47
XctmTdsLR_4_1953 NOR2XL $PINS A=n139 B=n138 Y=tmp_net401
XctmTdsLR_2_1906 NAND2BXL $PINS AN=tmp_net312 B=tmp_net374 Y=tmp_net375
XU1106 NOR3X2 $PINS A=state[0] B=n67 C=n56 Y=n663
XctmTdsLR_1_724 AOI222XL $PINS A0=n1671 A1=shadow_weights[18][2] B0=n1673
+ B1=shadow_weights[17][2] C0=shadow_weights[19][2] C1=n1281 Y=tmp_net49
XctmTdsLR_2_725 NAND2XL $PINS A=n1279 B=shadow_weights[16][2] Y=tmp_net50
XctmTdsLR_3_1907 NAND2XL $PINS A=gre_a_INV_6625_58 B=shadow_weights[15][8]
+ Y=tmp_net374
XctmTdsLR_1_727 NAND2XL $PINS A=n1456 B=n1459 Y=tmp_net51
XctmTdsLR_2_728 OAI211X1 $PINS A0=n1417 A1=n1398 B0=tmp_net51 C0=n1458 Y=n1466
XctmTdsLR_1_1954 OAI21XL $PINS A0=n271 A1=n279 B0=tmp_net402 Y=n275
XctmTdsLR_2_1841 AND3XL $PINS A=tmp_net332 B=n1150_CDR1 C=ZBUF_2_45
+ Y=tmp_net333
XU1114 CLKINVX2 $PINS A=n1311 Y=n1672
XU1115 INVX2 $PINS A=n1309 Y=n1668
XU1116 INVX2 $PINS A=n1306 Y=n1662
XU1117 CLKINVX3 $PINS A=n1302 Y=n1679
XU1118 INVX2 $PINS A=n1300 Y=n1677
XU1119 INVX2 $PINS A=n1298 Y=n1660
XU1120 CLKINVX2 $PINS A=n1310 Y=n1670
XctmTdsLR_3_1842 AOI222XL $PINS A0=gre_a_INV_6238_58 A1=shadow_weights[1][11]
+ B0=n1266 B1=shadow_weights[3][11] C0=gre_a_INV_6610_58
+ C1=shadow_weights[11][11] Y=tmp_net332
XctmTdsLR_1_748 NAND2XL $PINS A=n1278 B=shadow_weights[8][10] Y=tmp_net65
XU1124 OAI22XL $PINS A0=n2019 A1=n2021 B0=n2003 B1=n2011 Y=dac_p_force[17]
XU1125 OAI22XL $PINS A0=n2019 A1=n2004 B0=n2189 B1=n2011 Y=dac_p_force[16]
XU1126 OAI22XL $PINS A0=ZBUF_4201_28 A1=n1997 B0=n2182 B1=n2011
+ Y=dac_p_force[15]
XU1127 OAI22XL $PINS A0=ZBUF_4201_28 A1=n1998 B0=n2184 B1=n2011
+ Y=dac_p_force[14]
XU1128 OAI22XL $PINS A0=ZBUF_145_35 A1=n1997 B0=n2188 B1=n2011
+ Y=dac_p_force[13]
XU1129 OAI22XL $PINS A0=n2019 A1=n2008 B0=n2187 B1=n2011 Y=dac_p_force[12]
XU1130 CLKINVX2 $PINS A=n2009 Y=n2011
XU1132 OAI21XL $PINS A0=n426 A1=n423 B0=n427 Y=n441
XU1133 OAI21XL $PINS A0=n1881 A1=n1890 B0=n1882 Y=n1858
XU1134 OAI21XL $PINS A0=n1450 A1=n1447 B0=n1451 Y=n1498
XU1135 OAI21XL $PINS A0=n1054 A1=n1053 B0=n1052 Y=n1085
XU1136 OAI21XL $PINS A0=n193 A1=n190 B0=n194 Y=n198
XU1137 OAI21XL $PINS A0=n644 A1=n643 B0=n642 Y=n695
XU1138 OAI21XL $PINS A0=n461 A1=n460 B0=n459 Y=n511
XU1139 OAI21XL $PINS A0=n1707 A1=n1703 B0=n1704 Y=n279
XctmTdsLR_2_749 NAND2XL $PINS A=n1277 B=shadow_weights[10][10] Y=tmp_net66
XctmTdsLR_4_953 NAND2XL $PINS A=tmp_net77 B=tmp_net201 Y=HFSNET_127
XZCTSBUF_251_1345 BUFX8 $PINS A=net1731 Y=ZCTSNET_392
XU1145 XNOR2XL $PINS A=n1956 B=n1955 Y=n1960
XU1146 NOR3X4 $PINS A=wr_idx_r[4] B=wr_idx_r[3] C=n671 Y=N1841
XU1147 NAND2X1 $PINS A=n666 B=n2177 Y=n671
XU1148 OAI21XL $PINS A0=n2031 A1=n2025 B0=n2049 Y=n2045
XU1149 NOR2X1 $PINS A=n2047 B=target_bit[2] Y=n2049
XU1150 NAND2X2 $PINS A=target_bit[1] B=n2020 Y=n2031
XU1151 NOR2X1 $PINS A=target_bit[3] B=target_bit[4] Y=n2020
XU1153 NAND2X1 $PINS A=n559 B=n2159 Y=n669
XU1154 NOR2X1 $PINS A=n2163 B=target_bit[2] Y=n2033
XU1155 NOR2XL $PINS A=n2076 B=n1627 Y=n641
XU1156 NOR2X2 $PINS A=n725 B=n663 Y=n2076
XU1157 NOR2BXL $PINS AN=n579 B=wait_cnt[4] Y=n1627
XctmTdsLR_3_750 AOI222X1 $PINS A0=n1280 A1=shadow_weights[18][10] B0=n1282
+ B1=shadow_weights[17][10] C0=shadow_weights[19][10] C1=n1281 Y=tmp_net67
XctmTdsLR_4_751 NAND2XL $PINS A=n1279 B=shadow_weights[16][10] Y=tmp_net68
XU1160 NOR2X4 $PINS A=n627 B=n626 Y=n1291
XctmTdsLR_1_1843 NOR2BX1 $PINS AN=n1276_CDR2 B=tmp_net337 Y=n1296_CDR1
XU1163 INVX2 $PINS A=n1320 Y=n1686
XU1167 INVX2 $PINS A=n1308 Y=n1669
XctmTdsLR_1_753 NAND2XL $PINS A=n1278 B=shadow_weights[8][17] Y=tmp_net69
XU1170 OAI22XL $PINS A0=n2019 A1=n2189 B0=n2007 B1=n2004 Y=dac_n_force[16]
XU1171 OAI22XL $PINS A0=n2019 A1=n2192 B0=HFSNET_346 B1=n2007 Y=dac_n_force[19]
XU1172 OAI22X1 $PINS A0=n2019 A1=n2003 B0=n2021 B1=n2007 Y=dac_n_force[17]
XU1173 OAI22XL $PINS A0=n2019 A1=n2187 B0=n2008 B1=n2007 Y=dac_n_force[12]
XU1174 OAI22XL $PINS A0=n2016 A1=HFSNET_346 B0=n2192 B1=n2007 Y=dac_p_force[19]
XU1175 CLKINVX2 $PINS A=n2009 Y=n2007
XctmTdsLR_2_754 NAND2XL $PINS A=n1277 B=shadow_weights[10][17] Y=tmp_net70
XctmTdsLR_3_755 AOI222X1 $PINS A0=n1280 A1=shadow_weights[18][17] B0=n1282
+ B1=shadow_weights[17][17] C0=shadow_weights[19][17] C1=n1281 Y=tmp_net71
XHFSINV_622_598 INVX4 $PINS A=calc_result_r[5] Y=HFSNET_337
XctmTdsLR_4_756 NAND2XL $PINS A=n1279 B=shadow_weights[16][17] Y=tmp_net72
XctmTdsLR_1_954 AOI222XL $PINS A0=n1686 A1=shadow_weights[6][20]
+ B0=ZBUF_20020_1 B1=shadow_weights[0][20] C0=n1687 C1=shadow_weights[2][20]
+ Y=tmp_net202
XctmTdsLR_1_758 NAND2XL $PINS A=n516 B=HFSNET_347 Y=HFSNET_12
XHFSINV_710_578 CLKINVX8 $PINS A=calc_result_r[1] Y=HFSNET_317
XctmTdsLR_1_759 NAND2XL $PINS A=n1278 B=shadow_weights[8][1] Y=tmp_net73
XHFSINV_710_573 INVX4 $PINS A=calc_result_r[14] Y=HFSNET_312
XU1188 INVX4 $PINS A=calc_result_r[28] Y=n2306
XU1189 INVX4 $PINS A=calc_result_r[27] Y=n2305
XHFSINV_1117_583 INVX4 $PINS A=calc_result_r[25] Y=HFSNET_322
XHFSINV_733_582 INVX4 $PINS A=calc_result_r[24] Y=HFSNET_321
XHFSINV_722_581 INVX4 $PINS A=calc_result_r[23] Y=HFSNET_320
XHFSINV_957_580 INVX4 $PINS A=calc_result_r[22] Y=HFSNET_319
XHFSINV_777_579 INVX4 $PINS A=calc_result_r[21] Y=HFSNET_318
XU1195 CLKINVX3 $PINS A=calc_result_r[20] Y=n2299
XU1196 CLKINVX3 $PINS A=calc_result_r[19] Y=n2298
XHFSINV_655_577 INVX4 $PINS A=calc_result_r[18] Y=HFSNET_316
XctmTdsLR_2_760 NAND2XL $PINS A=n1277 B=shadow_weights[10][1] Y=tmp_net74
XHFSINV_753_584 INVX4 $PINS A=calc_result_r[29] Y=HFSNET_323
XHFSINV_702_576 INVX4 $PINS A=calc_result_r[17] Y=HFSNET_315
XHFSINV_651_575 CLKINVX8 $PINS A=calc_result_r[16] Y=HFSNET_314
XHFSINV_697_574 INVX4 $PINS A=calc_result_r[15] Y=HFSNET_313
XU1203 CLKBUFX3 $PINS A=orr_r Y=n2157
XctmTdsLR_3_761 AOI222XL $PINS A0=n1280 A1=shadow_weights[18][1] B0=n1282
+ B1=shadow_weights[17][1] C0=shadow_weights[19][1] C1=n1281 Y=tmp_net75
XU1206 AOI21XL $PINS A0=n143 A1=n141 B0=n90 Y=n139
XU1207 OAI21XL $PINS A0=n139 A1=n135 B0=n136 Y=n244
XU1208 OAI21XL $PINS A0=n240 A1=n236 B0=n237 Y=n235
XU1209 OAI21XL $PINS A0=n1082 A1=n1081 B0=n1080 Y=n1145
XU1210 OAI21XL $PINS A0=n1495 A1=n1494 B0=n1493 Y=n1552
XU1211 OAI21XL $PINS A0=n1724 A1=n1720 B0=n1721 Y=n1715
XU1212 OAI21XL $PINS A0=n563 A1=n562 B0=n561 Y=n584
XU1213 OAI21XL $PINS A0=n275 A1=HFSNET_346 B0=n274 Y=n895
XU1214 NOR2XL $PINS A=temp_acc[8] B=shadow_weights[17][8] Y=n214
XU1215 NOR2XL $PINS A=temp_acc[9] B=shadow_weights[17][9] Y=n159
XU1216 NOR2XL $PINS A=n214 B=n159 Y=n144
XU1217 NOR2XL $PINS A=temp_acc[10] B=shadow_weights[17][10] Y=n148
XU1218 NOR2XL $PINS A=temp_acc[11] B=shadow_weights[17][11] Y=n150
XU1219 NOR2XL $PINS A=n148 B=n150 Y=n80
XU1220 NAND2XL $PINS A=n144 B=n80 Y=n101
XU1221 NOR2XL $PINS A=temp_acc[12] B=HFSNET_209 Y=n108
XU1222 NOR2XL $PINS A=temp_acc[13] B=shadow_weights[17][13] Y=n111
XU1223 NOR2XL $PINS A=n108 B=n111 Y=n102
XU1224 NOR2XL $PINS A=temp_acc[14] B=HFSNET_211 Y=n106
XU1225 NOR2XL $PINS A=temp_acc[15] B=shadow_weights[17][15] Y=n120
XU1226 NOR2XL $PINS A=n106 B=n120 Y=n82
XU1227 NAND2XL $PINS A=n102 B=n82 Y=n84
XU1228 NOR2XL $PINS A=n101 B=n84 Y=n86
XU1229 NOR2XL $PINS A=temp_acc[2] B=shadow_weights[17][2] Y=n179
XU1230 NOR2XL $PINS A=temp_acc[3] B=shadow_weights[17][3] Y=n181
XU1231 NOR2XL $PINS A=n179 B=n181 Y=n74
XU1232 NOR2XL $PINS A=temp_acc[1] B=shadow_weights[17][1] Y=n168
XU1234 NAND2XL $PINS A=temp_acc[1] B=shadow_weights[17][1] Y=n169
XU1235 NAND2XL $PINS A=temp_acc[2] B=shadow_weights[17][2] Y=n178
XU1236 NAND2XL $PINS A=temp_acc[3] B=shadow_weights[17][3] Y=n182
XU1237 OAI21XL $PINS A0=n181 A1=n178 B0=n182 Y=n73
XU1238 AOI21XL $PINS A0=n74 A1=n174 B0=n73 Y=n186
XU1239 NOR2XL $PINS A=temp_acc[4] B=shadow_weights[17][4] Y=n187
XU1240 NOR2XL $PINS A=temp_acc[5] B=shadow_weights[17][5] Y=n193
XU1241 NOR2XL $PINS A=n187 B=n193 Y=n199
XU1242 NOR2XL $PINS A=temp_acc[6] B=shadow_weights[17][6] Y=n207
XU1243 NOR2XL $PINS A=temp_acc[7] B=shadow_weights[17][7] Y=n209
XU1244 NOR2XL $PINS A=n207 B=n209 Y=n76
XU1245 NAND2XL $PINS A=temp_acc[4] B=shadow_weights[17][4] Y=n190
XU1246 NAND2XL $PINS A=temp_acc[6] B=shadow_weights[17][6] Y=n206
XU1247 OAI21XL $PINS A0=n209 A1=n206 B0=n210 Y=n75
XU1248 AOI21XL $PINS A0=n76 A1=n198 B0=n75 Y=n77
XU1249 OAI21XL $PINS A0=n186 A1=n78 B0=n77 Y=n99
XU1250 NAND2XL $PINS A=temp_acc[8] B=shadow_weights[17][8] Y=n215
XU1251 NAND2XL $PINS A=temp_acc[9] B=shadow_weights[17][9] Y=n160
XU1252 NAND2XL $PINS A=temp_acc[10] B=shadow_weights[17][10] Y=n164
XU1253 OAI21XL $PINS A0=n150 A1=n164 B0=n151 Y=n79
XU1254 AOI21XL $PINS A0=n80 A1=n145 B0=n79 Y=n100
XU1255 NAND2XL $PINS A=temp_acc[12] B=HFSNET_209 Y=n155
XU1256 NAND2XL $PINS A=temp_acc[14] B=HFSNET_211 Y=n116
XU1257 OAI21XL $PINS A0=n120 A1=n116 B0=n121 Y=n81
XU1258 OAI21XL $PINS A0=n100 A1=n84 B0=n83 Y=n85
XU1259 AOI21XL $PINS A0=n86 A1=n99 B0=n85 Y=n125
XU1261 AOI21XL $PINS A0=n235 A1=n233 B0=n92 Y=n98
XU1262 NOR2XL $PINS A=temp_acc[23] B=shadow_weights[17][23] Y=n94
XU1263 OAI21XL $PINS A0=n98 A1=n94 B0=n95 Y=n253
XU1264 NAND2XL $PINS A=n252 B=n250 Y=n93
XU1265 XNOR2X1 $PINS A=n253 B=n93 Y=n1736
XU1266 NOR2XL $PINS A=n1736 B=shadow_weights[18][24] Y=n1730
XU1269 XOR2X1 $PINS A=n98 B=n97 Y=n1745
XU1270 NOR2XL $PINS A=n1745 B=shadow_weights[18][23] Y=n1740
XU1271 NOR2XL $PINS A=n1730 B=n1740 Y=n249
XU1272 INVXL $PINS A=n99 Y=n218
XctmTdsLR_4_762 NAND2XL $PINS A=n1279 B=shadow_weights[16][1] Y=tmp_net76
XU1274 XNOR2X1 $PINS A=n119 B=n107 Y=n1844
XU1275 NOR2XL $PINS A=n1844 B=shadow_weights[18][14] Y=n1839
XU1276 XOR2X1 $PINS A=n115 B=n114 Y=n1853
XU1277 NOR2XL $PINS A=n1853 B=shadow_weights[18][13] Y=n1848
XU1278 NOR2XL $PINS A=n1839 B=n1848 Y=n1827
XctmTdsLR_2_1844 NAND4XL $PINS A=n1272_CDR1 B=tmp_net336 C=n1273_CDR2
+ D=n1285_CDR1 Y=tmp_net337
XU1280 OR2XL $PINS A=n1835 B=shadow_weights[18][15] Y=n1832
XU1281 NAND2XL $PINS A=n1827 B=n1832 Y=n1781
XU1282 INVXL $PINS A=n125 Y=n134
XU1283 XOR2X1 $PINS A=n130 B=n129 Y=n1813
XU1284 NOR2XL $PINS A=n1813 B=shadow_weights[18][17] Y=n1808
XU1285 XNOR2X1 $PINS A=n134 B=n133 Y=n1823
XU1286 NOR2XL $PINS A=n1823 B=shadow_weights[18][16] Y=n1805
XU1287 NOR2XL $PINS A=n1808 B=n1805 Y=n1782
XctmTdsLR_1_1962 AOI21XL $PINS A0=n1873 A1=n1872 B0=tmp_net408 Y=n1878
XU1289 NOR2XL $PINS A=n1793 B=shadow_weights[18][19] Y=n1788
XU1290 XNOR2X1 $PINS A=n143 B=n142 Y=n1801
XU1291 NOR2XL $PINS A=n1801 B=shadow_weights[18][18] Y=n1786
XU1292 NOR2XL $PINS A=n1788 B=n1786 Y=n227
XU1293 NOR2XL $PINS A=n1781 B=n229 Y=n231
XctmTdsLR_3_1733 NAND3XL $PINS A=n789_CDR1 B=ZBUF_2_42 C=tmp_net257
+ Y=tmp_net258
XU1295 NOR2XL $PINS A=n1874 B=HFSNET_225 Y=n1869
XctmTdsLR_3_2018 INVXL $PINS A=n1436 Y=tmp_net436
XU1297 NOR2XL $PINS A=n1865 B=HFSNET_226 Y=n1860
XU1298 NOR2XL $PINS A=n1869 B=n1860 Y=n222
XU1299 OAI21XL $PINS A0=n218 A1=n214 B0=n215 Y=n163
XU1300 XNOR2X1 $PINS A=n163 B=n162 Y=n1894
XU1301 NOR2XL $PINS A=n1894 B=HFSNET_244 Y=n1879
XU1302 XNOR2X1 $PINS A=n167 B=n166 Y=n1886
XU1303 NOR2XL $PINS A=n1886 B=shadow_weights[18][10] Y=n1881
XU1304 NOR2XL $PINS A=n1879 B=n1881 Y=n1859
XU1307 XOR2XL $PINS A=n171 B=n172 Y=n1965
XU1308 NOR2XL $PINS A=n1965 B=shadow_weights[18][1] Y=n1961
XU1311 OAI21XL $PINS A0=n1961 A1=n1969 B0=n1962 Y=n1955
XU1314 XOR2X1 $PINS A=n180 B=n176 Y=n1957
XU1315 AOI21XL $PINS A0=n1955 A1=n1954 B0=n177 Y=n1947
XU1316 OAI21XL $PINS A0=n180 A1=n179 B0=n178 Y=n185
XU1317 INVXL $PINS A=n186 Y=n200
XU1318 XNOR2X1 $PINS A=n200 B=n188 Y=n1939
XU1319 AOI21XL $PINS A0=n1938 A1=n1936 B0=n189 Y=n1917
XU1320 AOI21XL $PINS A0=n200 A1=n199 B0=n198 Y=n208
XU1321 XOR2X1 $PINS A=n208 B=n202 Y=n1923
XU1322 OR2XL $PINS A=n1923 B=shadow_weights[18][6] Y=n1920
XU1323 OAI21XL $PINS A0=n208 A1=n207 B0=n206 Y=n213
XU1324 NOR2XL $PINS A=n1913 B=shadow_weights[18][7] Y=n1908
XU1325 NOR2XL $PINS A=n1904 B=shadow_weights[18][8] Y=n1899
XU1326 OAI21XL $PINS A0=n1909 A1=n1899 B0=n1900 Y=n219
XU1327 AOI21XL $PINS A0=n1898 A1=n220 B0=n219 Y=n1857
XU1328 NAND2XL $PINS A=n1874 B=HFSNET_225 Y=n1870
XU1329 OAI21XL $PINS A0=n1870 A1=n1860 B0=n1861 Y=n221
XU1330 NAND2XL $PINS A=n1853 B=shadow_weights[18][13] Y=n1849
XU1331 AOI21XL $PINS A0=n1828 A1=n1832 B0=n225 Y=n1780
XU1332 NAND2XL $PINS A=n1823 B=shadow_weights[18][16] Y=n1818
XU1333 OAI21XL $PINS A0=n1808 A1=n1818 B0=n1809 Y=n1783
XU1334 OAI21XL $PINS A0=n1788 A1=n1797 B0=n1789 Y=n226
XU1335 AOI21X1 $PINS A0=n231 A1=n1779 B0=n230 Y=n1749
XU1336 NAND2XL $PINS A=n233 B=n232 Y=n234
XU1337 XNOR2X1 $PINS A=n235 B=n234 Y=n1756
XU1338 OR2XL $PINS A=n1756 B=shadow_weights[18][22] Y=n1753
XctmTdsLR_2_1963 NAND2XL $PINS A=tmp_net407 B=n1870 Y=n1872
XU1340 NOR2XL $PINS A=n1767 B=shadow_weights[18][21] Y=n1762
XU1341 XNOR2X1 $PINS A=n244 B=n243 Y=n1775
XU1342 NOR2XL $PINS A=n1775 B=HFSNET_234 Y=n1760
XU1343 NOR2XL $PINS A=n1762 B=n1760 Y=n1751
XU1344 NAND2XL $PINS A=n1775 B=HFSNET_234 Y=n1771
XU1345 NAND2XL $PINS A=n1745 B=shadow_weights[18][23] Y=n1741
XU1346 NAND2XL $PINS A=n1736 B=shadow_weights[18][24] Y=n1731
XU1347 OAI21XL $PINS A0=n1730 A1=n1741 B0=n1731 Y=n248
XU1348 AOI21XL $PINS A0=n249 A1=n1729 B0=n248 Y=n1724
XU1349 AOI21XL $PINS A0=n253 A1=n252 B0=n251 Y=n258
XU1350 NOR2XL $PINS A=temp_acc[25] B=shadow_weights[17][25] Y=n257
XU1353 XOR2X1 $PINS A=n258 B=n255 Y=n1725
XU1354 NOR2XL $PINS A=n1725 B=shadow_weights[18][25] Y=n1720
XU1355 NAND2XL $PINS A=n1725 B=shadow_weights[18][25] Y=n1721
XU1356 OAI21XL $PINS A0=n258 A1=n257 B0=n256 Y=n264
XU1357 NAND2XL $PINS A=n263 B=n261 Y=n259
XU1358 OR2XL $PINS A=n1716 B=HFSNET_241 Y=n1713
XU1359 NAND2XL $PINS A=n1716 B=HFSNET_241 Y=n1712
XU1360 AOI21XL $PINS A0=n1715 A1=n1713 B0=n260 Y=n1707
XU1361 AOI21XL $PINS A0=n264 A1=n263 B0=n262 Y=n269
XctmTdsLR_2_2047 NAND2XL $PINS A=tmp_net452 B=n423 Y=tmp_net219
XU1365 NOR2XL $PINS A=n1708 B=shadow_weights[18][27] Y=n1703
XU1366 NAND2XL $PINS A=n1708 B=shadow_weights[18][27] Y=n1704
XU1367 OAI21XL $PINS A0=n269 A1=n268 B0=n267 Y=n283
XU1368 NAND2XL $PINS A=n282 B=n280 Y=n270
XU1369 OR2XL $PINS A=n272 B=shadow_weights[18][28] Y=n278
XU1370 NAND2XL $PINS A=n272 B=shadow_weights[18][28] Y=n276
XU1371 NAND2XL $PINS A=n278 B=n276 Y=n271
XctmTdsLR_3_1964 INVXL $PINS A=n1869 Y=tmp_net407
XU1373 NOR2XL $PINS A=n2178 B=target_bit[3] Y=n1993
XU1375 NOR2XL $PINS A=n67 B=n2171 Y=n723
XU1376 AND2X2 $PINS A=n1991 B=n723 Y=n733
XU1377 AOI211XL $PINS A0=HFSNET_345 A1=n2208 B0=n273 C0=HFSNET_348 Y=n274
XU1378 AOI21XL $PINS A0=n279 A1=n278 B0=n277 Y=n291
XU1379 AOI21XL $PINS A0=n283 A1=n282 B0=n281 Y=n287
XU1383 XOR2X1 $PINS A=n287 B=n286 Y=n293
XctmTdsLR_4_1965 NOR2XL $PINS A=n1873 B=n1872 Y=tmp_net408
XU1385 AOI211XL $PINS A0=HFSNET_345 A1=n2214 B0=n294 C0=HFSNET_348 Y=n295
XU1386 OAI21XL $PINS A0=n296 A1=HFSNET_346 B0=n295 Y=n894
XU1387 NAND3XL $PINS A=wr_idx_r[1] B=n65 C=n2160 Y=n667
XU1388 NAND2X1 $PINS A=n559 B=wr_idx_r[2] Y=n577
XHFSINV_11_511 INVXL $PINS A=N1838 Y=HFSNET_253
XU1390 NAND3XL $PINS A=n2177 B=n65 C=n2160 Y=n600
XU1391 NOR2X2 $PINS A=n600 B=n577 Y=N1838
XU1392 NAND3XL $PINS A=wr_idx_r[1] B=wr_idx_r[3] C=n65 Y=n668
XU1393 NOR2X2 $PINS A=n577 B=n668 Y=N1828
XU1394 NAND3XL $PINS A=wr_idx_r[3] B=n2177 C=n65 Y=n598
XU1395 NOR2X4 $PINS A=n577 B=n598 Y=N1830
XU1396 NOR2X2 $PINS A=n669 B=n600 Y=N1842
XU1397 NOR2X2 $PINS A=n669 B=n598 Y=N1834
XctmTdsLR_1_764 AOI222XL $PINS A0=n1671 A1=shadow_weights[18][0] B0=n1673
+ B1=shadow_weights[17][0] C0=shadow_weights[19][0] C1=n1281 Y=tmp_net77
XctmTdsLR_2_1783 AND4XL $PINS A=tmp_net57 B=tmp_net55 C=tmp_net58 D=tmp_net56
+ Y=tmp_net288
XctmTdsLR_1_859 AOI222XL $PINS A0=n1291 A1=shadow_weights[13][12] B0=n1290
+ B1=shadow_weights[6][12] C0=n1292 C1=shadow_weights[2][12] Y=tmp_net136
XctmTdsLR_1_767 NAND2X2 $PINS A=n672_CDR1 B=n673_CDR1 Y=HFSNET_20
XU1402 NAND2XL $PINS A=n2160 B=wr_idx_r[4] Y=n670
XU1403 NAND2BXL $PINS AN=n670 B=wr_idx_r[1] Y=n665
XU1404 NAND2XL $PINS A=wr_idx_r[0] B=n2159 Y=n658
XU1405 NOR2XL $PINS A=n815 B=n658 Y=n666
XU1407 AOI21XL $PINS A0=n2189 A1=n318 B0=n2133 Y=n317
XU1408 OAI21XL $PINS A0=n2118 A1=n318 B0=n317 Y=n757
XU1409 NAND2XL $PINS A=n639 B=n638 Y=n722
XU1410 AND2XL $PINS A=n722 B=n815 Y=n774
XU1411 INVXL $PINS A=comp_out Y=n825
XU1412 OR2XL $PINS A=avg_cnt[0] B=n322 Y=n967
XU1413 NAND2XL $PINS A=target_bit[0] B=gre_a_INV_2893_58 Y=n892
XU1414 NOR3XL $PINS A=n67 B=state[2] C=state[0] Y=n652
XU1415 NAND2XL $PINS A=state[3] B=n652 Y=n1416
XU1416 NAND2XL $PINS A=gre_a_INV_2154_58 B=avg_rounded_r[22] Y=n843
XU1417 NAND2XL $PINS A=gre_a_INV_2154_58 B=avg_rounded_r[34] Y=n831
XU1418 NAND2XL $PINS A=gre_a_INV_2154_58 B=avg_rounded_r[23] Y=n842
XU1419 NAND2XL $PINS A=gre_a_INV_2154_58 B=avg_rounded_r[6] Y=n859
XU1420 NAND2XL $PINS A=gre_a_INV_2154_58 B=avg_rounded_r[25] Y=n840
XU1421 NAND2XL $PINS A=gre_a_INV_2154_58 B=avg_rounded_r[24] Y=n841
XU1422 NAND2XL $PINS A=gre_a_INV_2154_58 B=avg_rounded_r[29] Y=n836
XU1423 NAND2XL $PINS A=gre_a_INV_2154_58 B=avg_rounded_r[27] Y=n838
XU1424 NAND2XL $PINS A=gre_a_INV_2154_58 B=avg_rounded_r[31] Y=n834
XU1425 NAND2XL $PINS A=gre_a_INV_2154_58 B=avg_rounded_r[30] Y=n835
XU1426 NAND2XL $PINS A=gre_a_INV_2154_58 B=avg_rounded_r[32] Y=n833
XU1427 NAND2XL $PINS A=gre_a_INV_2154_58 B=avg_rounded_r[33] Y=n832
XU1428 NAND2XL $PINS A=gre_a_INV_2154_58 B=avg_rounded_r[35] Y=n830
XU1429 NAND2XL $PINS A=gre_a_INV_2154_58 B=avg_rounded_r[28] Y=n837
XU1430 NAND2XL $PINS A=gre_a_INV_2154_58 B=avg_rounded_r[21] Y=n844
XU1431 NAND2XL $PINS A=gre_a_INV_2154_58 B=avg_rounded_r[26] Y=n839
XU1432 NAND2XL $PINS A=gre_a_INV_2154_58 B=avg_rounded_r[20] Y=n845
XU1433 NAND2XL $PINS A=overrange_acc B=gre_a_INV_2893_58 Y=n893
XU1434 OR2XL $PINS A=meas_val_p[0] B=accumulator[0] Y=n328
XU1435 NAND2XL $PINS A=meas_val_p[0] B=accumulator[0] Y=n326
XU1436 NAND2XL $PINS A=n328 B=n326 Y=n321
XU1437 XNOR2XL $PINS A=n321 B=meas_val_n[0] Y=n323
XU1438 NAND2XL $PINS A=n323 B=HFSNET_347 Y=n962
XU1439 NOR2XL $PINS A=n324 B=meas_val_n[1] Y=n336
XU1441 NAND2XL $PINS A=n324 B=meas_val_n[1] Y=n335
XU1443 INVXL $PINS A=n326 Y=n327
XU1444 AOI21XL $PINS A0=n328 A1=meas_val_n[0] B0=n327 Y=n337
XU1445 XOR2XL $PINS A=n329 B=n337 Y=n330
XU1446 NAND2XL $PINS A=n330 B=HFSNET_347 Y=n961
XU1447 NAND2XL $PINS A=gre_a_INV_2893_58 B=accumulator[23] Y=n872
XU1448 NAND2XL $PINS A=gre_a_INV_2893_58 B=accumulator[22] Y=n873
XU1449 NAND2XL $PINS A=gre_a_INV_2893_58 B=accumulator[21] Y=n874
XU1450 NAND2XL $PINS A=gre_a_INV_2893_58 B=accumulator[9] Y=n886
XU1451 NAND2XL $PINS A=gre_a_INV_2893_58 B=accumulator[19] Y=n876
XU1452 NAND2XL $PINS A=gre_a_INV_2893_58 B=accumulator[7] Y=n888
XU1453 NAND2XL $PINS A=gre_a_INV_2893_58 B=accumulator[15] Y=n880
XctmTdsLR_2_955 NAND2XL $PINS A=n1319 B=shadow_weights[13][20] Y=tmp_net203
XctmTdsLR_1_768 NAND2XL $PINS A=n1278 B=shadow_weights[8][12] Y=tmp_net79
XU1456 NAND2XL $PINS A=gre_a_INV_2893_58 B=accumulator[17] Y=n878
XU1457 NAND2XL $PINS A=gre_a_INV_2893_58 B=accumulator[14] Y=n881
XU1458 NAND2XL $PINS A=gre_a_INV_2893_58 B=accumulator[8] Y=n887
XU1459 NAND2XL $PINS A=gre_a_INV_2893_58 B=accumulator[10] Y=n885
XctmTdsLR_3_956 NAND4X1 $PINS A=tmp_net202 B=n1340_CDR2 C=n1337 D=tmp_net203
+ Y=HFSNET_154
XctmTdsLR_2_769 NAND2XL $PINS A=n1277 B=shadow_weights[10][12] Y=tmp_net80
XU1462 NAND2XL $PINS A=gre_a_INV_2893_58 B=accumulator[20] Y=n875
XU1463 NAND2XL $PINS A=gre_a_INV_2893_58 B=accumulator[16] Y=n879
XU1464 NAND2XL $PINS A=target_bit[4] B=gre_a_INV_2893_58 Y=n890
XU1465 NAND2XL $PINS A=target_bit[3] B=gre_a_INV_2893_58 Y=n891
XU1466 ADDHXL $PINS A=meas_val_p[1] B=accumulator[1] CO=n332 S=n324
XU1467 NOR2XL $PINS A=n333 B=n332 Y=n354
XU1469 NAND2XL $PINS A=n333 B=n332 Y=n356
XU1471 INVXL $PINS A=n359 Y=n347
XU1472 XOR2XL $PINS A=n338 B=n347 Y=n339
XU1473 NAND2XL $PINS A=n339 B=HFSNET_347 Y=n960
XU1474 NOR3XL $PINS A=HFSNET_290 B=n2162 C=n2177 Y=n340
XU1475 NAND2XL $PINS A=wr_idx_r[3] B=n340 Y=n1987
XU1476 OAI211XL $PINS A0=wr_idx_r[3] A1=n340 B0=N1822 C0=n1987 Y=n828
XU1477 NAND2XL $PINS A=gre_a_INV_2154_58 B=avg_rounded_r[9] Y=n856
XU1478 NAND2XL $PINS A=gre_a_INV_2154_58 B=avg_rounded_r[15] Y=n850
XU1479 NAND2XL $PINS A=gre_a_INV_2154_58 B=avg_rounded_r[12] Y=n853
XU1480 NAND2XL $PINS A=gre_a_INV_2154_58 B=avg_rounded_r[10] Y=n855
XU1481 NAND2XL $PINS A=gre_a_INV_2154_58 B=avg_rounded_r[16] Y=n849
XU1482 NAND2XL $PINS A=gre_a_INV_2154_58 B=avg_rounded_r[7] Y=n858
XU1483 NAND2XL $PINS A=gre_a_INV_2154_58 B=avg_rounded_r[18] Y=n847
XU1484 NAND2XL $PINS A=gre_a_INV_2154_58 B=avg_rounded_r[11] Y=n854
XU1485 NAND2XL $PINS A=gre_a_INV_2154_58 B=avg_rounded_r[8] Y=n857
XU1486 NAND2XL $PINS A=gre_a_INV_2154_58 B=avg_rounded_r[13] Y=n852
XU1487 NAND2XL $PINS A=gre_a_INV_2154_58 B=avg_rounded_r[17] Y=n848
XU1488 NAND2XL $PINS A=gre_a_INV_2154_58 B=avg_rounded_r[14] Y=n851
XU1489 NAND2XL $PINS A=gre_a_INV_2154_58 B=avg_rounded_r[19] Y=n846
XU1490 NAND2XL $PINS A=gre_a_INV_2893_58 B=accumulator[25] Y=n870
XU1491 NAND2XL $PINS A=gre_a_INV_2893_58 B=accumulator[32] Y=n863
XU1492 NAND2XL $PINS A=gre_a_INV_2893_58 B=accumulator[26] Y=n869
XU1493 NAND2XL $PINS A=gre_a_INV_2893_58 B=accumulator[33] Y=n862
XU1494 NAND2XL $PINS A=gre_a_INV_2893_58 B=accumulator[28] Y=n867
XU1495 NAND2XL $PINS A=gre_a_INV_2893_58 B=accumulator[31] Y=n864
XU1496 NAND2XL $PINS A=gre_a_INV_2893_58 B=accumulator[30] Y=n865
XU1497 NAND2XL $PINS A=gre_a_INV_2893_58 B=accumulator[34] Y=n861
XU1498 NAND2XL $PINS A=gre_a_INV_2893_58 B=accumulator[27] Y=n868
XU1499 NAND2XL $PINS A=gre_a_INV_2893_58 B=accumulator[29] Y=n866
XU1500 NAND2XL $PINS A=gre_a_INV_2893_58 B=accumulator[13] Y=n882
XU1501 NAND2XL $PINS A=gre_a_INV_2893_58 B=accumulator[24] Y=n871
XU1502 NAND2XL $PINS A=gre_a_INV_2893_58 B=accumulator[35] Y=n860
XU1503 NAND2XL $PINS A=avg_cnt[1] B=avg_cnt[0] Y=n343
XU1504 OAI211XL $PINS A0=avg_cnt[1] A1=avg_cnt[0] B0=HFSNET_347 C0=n343 Y=n966
XU1505 INVXL $PINS A=n343 Y=n344
XU1506 OAI211XL $PINS A0=n344 A1=avg_cnt[2] B0=HFSNET_347 C0=n345 Y=n965
XU1507 INVXL $PINS A=n345 Y=n346
XU1508 OAI211XL $PINS A0=n346 A1=avg_cnt[3] B0=HFSNET_347 C0=n1978 Y=n964
XU1509 OAI21XL $PINS A0=n347 A1=n354 B0=n356 Y=n352
XU1510 CMPR32X1 $PINS A=meas_val_p[2] B=meas_val_n[2] C=accumulator[2] CO=n348
+ S=n333
XU1511 NOR2XL $PINS A=n349 B=n348 Y=n357
XU1513 NAND2XL $PINS A=n349 B=n348 Y=n355
XctmTdsLR_2_2000 NAND2XL $PINS A=n604 B=n596 Y=tmp_net428
XU1516 NAND2XL $PINS A=n353 B=HFSNET_347 Y=n959
XU1517 NOR2XL $PINS A=n357 B=n354 Y=n360
XU1518 OAI21XL $PINS A0=n357 A1=n356 B0=n355 Y=n358
XU1519 AOI21XL $PINS A0=n360 A1=n359 B0=n358 Y=n376
XU1520 CMPR32X1 $PINS A=meas_val_p[3] B=meas_val_n[3] C=accumulator[3] CO=n361
+ S=n349
XU1521 NOR2XL $PINS A=n362 B=n361 Y=n365
XU1522 INVXL $PINS A=n365 Y=n425
XU1523 NAND2XL $PINS A=n362 B=n361 Y=n423
XU1524 NAND2XL $PINS A=n425 B=n423 Y=n363
XU1525 XNOR2XL $PINS A=n443 B=n363 Y=n364
XU1526 NAND2XL $PINS A=n364 B=HFSNET_347 Y=n958
XU1527 CMPR32X1 $PINS A=meas_val_p[4] B=meas_val_n[4] C=accumulator[4] CO=n366
+ S=n362
XU1528 NOR2XL $PINS A=n367 B=n366 Y=n426
XU1529 NOR2XL $PINS A=n426 B=n365 Y=n442
XU1530 CMPR32X1 $PINS A=meas_val_p[5] B=meas_val_n[5] C=accumulator[5] CO=n368
+ S=n367
XU1531 NOR2XL $PINS A=n369 B=n368 Y=n477
XU1532 ADDFX1 $PINS A=meas_val_p[6] B=meas_val_n[6] CI=accumulator[6] CO=n370
+ S=n369
XU1533 NOR2XL $PINS A=n371 B=n370 Y=n479
XU1534 NOR2XL $PINS A=n477 B=n479 Y=n373
XU1535 NAND2XL $PINS A=n442 B=n373 Y=n375
XU1536 NAND2XL $PINS A=n367 B=n366 Y=n427
XU1537 NAND2XL $PINS A=n369 B=n368 Y=n476
XU1538 OAI21XL $PINS A0=n476 A1=n479 B0=n480 Y=n372
XU1539 AOI21XL $PINS A0=n373 A1=n441 B0=n372 Y=n374
XU1540 OAI21XL $PINS A0=n376 A1=n375 B0=n374 Y=n403
XU1541 INVXL $PINS A=n403 Y=n521
XU1542 CMPR32X1 $PINS A=meas_val_p[7] B=meas_val_n[7] C=accumulator[7] CO=n377
+ S=n371
XU1543 NOR2XL $PINS A=n378 B=n377 Y=n448
XU1545 NAND2XL $PINS A=n378 B=n377 Y=n447
XU1547 XOR2XL $PINS A=n521 B=n380 Y=n381
XU1548 NAND2XL $PINS A=n381 B=HFSNET_347 Y=n955
XU1549 CMPR32X1 $PINS A=meas_val_p[8] B=meas_val_n[8] C=accumulator[8] CO=n382
+ S=n378
XU1550 NOR2XL $PINS A=n383 B=n382 Y=n449
XU1551 NOR2XL $PINS A=n448 B=n449 Y=n466
XU1552 CMPR32X1 $PINS A=meas_val_p[9] B=meas_val_n[9] C=accumulator[9] CO=n384
+ S=n383
XU1553 NOR2XL $PINS A=n385 B=n384 Y=n470
XU1554 ADDFX1 $PINS A=meas_val_p[10] B=meas_val_n[10] CI=accumulator[10]
+ CO=n386 S=n385
XU1555 NOR2XL $PINS A=n387 B=n386 Y=n540
XU1556 NOR2XL $PINS A=n470 B=n540 Y=n389
XU1557 NAND2XL $PINS A=n466 B=n389 Y=n520
XU1558 CMPR32X1 $PINS A=meas_val_p[11] B=meas_val_n[11] C=accumulator[11]
+ CO=n390 S=n387
XU1559 NOR2XL $PINS A=n391 B=n390 Y=n522
XU1560 ADDFX1 $PINS A=meas_val_p[12] B=meas_val_n[12] CI=accumulator[12]
+ CO=n392 S=n391
XU1561 NOR2XL $PINS A=n393 B=n392 Y=n524
XU1562 NOR2XL $PINS A=n522 B=n524 Y=n590
XU1563 CMPR32X1 $PINS A=meas_val_p[13] B=meas_val_n[13] C=accumulator[13]
+ CO=n394 S=n393
XU1564 NOR2XL $PINS A=n395 B=n394 Y=n595
XU1565 ADDFX1 $PINS A=meas_val_p[14] B=meas_val_n[14] CI=accumulator[14]
+ CO=n396 S=n395
XU1566 NOR2XL $PINS A=n397 B=n396 Y=n605
XU1567 NOR2XL $PINS A=n595 B=n605 Y=n399
XU1568 NAND2XL $PINS A=n590 B=n399 Y=n401
XU1569 NOR2XL $PINS A=n520 B=n401 Y=n404
XU1570 NAND2XL $PINS A=n383 B=n382 Y=n450
XU1571 NAND2XL $PINS A=n385 B=n384 Y=n536
XU1572 NAND2XL $PINS A=n387 B=n386 Y=n541
XU1573 OAI21XL $PINS A0=n540 A1=n536 B0=n541 Y=n388
XU1574 AOI21XL $PINS A0=n389 A1=n467 B0=n388 Y=n519
XU1575 NAND2XL $PINS A=n391 B=n390 Y=n532
XU1576 NAND2XL $PINS A=n395 B=n394 Y=n601
XU1577 OAI21XL $PINS A0=n605 A1=n601 B0=n606 Y=n398
XU1578 OAI21XL $PINS A0=n519 A1=n401 B0=n400 Y=n402
XU1579 AOI21X1 $PINS A0=n404 A1=n403 B0=n402 Y=n455
XU1580 CMPR32X1 $PINS A=meas_val_p[15] B=meas_val_n[15] C=accumulator[15]
+ CO=n405 S=n397
XU1581 NOR2XL $PINS A=n406 B=n405 Y=n456
XU1582 ADDFHXL $PINS A=meas_val_p[16] B=meas_val_n[16] CI=accumulator[16]
+ CO=n407 S=n406
XU1583 NOR2XL $PINS A=n408 B=n407 Y=n502
XU1584 NOR2XL $PINS A=n456 B=n502 Y=n486
XU1585 CMPR32X1 $PINS A=meas_val_p[17] B=meas_val_n[17] C=accumulator[17]
+ CO=n409 S=n408
XU1586 OR2XL $PINS A=n410 B=n409 Y=n488
XU1587 NAND2XL $PINS A=n486 B=n488 Y=n546
XU1588 ADDFHXL $PINS A=meas_val_p[18] B=meas_val_n[18] CI=accumulator[18]
+ CO=n412 S=n410
XU1589 NOR2XL $PINS A=n413 B=n412 Y=n551
XU1590 NOR2XL $PINS A=n546 B=n551 Y=n493
XU1591 ADDFHXL $PINS A=meas_val_p[19] B=meas_val_n[19] CI=accumulator[19]
+ CO=n414 S=n413
XU1592 OR2XL $PINS A=n415 B=n414 Y=n495
XU1593 NAND2XL $PINS A=n493 B=n495 Y=n418
XU1594 NAND2XL $PINS A=n406 B=n405 Y=n499
XU1595 NAND2XL $PINS A=n408 B=n407 Y=n503
XU1596 AOI21XL $PINS A0=n485 A1=n488 B0=n411 Y=n547
XU1598 CMPR32X1 $PINS A=meas_val_p[20] B=meas_val_n[20] C=accumulator[20]
+ CO=n419 S=n415
XU1599 NAND2XL $PINS A=n434 B=n432 Y=n421
XctmTdsLR_3_770 AOI222XL $PINS A0=HFSNET_226 A1=n1280 B0=n1282 B1=HFSNET_209
+ C0=shadow_weights[19][12] C1=n1281 Y=tmp_net81
XZBUF_2_inst_1037 BUFXL $PINS A=tmp_net15 Y=ZBUF_2_17
XZBUF_2_inst_1038 CLKBUFX3 $PINS A=tmp_net111 Y=ZBUF_2_18
XctmTdsLR_3_1845 AOI211XL $PINS A0=gre_a_INV_6610_58 A1=shadow_weights[11][18]
+ B0=tmp_net334 C0=tmp_net335 Y=tmp_net336
XHFSINV_370_552 CLKINVX1 $PINS A=n968 Y=HFSNET_291
XU1607 AOI21XL $PINS A0=n431 A1=HFSNET_347 B0=HFSNET_291 Y=n817
XU1608 AOI21XL $PINS A0=n435 A1=n434 B0=n433 Y=n461
XU1609 ADDFHXL $PINS A=meas_val_p[21] B=meas_val_n[21] CI=accumulator[21]
+ CO=n436 S=n420
XctmTdsLR_4_771 NAND2XL $PINS A=n1279 B=shadow_weights[16][12] Y=tmp_net82
XU1613 AOI21XL $PINS A0=n443 A1=n442 B0=n441 Y=n478
XU1616 XOR2XL $PINS A=n478 B=n445 Y=n446
XU1617 NAND2XL $PINS A=n446 B=HFSNET_347 Y=n957
XU1618 OAI21XL $PINS A0=n521 A1=n448 B0=n447 Y=n453
XU1621 XNOR2XL $PINS A=n453 B=n452 Y=n454
XU1622 NAND2XL $PINS A=n454 B=HFSNET_347 Y=n954
XU1623 INVXL $PINS A=n456 Y=n501
XU1624 NAND2XL $PINS A=n501 B=n499 Y=n457
XU1625 XNOR2XL $PINS A=n550 B=n457 Y=n458
XU1626 NAND2XL $PINS A=n458 B=HFSNET_347 Y=n948
XU1627 ADDFHXL $PINS A=meas_val_p[22] B=meas_val_n[22] CI=accumulator[22]
+ CO=n462 S=n437
XU1628 NAND2XL $PINS A=n510 B=n508 Y=n464
XctmTdsLR_2_860 NAND2XL $PINS A=ZBUF_20020_1 B=shadow_weights[0][12]
+ Y=tmp_net137
XctmTdsLR_1_1908 NAND2XL $PINS A=n1296_CDR1 B=tmp_net378 Y=HFSNET_160
XU1632 INVXL $PINS A=n470 Y=n538
XU1633 NAND2XL $PINS A=n538 B=n536 Y=n471
XU1634 XNOR2XL $PINS A=n539 B=n471 Y=n472
XU1635 NAND2XL $PINS A=n472 B=HFSNET_347 Y=n953
XU1636 AOI2BB1XL $PINS A0N=n579 A1N=wait_cnt[4] B0=n2076 Y=n475
XU1637 INVXL $PINS A=n573 Y=n473
XU1638 AOI21XL $PINS A0=n475 A1=n474 B0=n473 Y=n790
XU1639 NAND2XL $PINS A=n1875 B=n2173 Y=n973
XU1640 OAI21XL $PINS A0=n478 A1=n477 B0=n476 Y=n483
XU1643 XNOR2XL $PINS A=n483 B=n482 Y=n484
XU1644 NAND2XL $PINS A=n484 B=HFSNET_347 Y=n956
XU1645 NAND2XL $PINS A=n488 B=n487 Y=n489
XU1646 NAND2XL $PINS A=n491 B=HFSNET_347 Y=n946
XU1647 NAND2XL $PINS A=n495 B=n494 Y=n496
XU1648 NAND2XL $PINS A=n498 B=HFSNET_347 Y=n944
XctmTdsLR_5_772 NAND4XL $PINS A=tmp_net79 B=tmp_net80 C=tmp_net81 D=tmp_net82
+ Y=HFSNET_41
XU1652 NAND2XL $PINS A=n507 B=HFSNET_347 Y=n947
XU1653 AOI21XL $PINS A0=n511 A1=n510 B0=n509 Y=n563
XU1654 ADDFHXL $PINS A=meas_val_p[23] B=meas_val_n[23] CI=accumulator[23]
+ CO=n512 S=n463
XZCTSBUF_255_1346 BUFX12 $PINS A=net1736 Y=ZCTSNET_393
XU1658 AOI22XL $PINS A0=target_bit[0] A1=n2158 B0=target_bit[1] B1=n2163 Y=n518
XU1660 AOI21XL $PINS A0=n2100 A1=n2132 B0=n2076 Y=n517
XU1661 AOI21XL $PINS A0=n518 A1=n2078 B0=n517 Y=n792
XU1662 INVXL $PINS A=n522 Y=n533
XU1663 INVXL $PINS A=n532 Y=n523
XU1666 XOR2XL $PINS A=n528 B=n527 Y=n530
XU1667 AOI21XL $PINS A0=n530 A1=HFSNET_347 B0=HFSNET_291 Y=n818
XU1668 NAND2XL $PINS A=n533 B=n532 Y=n534
XU1669 NAND2XL $PINS A=n535 B=HFSNET_347 Y=n951
XU1670 INVXL $PINS A=n536 Y=n537
XU1673 NAND2XL $PINS A=n545 B=HFSNET_347 Y=n952
XU1674 NOR2XL $PINS A=calc_cnt[0] B=calc_cnt[1] Y=n617
XU1675 NAND2XL $PINS A=calc_cnt[0] B=calc_cnt[1] Y=n618
XU1676 NAND3XL $PINS A=n1875 B=n629 C=n618 Y=n972
XctmTdsLR_1_773 NAND2XL $PINS A=n1278 B=shadow_weights[8][13] Y=tmp_net83
XctmTdsLR_2_774 NAND2XL $PINS A=n1277 B=shadow_weights[10][13] Y=tmp_net84
XU1681 NAND2XL $PINS A=n556 B=HFSNET_347 Y=n945
XU1682 NAND2XL $PINS A=n557 B=calc_cnt[2] Y=n614
XU1683 OAI211XL $PINS A0=calc_cnt[2] A1=n557 B0=n1875 C0=n614 Y=n971
XU1684 INVXL $PINS A=n614 Y=n558
XU1686 OAI211XL $PINS A0=calc_cnt[3] A1=n558 B0=n1875 C0=n1698 Y=n970
XU1687 INVXL $PINS A=n2076 Y=n1629
XU1688 AOI22XL $PINS A0=n2078 A1=n2163 B0=n2199 B1=n1629 Y=n791
XU1689 NOR2XL $PINS A=wr_idx_r[1] B=n815 Y=n576
XU1690 AOI22XL $PINS A0=wr_idx_r[1] A1=n559 B0=wr_idx_r[0] B1=n576 Y=n560
XU1691 INVXL $PINS A=n638 Y=n1658
XU1692 NAND3XL $PINS A=n639 B=n68 C=n2172 Y=n1657
XU1693 NAND3XL $PINS A=n560 B=n1658 C=n1657 Y=N1490
XU1694 ADDFHXL $PINS A=meas_val_p[24] B=meas_val_n[24] CI=accumulator[24]
+ CO=n564 S=n513
XU1695 NAND2XL $PINS A=n583 B=n581 Y=n566
XU1696 INVXL $PINS A=n2072 Y=n1992
XU1697 NAND2XL $PINS A=n1992 B=n2202 Y=n571
XU1698 OAI21XL $PINS A0=n1992 A1=n2202 B0=n571 Y=n569
XU1699 NOR2XL $PINS A=n2100 B=sar_ptr[2] Y=n2074
XU1700 NAND2XL $PINS A=n2074 B=n1 Y=n570
XU1701 OAI21XL $PINS A0=n2074 A1=n1 B0=n570 Y=n568
XU1702 AOI22XL $PINS A0=n2078 A1=n569 B0=n1629 B1=n568 Y=n794
XU1703 NOR2XL $PINS A=n570 B=sar_ptr[4] Y=n1626
XU1704 AOI21XL $PINS A0=n570 A1=sar_ptr[4] B0=n1626 Y=n574
XU1705 AOI22XL $PINS A0=target_bit[4] A1=n571 B0=n2020 B1=n1992 Y=n572
XU1706 OAI22XL $PINS A0=n2076 A1=n574 B0=n573 B1=n572 Y=n575
XU1707 INVXL $PINS A=n575 Y=n820
XU1708 AOI22XL $PINS A0=wr_idx_r[1] A1=n666 B0=wr_idx_r[2] B1=n576 Y=n578
XU1709 NAND4XL $PINS A=n578 B=n1658 C=n1657 D=n577 Y=N1491
XU1710 AOI32XL $PINS A0=wait_cnt[1] A1=n641 A2=wait_cnt[0] B0=n1984 B1=n641
+ Y=n926
XU1711 AOI32XL $PINS A0=wait_cnt[3] A1=n641 A2=n580 B0=n579 B1=n641 Y=n924
XU1712 AOI21XL $PINS A0=n584 A1=n583 B0=n582 Y=n644
XU1713 ADDFHXL $PINS A=meas_val_p[25] B=meas_val_n[25] CI=accumulator[25]
+ CO=n585 S=n565
XctmTdsLR_1_1887 OR4X1 $PINS A=tmp_net177 B=tmp_net176 C=tmp_net340
+ D=tmp_net362 Y=HFSNET_164
XctmTdsLR_2_1785 NAND4XL $PINS A=tmp_net289 B=tmp_net290 C=tmp_net291
+ D=tmp_net292 Y=tmp_net293
XU1718 INVXL $PINS A=n595 Y=n603
XU1719 NAND2XL $PINS A=n603 B=n601 Y=n596
XU1720 NAND2XL $PINS A=n597 B=HFSNET_347 Y=n950
XU1721 NAND3XL $PINS A=N1822 B=wr_idx_r[2] C=wr_idx_r[0] Y=n599
XU1722 NOR2XL $PINS A=n668 B=n599 Y=N1827
XHFSINV_11_530 INVXL $PINS A=N1835 Y=HFSNET_270
XU1724 NOR2X1 $PINS A=n667 B=n599 Y=N1835
XU1725 NOR2X1 $PINS A=n600 B=n599 Y=N1837
XU1726 INVXL $PINS A=n601 Y=n602
XU1729 NAND2XL $PINS A=n610 B=HFSNET_347 Y=n949
XU1730 NOR2XL $PINS A=calc_cnt[2] B=calc_cnt[3] Y=n1659
XU1732 OR2XL $PINS A=n631 B=n626 Y=n1297
XU1733 OR2X1 $PINS A=n631 B=n618 Y=n1298
XU1734 NOR2XL $PINS A=n2176 B=calc_cnt[4] Y=n611
XU1735 NAND2XL $PINS A=n611 B=n2175 Y=n628
XU1736 OR2XL $PINS A=n628 B=n629 Y=n1299
XU1737 OR2XL $PINS A=n628 B=n626 Y=n1300
XctmTdsLR_3_1786 NAND2XL $PINS A=gre_a_INV_6625_58 B=shadow_weights[15][5]
+ Y=tmp_net289
XU1739 NAND2XL $PINS A=n611 B=calc_cnt[3] Y=n627
XU1740 OR2XL $PINS A=n627 B=n629 Y=n1301
XU1741 OR2XL $PINS A=n627 B=n630 Y=n1302
XctmTdsLR_4_1787 NAND2XL $PINS A=ZBUF_20020_1 B=shadow_weights[0][5]
+ Y=tmp_net290
XctmTdsLR_3_861 NAND4XL $PINS A=n1174 B=n1175 C=tmp_net136 D=tmp_net137
+ Y=tmp_net138
XHFSINV_256_603 INVX4 $PINS A=n1210 Y=HFSNET_342
XctmTdsLR_1_957 AOI22XL $PINS A0=n1291 A1=shadow_weights[13][14] B0=n1290
+ B1=shadow_weights[6][14] Y=tmp_net204
XU1746 NAND3XL $PINS A=n2176 B=n2161 C=calc_cnt[3] Y=n616
XU1747 OR2XL $PINS A=n616 B=n618 Y=n1305
XU1748 OR2XL $PINS A=n616 B=n626 Y=n1306
XU1749 AOI22XL $PINS A0=gre_a_INV_6610_58 A1=shadow_weights[11][0] B0=n1274
+ B1=shadow_weights[9][0] Y=n615
XU1750 OR2XL $PINS A=n616 B=n629 Y=n1308
XU1751 OR2XL $PINS A=n616 B=n630 Y=n1309
XU1752 AOI22X1 $PINS A0=n1277 A1=shadow_weights[10][0] B0=n1278
+ B1=shadow_weights[8][0] Y=n621
XU1753 OR2X1 $PINS A=n630 B=n2161 Y=n675
XctmTdsLR_4_862 OR4X2 $PINS A=n1173_CDR1 B=HFSNET_41 C=n1172_CDR1 D=tmp_net138
+ Y=HFSNET_171
XU1755 OR2X1 $PINS A=n626 B=n2161 Y=n676
XU1756 OR2XL $PINS A=n618 B=n2161 Y=n1311
XctmTdsLR_1_863 AOI222XL $PINS A0=n1686 A1=shadow_weights[6][21] B0=n1687
+ B1=shadow_weights[2][21] C0=ZBUF_20020_1 C1=shadow_weights[0][21] Y=tmp_net139
XctmTdsLR_2_864 OAI2BB1XL $PINS A0N=shadow_weights[15][21]
+ A1N=gre_a_INV_6625_58 B0=tmp_net139 Y=tmp_net140
XctmTdsLR_3_865 AOI21XL $PINS A0=n1319 A1=shadow_weights[13][21] B0=tmp_net140
+ Y=tmp_net141
XU1760 OR2XL $PINS A=n628 B=n630 Y=n1320
XU1761 OR2X1 $PINS A=n631 B=n630 Y=n1322
XU1762 OR2XL $PINS A=n1698 B=calc_cnt[4] Y=n993
XZCTSBUF_255_1347 CLKBUFX8 $PINS A=net1741 Y=ZCTSNET_394
XU1766 AND2X4 $PINS A=n659 B=n1657 Y=n640
XctmTdsLR_3_1987 INVXL $PINS A=n357 Y=tmp_net420
XU1768 AOI22XL $PINS A0=n2157 A1=N1822 B0=n640 B1=calib_overrange Y=n698
XU1769 INVXL $PINS A=n641 Y=n1982
XU1770 OR2XL $PINS A=wait_cnt[0] B=n1982 Y=n927
XU1771 ADDFHXL $PINS A=meas_val_p[26] B=meas_val_n[26] CI=accumulator[26]
+ CO=n645 S=n586
XctmTdsLR_2_1909 AOI21X1 $PINS A0=ZBUF_20020_1 A1=shadow_weights[0][18]
+ B0=tmp_net377 Y=tmp_net378
XU1773 NOR2BX2 $PINS AN=avg_cnt[4] B=n1978 Y=n1979
XU1774 NAND2XL $PINS A=n1627 B=n1626 Y=n1693
XctmTdsLR_4_866 NAND2X2 $PINS A=n1354_CDR1 B=tmp_net141 Y=HFSNET_162
XctmTdsLR_1_867 AOI222XL $PINS A0=n1686 A1=shadow_weights[6][19] B0=n1687
+ B1=shadow_weights[2][19] C0=ZBUF_20020_1 C1=shadow_weights[0][19] Y=tmp_net142
XU1778 AOI211XL $PINS A0=n725 A1=n1693 B0=n652 C0=n651 Y=n660
XU1779 OAI21XL $PINS A0=n1979 A1=n322 B0=n660 Y=n653
XU1780 AOI211XL $PINS A0=n654 A1=n1658 B0=n663 C0=n653 Y=n816
XU1781 INVXL $PINS A=n1693 Y=n726
XU1782 INVXL $PINS A=n732 Y=n655
XU1783 OAI21XL $PINS A0=n655 A1=state[1] B0=state[2] Y=n656
XU1784 OAI21XL $PINS A0=start_calib A1=state[2] B0=n656 Y=n657
XU1785 NAND2XL $PINS A=n1979 B=HFSNET_347 Y=n730
XU1786 NAND4XL $PINS A=n660 B=n1655 C=n659 D=n730 Y=n661
XU1787 AOI211XL $PINS A0=n726 A1=n663 B0=n662 C0=n661 Y=n821
XU1788 NOR2X1 $PINS A=n664 B=n667 Y=N1839
XU1789 NOR2X1 $PINS A=n664 B=n668 Y=N1831
XU1790 NOR2XL $PINS A=n665 B=n669 Y=N1824
XU1791 NOR2X1 $PINS A=n670 B=n671 Y=N1825
XU1792 NOR2X2 $PINS A=n669 B=n667 Y=N1840
XU1793 NOR2X2 $PINS A=n669 B=n668 Y=N1832
XU1794 AOI22XL $PINS A0=gre_a_INV_8759_58 A1=shadow_weights[4][1] B0=n1268
+ B1=shadow_weights[5][1] Y=n673_CDR1
XU1795 AOI22XL $PINS A0=gre_a_INV_5313_58 A1=shadow_weights[12][1] B0=n1266
+ B1=shadow_weights[3][1] Y=n672_CDR1
XctmTdsLR_2_868 OAI2BB1XL $PINS A0N=shadow_weights[13][19] A1N=n1319
+ B0=tmp_net142 Y=tmp_net143
XctmTdsLR_3_869 AOI21XL $PINS A0=gre_a_INV_6625_58 A1=shadow_weights[15][19]
+ B0=tmp_net143 Y=tmp_net144
XctmTdsLR_4_870 NAND2X1 $PINS A=n1326_CDR2 B=tmp_net144 Y=HFSNET_159
XctmTdsLR_1_871 AOI222XL $PINS A0=n1686 A1=shadow_weights[6][28]
+ B0=ZBUF_20020_1 B1=shadow_weights[0][28] C0=n1687 C1=shadow_weights[2][28]
+ Y=tmp_net145
XctmTdsLR_3_1910 OAI2BB1XL $PINS A0N=shadow_weights[15][18]
+ A1N=gre_a_INV_6625_58 B0=tmp_net376 Y=tmp_net377
XctmTdsLR_4_1911 AOI222XL $PINS A0=n1290 A1=shadow_weights[6][18] B0=n1291
+ B1=shadow_weights[13][18] C0=n1292 C1=shadow_weights[2][18] Y=tmp_net376
XctmTdsLR_2_958 OAI2BB1XL $PINS A0N=shadow_weights[2][14] A1N=n1292
+ B0=tmp_net204 Y=tmp_net205
XU1803 NOR2XL $PINS A=HFSNET_128 B=temp_acc[1] Y=n739
XU1804 AOI21XL $PINS A0=n695 A1=n694 B0=n693 Y=n806
XU1805 ADDFHXL $PINS A=meas_val_p[27] B=meas_val_n[27] CI=accumulator[27]
+ CO=n696 S=n646
XU1809 AOI21XL $PINS A0=n732 A1=n723 B0=n56 Y=n724
XU1813 NAND3XL $PINS A=n730 B=n729 C=n1416 Y=n731
XctmTdsLR_1_778 NAND2XL $PINS A=n1278 B=shadow_weights[8][14] Y=tmp_net87
XctmTdsLR_2_779 NAND2XL $PINS A=n1277 B=shadow_weights[10][14] Y=tmp_net88
XctmTdsLR_3_780 AOI222XL $PINS A0=n1280 A1=shadow_weights[18][14] B0=n1282
+ B1=HFSNET_211 C0=shadow_weights[19][14] C1=n1281 Y=tmp_net89
XctmTdsLR_4_781 NAND2XL $PINS A=n1279 B=shadow_weights[16][14] Y=tmp_net90
XU1818 AOI22X1 $PINS A0=n1278 A1=shadow_weights[8][2] B0=n1277
+ B1=shadow_weights[10][2] Y=n745_CDR2
XctmTdsLR_5_782 NAND4XL $PINS A=tmp_net87 B=tmp_net89 C=tmp_net90 D=tmp_net88
+ Y=HFSNET_45
XctmTdsLR_1_783 AOI22XL $PINS A0=n1673 A1=shadow_weights[17][20] B0=n1670
+ B1=shadow_weights[16][20] Y=tmp_net91
XctmTdsLR_2_1888 AND2XL $PINS A=HFSNET_342 B=shadow_weights[7][17] Y=tmp_net362
XctmTdsLR_2_784 AOI22XL $PINS A0=n1671 A1=HFSNET_234 B0=n1672
+ B1=shadow_weights[19][20] Y=tmp_net92
XU1823 NOR2XL $PINS A=HFSNET_129 B=temp_acc[2] Y=n976
XU1824 NAND2XL $PINS A=HFSNET_129 B=temp_acc[2] Y=n978
XU1825 OAI21XL $PINS A0=n779 A1=n976 B0=n978 Y=n802
XU1826 AOI22XL $PINS A0=n1280 A1=shadow_weights[18][3] B0=n1279
+ B1=shadow_weights[16][3] Y=n784
XU1827 AOI22XL $PINS A0=n1282 A1=shadow_weights[17][3] B0=n1281
+ B1=shadow_weights[19][3] Y=n783
XctmTdsLR_3_785 NAND3XL $PINS A=n1332_CDR1 B=tmp_net91 C=tmp_net92 Y=HFSNET_53
XU1830 NOR2XL $PINS A=HFSNET_130 B=temp_acc[3] Y=n979
XU1831 OAI21XL $PINS A0=n806 A1=n805 B0=n804 Y=n814
XU1832 ADDFHXL $PINS A=meas_val_p[28] B=meas_val_n[28] CI=accumulator[28]
+ CO=n807 S=n718
XctmTdsLR_1_1912 OR4XL $PINS A=tmp_net379 B=copt_gre_net_478 C=copt_gre_net_479
+ D=tmp_net381 Y=HFSNET_163
XU1834 AOI21X1 $PINS A0=n814 A1=n813 B0=n812 Y=n1082
XU1835 CMPR32X1 $PINS A=accumulator[29] B=n2169 C=n2193 CO=n824 S=n808
XU1838 OAI21XL $PINS A0=n979 A1=n978 B0=n977 Y=n980
XU1839 AOI21XL $PINS A0=n982 A1=n981 B0=n980 Y=n1061
XU1840 INVXL $PINS A=n1061 Y=n1087
XctmTdsLR_2_872 OAI2BB1XL $PINS A0N=shadow_weights[15][28]
+ A1N=gre_a_INV_6625_58 B0=tmp_net145 Y=tmp_net146
XctmTdsLR_3_873 AOI21XL $PINS A0=n1319 A1=shadow_weights[13][28] B0=tmp_net146
+ Y=tmp_net147
XctmTdsLR_2_1913 AND2XL $PINS A=ZBUF_20020_1 B=shadow_weights[0][4]
+ Y=tmp_net379
XU1844 NOR2XL $PINS A=HFSNET_163 B=temp_acc[4] Y=n1022
XU1845 NAND2XL $PINS A=HFSNET_163 B=temp_acc[4] Y=n1053
XctmTdsLR_4_874 NAND2XL $PINS A=n1622_CDR2 B=tmp_net147 Y=HFSNET_157
XctmTdsLR_1_875 AOI222XL $PINS A0=n1686 A1=shadow_weights[6][27] B0=n1687
+ B1=shadow_weights[2][27] C0=ZBUF_20020_1 C1=shadow_weights[0][27] Y=tmp_net148
XctmTdsLR_2_876 NAND2XL $PINS A=n1319 B=shadow_weights[13][27] Y=tmp_net149
XZBUF_2_inst_1045 BUFXL $PINS A=tmp_net47 Y=ZBUF_2_20
XU1850 NOR2XL $PINS A=HFSNET_131 B=temp_acc[5] Y=n1054
XU1851 NOR2XL $PINS A=n1022 B=n1054 Y=n1086
XctmTdsLR_3_877 NAND4XL $PINS A=n1598 B=tmp_net148 C=tmp_net149 D=n1597_CDR2
+ Y=tmp_net150
XctmTdsLR_4_878 OR4X2 $PINS A=n1596_CDR1 B=n1595_CDR2 C=n1594_CDR2 D=tmp_net150
+ Y=HFSNET_155
XU1854 NOR4BX2 $PINS AN=n1032_CDR2 B=n1031_CDR2 C=n1030_CDR2 D=HFSNET_103
+ Y=n1036
XctmTdsLR_3_959 AOI221XL $PINS A0=ZBUF_20020_1 A1=shadow_weights[0][14]
+ B0=gre_a_INV_6625_58 B1=shadow_weights[15][14] C0=tmp_net205 Y=tmp_net206
XU1856 NOR2XL $PINS A=HFSNET_132 B=temp_acc[6] Y=n1134
XctmTdsLR_1_786 AOI22XL $PINS A0=n1670 A1=shadow_weights[16][29] B0=n1673
+ B1=shadow_weights[17][29] Y=tmp_net93
XctmTdsLR_2_787 AOI22XL $PINS A0=n1671 A1=shadow_weights[18][29] B0=n1672
+ B1=shadow_weights[19][29] Y=tmp_net94
XctmTdsLR_3_1914 OAI2BB1XL $PINS A0N=shadow_weights[15][4]
+ A1N=gre_a_INV_6625_58 B0=tmp_net380 Y=tmp_net381
XctmTdsLR_4_960 NAND2XL $PINS A=n1206_CDR2 B=tmp_net206 Y=HFSNET_170
XU1861 NOR2XL $PINS A=HFSNET_133 B=temp_acc[7] Y=n1136
XU1862 NOR2XL $PINS A=n1134 B=n1136 Y=n1058
XU1863 NAND2XL $PINS A=HFSNET_132 B=temp_acc[6] Y=n1133
XU1864 OAI21XL $PINS A0=n1136 A1=n1133 B0=n1137 Y=n1057
XU1865 AOI21XL $PINS A0=n1058 A1=n1085 B0=n1057 Y=n1059
XU1866 OAI21XL $PINS A0=n1061 A1=n1060 B0=n1059 Y=n1235
XU1867 INVXL $PINS A=n1235 Y=n1423
XU1868 AOI22XL $PINS A0=n1266 A1=shadow_weights[3][8] B0=gre_a_INV_6238_58
+ B1=shadow_weights[1][8] Y=n1071_CDR2
XU1869 AOI22X2 $PINS A0=gre_a_INV_8759_58 A1=shadow_weights[4][8] B0=n1268
+ B1=shadow_weights[5][8] Y=n1063
XU1870 AOI22X1 $PINS A0=n1270 A1=shadow_weights[14][8] B0=gre_a_INV_5313_58
+ B1=shadow_weights[12][8] Y=n1062_CDR1
XctmTdsLR_4_1915 AOI222XL $PINS A0=n1290 A1=shadow_weights[6][4] B0=n1292
+ B1=shadow_weights[2][4] C0=n1319 C1=shadow_weights[13][4] Y=tmp_net380
XU1872 AOI22XL $PINS A0=gre_a_INV_6610_58 A1=shadow_weights[11][8] B0=n1274
+ B1=shadow_weights[9][8] Y=n1064
XctmTdsLR_4_1846 OAI2BB1XL $PINS A0N=shadow_weights[1][18]
+ A1N=gre_a_INV_6238_58 B0=ZBUF_2_0 Y=tmp_net334
XctmTdsLR_2_1955 NAND2XL $PINS A=n271 B=n279 Y=tmp_net402
XctmTdsLR_1_2001 NAND2XL $PINS A=n694 B=n692 Y=tmp_net423
XctmTdsLR_1_1956 OAI21XL $PINS A0=n291 A1=tmp_net403 B0=tmp_net404 Y=n296
XU1877 NOR2XL $PINS A=HFSNET_172 B=temp_acc[8] Y=n1110
XU1880 NAND2XL $PINS A=n1144 B=n1142 Y=n1083
XU1881 AOI21XL $PINS A0=n1087 A1=n1086 B0=n1085 Y=n1135
XU1882 OAI21XL $PINS A0=n1423 A1=n1110 B0=n1112 Y=n1108
XctmTdsLR_1_791 NAND2XL $PINS A=n1278 B=shadow_weights[8][6] Y=tmp_net96
XctmTdsLR_2_792 NAND2XL $PINS A=n1277 B=shadow_weights[10][6] Y=tmp_net97
XctmTdsLR_5_1847 OAI2BB1XL $PINS A0N=shadow_weights[9][18] A1N=n1274
+ B0=tmp_net101 Y=tmp_net335
XU1887 NOR2XL $PINS A=HFSNET_134 B=temp_acc[9] Y=n1113
XU1888 NOR2XL $PINS A=n1110 B=n1113 Y=n1164
XctmTdsLR_1_2002 AND4XL $PINS A=tmp_net310 B=n1355_CDR1 C=n1356_CDR2
+ D=n1357_CDR2 Y=HFSNET_75
XctmTdsLR_2_1957 XOR2X1 $PINS A=n293 B=shadow_weights[18][29] Y=tmp_net403
XctmTdsLR_1_2003 OAI21XL $PINS A0=n1108 A1=n1107 B0=tmp_net429 Y=n1109
XZCTSBUF_251_1348 CLKBUFX8 $PINS A=net1746 Y=ZCTSNET_395
XU1893 NOR2XL $PINS A=HFSNET_135 B=temp_acc[10] Y=n1163
XU1894 NAND2XL $PINS A=HFSNET_135 B=temp_acc[10] Y=n1432
XU1895 OAI21XL $PINS A0=n1135 A1=n1134 B0=n1133 Y=n1140
XU1896 AOI21XL $PINS A0=n1145 A1=n1144 B0=n1143 Y=n1495
XctmTdsLR_3_1958 NAND2XL $PINS A=n291 B=tmp_net403 Y=tmp_net404
XctmTdsLR_1_1969 OAI21XL $PINS A0=n1843 A1=n1842 B0=tmp_net412 Y=n1847
XctmTdsLR_2_1970 NAND2XL $PINS A=tmp_net411 B=n1840 Y=n1842
XctmTdsLR_3_793 AOI222XL $PINS A0=shadow_weights[19][6] A1=n1281 B0=n1280
+ B1=shadow_weights[18][6] C0=n1282 C1=shadow_weights[17][6] Y=tmp_net98
XU1903 NOR2XL $PINS A=HFSNET_136 B=temp_acc[11] Y=n1436
XU1904 NOR2XL $PINS A=n1163 B=n1436 Y=n1225
XU1905 NAND2XL $PINS A=n1164 B=n1225 Y=n1422
XU1906 AOI22XL $PINS A0=gre_a_INV_6238_58 A1=shadow_weights[1][12] B0=n1266
+ B1=shadow_weights[3][12] Y=n1174
XU1907 AOI22XL $PINS A0=gre_a_INV_8759_58 A1=shadow_weights[4][12] B0=n1268
+ B1=shadow_weights[5][12] Y=n1166_CDR1
XU1908 AOI22XL $PINS A0=n1270 A1=shadow_weights[14][12] B0=gre_a_INV_5313_58
+ B1=shadow_weights[12][12] Y=n1165_CDR1
XU1909 NAND2XL $PINS A=n1166_CDR1 B=n1165_CDR1 Y=n1173_CDR1
XU1910 AOI22X1 $PINS A0=gre_a_INV_6610_58 A1=shadow_weights[11][12] B0=n1274
+ B1=shadow_weights[9][12] Y=n1167_CDR1
XctmTdsLR_1_885 AOI222XL $PINS A0=n1291 A1=shadow_weights[13][7] B0=n1290
+ B1=shadow_weights[6][7] C0=n1292 C1=shadow_weights[2][7] Y=tmp_net155
XctmTdsLR_3_1971 INVXL $PINS A=n1839 Y=tmp_net411
XctmTdsLR_4_1972 NAND2XL $PINS A=n1843 B=n1842 Y=tmp_net412
XctmTdsLR_4_794 NAND2XL $PINS A=n1279 B=shadow_weights[16][6] Y=tmp_net99
XU1915 AOI22XL $PINS A0=gre_a_INV_6238_58 A1=shadow_weights[1][13] B0=n1266
+ B1=shadow_weights[3][13] Y=n1188
XU1916 AOI22XL $PINS A0=gre_a_INV_8759_58 A1=shadow_weights[4][13] B0=n1268
+ B1=shadow_weights[5][13] Y=n1180_CDR2
XU1917 AOI22XL $PINS A0=gre_a_INV_5313_58 A1=shadow_weights[12][13] B0=n1270
+ B1=shadow_weights[14][13] Y=n1179
XU1918 NAND2XL $PINS A=n1180_CDR2 B=n1179 Y=n1187_CDR2
XU1919 AOI22XL $PINS A0=gre_a_INV_6610_58 A1=shadow_weights[11][13] B0=n1274
+ B1=shadow_weights[9][13] Y=n1181_CDR2
XctmTdsLR_1_1973 OAI21XL $PINS A0=HFSNET_293 A1=n1419 B0=tmp_net413 Y=n1420
XctmTdsLR_2_1974 NAND2XL $PINS A=HFSNET_293 B=n1419 Y=tmp_net413
XctmTdsLR_1_1977 NOR3XL $PINS A=n1187_CDR2 B=n1186_CDR2 C=tmp_net417
+ Y=n1192_CDR1
XctmTdsLR_5_795 NAND4X1 $PINS A=tmp_net98 B=tmp_net96 C=tmp_net99 D=tmp_net97
+ Y=HFSNET_103
XU1924 NOR2XL $PINS A=HFSNET_168 B=temp_acc[13] Y=n1426
XU1925 NOR2XL $PINS A=n1424 B=n1426 Y=n1485
XU1926 AOI22XL $PINS A0=HFSNET_342 A1=shadow_weights[7][14] B0=n1266
+ B1=shadow_weights[3][14] Y=n1202_CDR2
XU1927 AOI22XL $PINS A0=n1270 A1=shadow_weights[14][14] B0=n1268
+ B1=shadow_weights[5][14] Y=n1194_CDR2
XU1928 AOI22XL $PINS A0=gre_a_INV_5313_58 A1=shadow_weights[12][14]
+ B0=gre_a_INV_8759_58 B1=shadow_weights[4][14] Y=n1193_CDR1
XU1929 NAND2XL $PINS A=n1194_CDR2 B=n1193_CDR1 Y=n1201_CDR2
XU1930 AOI22XL $PINS A0=gre_a_INV_6610_58 A1=shadow_weights[11][14] B0=n1274
+ B1=shadow_weights[9][14] Y=n1195_CDR1
XctmTdsLR_1_891 NAND2XL $PINS A=n1319 B=shadow_weights[13][0] Y=tmp_net159
XctmTdsLR_5_1788 AOI222XL $PINS A0=n1268 A1=shadow_weights[5][5] B0=n1279
+ B1=shadow_weights[16][5] C0=gre_a_INV_6610_58 C1=shadow_weights[11][5]
+ Y=tmp_net291
XctmTdsLR_4_1734 NAND2XL $PINS A=n1319 B=shadow_weights[13][3] Y=tmp_net257
XctmTdsLR_1_796 AOI222XL $PINS A0=shadow_weights[18][18] A1=n1280 B0=n1282
+ B1=shadow_weights[17][18] C0=shadow_weights[19][18] C1=n1281 Y=tmp_net100
XctmTdsLR_3_1746 AOI222XL $PINS A0=n1290 A1=shadow_weights[6][0] B0=n1266
+ B1=shadow_weights[3][0] C0=gre_a_INV_6238_58 C1=shadow_weights[1][0]
+ Y=tmp_net266
XctmTdsLR_2_797 NAND2XL $PINS A=n1279 B=shadow_weights[16][18] Y=tmp_net101
XctmTdsLR_2_1978 NAND2XL $PINS A=tmp_net416 B=n1188 Y=tmp_net417
XctmTdsLR_3_1979 INVX2 $PINS A=tmp_net415 Y=tmp_net416
XU1939 AOI22XL $PINS A0=gre_a_INV_6610_58 A1=shadow_weights[11][15] B0=n1274
+ B1=shadow_weights[9][15] Y=n1209_CDR2
XctmTdsLR_2_1748 AOI222XL $PINS A0=n1279 A1=shadow_weights[16][0] B0=n1268
+ B1=shadow_weights[5][0] C0=n1270 C1=shadow_weights[14][0] Y=tmp_net267
XctmTdsLR_3_801 NAND4X1 $PINS A=tmp_net262 B=tmp_net254 C=ZBUF_2_17 D=ZBUF_2_52
+ Y=HFSNET_173
XctmTdsLR_4_1980 NAND4XL $PINS A=tmp_net273 B=tmp_net83 C=tmp_net84
+ D=tmp_net274 Y=tmp_net415
XZCTSBUF_255_1350 BUFX8 $PINS A=net1756 Y=ZCTSNET_397
XU1944 NOR2XL $PINS A=HFSNET_173 B=temp_acc[15] Y=n1561
XU1945 NOR2XL $PINS A=n1490 B=n1561 Y=n1231
XU1946 OAI21XL $PINS A0=n1436 A1=n1432 B0=n1437 Y=n1223
XU1947 AOI21XL $PINS A0=n1225 A1=n1224 B0=n1223 Y=n1421
XU1948 OAI21XL $PINS A0=n1561 A1=n1557 B0=n1562 Y=n1230
XU1949 OAI21XL $PINS A0=n1421 A1=n1233 B0=n1232 Y=n1234
XU1950 AOI21X1 $PINS A0=n1235 A1=n1236 B0=n1234 Y=n1417
XctmTdsLR_2_1750 AOI222XL $PINS A0=n1278 A1=shadow_weights[8][7] B0=n1277
+ B1=shadow_weights[10][7] C0=n1279 C1=shadow_weights[16][7] Y=tmp_net268
XctmTdsLR_1_1981 OAI21XL $PINS A0=n1800 A1=n1799 B0=tmp_net418 Y=n1804
XU1953 NOR2XL $PINS A=HFSNET_167 B=temp_acc[16] Y=n1418
XctmTdsLR_6_1789 AOI22X1 $PINS A0=n1270 A1=shadow_weights[14][5] B0=n1274
+ B1=shadow_weights[9][5] Y=tmp_net292
XctmTdsLR_2_1982 NAND2XL $PINS A=n1800 B=n1799 Y=tmp_net418
XZCTSBUF_251_1351 BUFX8 $PINS A=net1666 Y=ZCTSNET_398
XU1957 NOR2XL $PINS A=HFSNET_164 B=temp_acc[17] Y=n1450
XU1958 NOR2XL $PINS A=n1418 B=n1450 Y=n1499
XZCTSBUF_247_1352 BUFX12 $PINS A=net1671 Y=ZCTSNET_399
XctmTdsLR_1_899 AOI222X1 $PINS A0=n1291 A1=shadow_weights[13][17] B0=n1290
+ B1=shadow_weights[6][17] C0=n1292 C1=shadow_weights[2][17] Y=tmp_net165
XctmTdsLR_2_900 NAND2XL $PINS A=ZBUF_20020_1 B=shadow_weights[0][17]
+ Y=tmp_net166
XctmTdsLR_4_1988 NAND2XL $PINS A=n352 B=n351 Y=tmp_net421
XU1963 NOR2XL $PINS A=HFSNET_160 B=temp_acc[18] Y=n1515
XU1964 AOI22XL $PINS A0=n1677 A1=shadow_weights[5][19] B0=n1679
+ B1=shadow_weights[14][19] Y=n1303_CDR2
XU1965 AOI22XL $PINS A0=gre_a_INV_6610_58 A1=shadow_weights[11][19]
+ B0=HFSNET_342 B1=shadow_weights[7][19] Y=n1307_CDR2
XU1966 AOI22XL $PINS A0=n1672 A1=shadow_weights[19][19] B0=n1669
+ B1=shadow_weights[8][19] Y=n1314_CDR1
XU1967 AOI22XL $PINS A0=n1670 A1=shadow_weights[16][19] B0=n1668
+ B1=shadow_weights[10][19] Y=n1313_CDR2
XU1968 AOI22XL $PINS A0=n1671 A1=shadow_weights[18][19] B0=n1673
+ B1=shadow_weights[17][19] Y=n1312_CDR2
XU1969 NAND3XL $PINS A=n1314_CDR1 B=n1313_CDR2 C=n1312_CDR2 Y=n1315_CDR2
XU1970 NOR4BX1 $PINS AN=n1318_CDR2 B=n1317_CDR2 C=n1316_CDR2 D=n1315_CDR2
+ Y=n1326_CDR2
XU1971 NOR2XL $PINS A=HFSNET_159 B=temp_acc[19] Y=n1517
XU1972 NOR2XL $PINS A=n1515 B=n1517 Y=n1388
XU1973 AOI22XL $PINS A0=n1677 A1=shadow_weights[5][20] B0=n1679
+ B1=shadow_weights[14][20] Y=n1327_CDR1
XU1974 AOI22XL $PINS A0=n1660 A1=shadow_weights[3][20] B0=gre_a_INV_8759_58
+ B1=shadow_weights[4][20] Y=n1329_CDR2
XU1975 AOI22XL $PINS A0=n1669 A1=shadow_weights[8][20] B0=n1668
+ B1=shadow_weights[10][20] Y=n1332_CDR1
XZCTSBUF_251_1353 BUFX8 $PINS A=net1676 Y=ZCTSNET_400
XZCTSBUF_255_1354 BUFX12 $PINS A=net1681 Y=ZCTSNET_401
XctmTdsLR_1_903 AOI22XL $PINS A0=n1673 A1=shadow_weights[17][23] B0=n1670
+ B1=shadow_weights[16][23] Y=tmp_net168
XU1979 NOR2XL $PINS A=HFSNET_154 B=temp_acc[20] Y=n1524
XU1980 AOI22XL $PINS A0=gre_a_INV_8759_58 A1=shadow_weights[4][21] B0=n1677
+ B1=shadow_weights[5][21] Y=n1342_CDR1
XU1981 AOI22XL $PINS A0=n1679 A1=shadow_weights[14][21] B0=gre_a_INV_5313_58
+ B1=shadow_weights[12][21] Y=n1341_CDR1
XU1982 NAND2XL $PINS A=n1342_CDR1 B=n1341_CDR1 Y=n1349_CDR1
XU1983 AOI22XL $PINS A0=n1662 A1=shadow_weights[9][21] B0=HFSNET_342
+ B1=shadow_weights[7][21] Y=n1343_CDR1
XU1984 AOI22XL $PINS A0=n1668 A1=shadow_weights[10][21] B0=n1669
+ B1=shadow_weights[8][21] Y=n1346_CDR1
XU1985 AOI22XL $PINS A0=n1671 A1=shadow_weights[18][21] B0=n1673
+ B1=shadow_weights[17][21] Y=n1345_CDR1
XU1986 AOI22XL $PINS A0=n1670 A1=shadow_weights[16][21] B0=n1672
+ B1=shadow_weights[19][21] Y=n1344_CDR1
XU1987 NAND3XL $PINS A=n1346_CDR1 B=n1345_CDR1 C=n1344_CDR1 Y=n1347_CDR1
XU1988 NOR2XL $PINS A=HFSNET_162 B=temp_acc[21] Y=n1508
XU1989 NOR2XL $PINS A=n1524 B=n1508 Y=n1569
XU1990 AOI22XL $PINS A0=gre_a_INV_8759_58 A1=shadow_weights[4][22]
+ B0=gre_a_INV_5313_58 B1=shadow_weights[12][22] Y=n1356_CDR2
XU1991 AOI22XL $PINS A0=HFSNET_342 A1=shadow_weights[7][22] B0=n1677
+ B1=shadow_weights[5][22] Y=n1355_CDR1
XctmTdsLR_1_1989 XOR2X1 $PINS A=tmp_net244 B=tmp_net422 Y=n1874
XU1993 AOI22XL $PINS A0=n1679 A1=shadow_weights[14][22] B0=n1660
+ B1=shadow_weights[3][22] Y=n1357_CDR2
XU1994 AOI22X2 $PINS A0=n1668 A1=shadow_weights[10][22] B0=n1669
+ B1=shadow_weights[8][22] Y=n1360_CDR2
XU1995 AOI22X1 $PINS A0=n1671 A1=shadow_weights[18][22] B0=n1672
+ B1=shadow_weights[19][22] Y=n1359_CDR1
XU1996 AOI22XL $PINS A0=n1673 A1=shadow_weights[17][22] B0=n1670
+ B1=shadow_weights[16][22] Y=n1358_CDR2
XctmTdsLR_2_904 AOI22XL $PINS A0=n1671 A1=shadow_weights[18][23]
+ B0=shadow_weights[19][23] B1=n1672 Y=tmp_net169
XU1998 OR2XL $PINS A=HFSNET_165 B=temp_acc[22] Y=n1572
XU1999 NAND2XL $PINS A=n1569 B=n1572 Y=n1394
XU2000 NOR2XL $PINS A=n1503 B=n1394 Y=n1457
XctmTdsLR_1_961 NAND2XL $PINS A=n1568 B=n1572 Y=tmp_net207
XctmTdsLR_2_962 OAI211XL $PINS A0=n1504 A1=n1394 B0=tmp_net207 C0=n1571 Y=n1456
XU2003 NAND2XL $PINS A=HFSNET_167 B=temp_acc[16] Y=n1447
XU2004 NAND2XL $PINS A=HFSNET_160 B=temp_acc[18] Y=n1514
XU2005 OAI21XL $PINS A0=n1517 A1=n1514 B0=n1518 Y=n1387
XU2006 AOI21XL $PINS A0=n1388 A1=n1498 B0=n1387 Y=n1504
XU2007 NAND2XL $PINS A=HFSNET_154 B=temp_acc[20] Y=n1525
XctmTdsLR_3_905 NAND3XL $PINS A=n1374_CDR1 B=tmp_net168 C=tmp_net169
+ Y=HFSNET_88
XctmTdsLR_1_963 OAI2BB1XL $PINS A0N=n1002 A1N=n1087 B0=n1053 Y=tmp_net208
XU2010 NAND2XL $PINS A=n315 B=n729 Y=N1754
XU2013 INVXL $PINS A=n1442 Y=n1489
XU2014 NAND2XL $PINS A=n1444 B=n1443 Y=n1445
XU2015 AOI22X1 $PINS A0=n1671 A1=shadow_weights[18][25] B0=n1673
+ B1=shadow_weights[17][25] Y=n1471_CDR1
XU2016 AOI22XL $PINS A0=n1670 A1=shadow_weights[16][25] B0=n1669
+ B1=shadow_weights[8][25] Y=n1470_CDR1
XU2017 OAI21XL $PINS A0=n1489 A1=n1488 B0=n1487 Y=n1560
XU2018 NAND2XL $PINS A=n1559 B=n1557 Y=n1491
XU2019 NAND2XL $PINS A=n1551 B=n1549 Y=n1496
XU2020 AOI21XL $PINS A0=HFSNET_293 A1=n1499 B0=n1498 Y=n1516
XU2021 AOI21XL $PINS A0=HFSNET_293 A1=n1506 B0=n1505 Y=n1523
XU2022 OAI21XL $PINS A0=n1523 A1=n1524 B0=n1525 Y=n1512
XU2023 OAI21XL $PINS A0=n1516 A1=n1515 B0=n1514 Y=n1521
XU2024 INVXL $PINS A=n1523 Y=n1570
XU2025 OAI21XL $PINS A0=n1531 A1=n1530 B0=n1529 Y=n1587
XctmTdsLR_2_1990 NOR2BX1 $PINS AN=n151 B=n150 Y=tmp_net422
XU2027 AOI22XL $PINS A0=n1670 A1=shadow_weights[16][26] B0=n1672
+ B1=shadow_weights[19][26] Y=n1535_CDR2
XU2028 NOR2XL $PINS A=n2200 B=accumulator[33] Y=n1577
XU2031 XOR2X1 $PINS A=n1578 B=n1554 Y=n1556
XU2034 OAI21XL $PINS A0=n1578 A1=n1577 B0=n1576 Y=n1582
XctmTdsLR_1_1991 NAND2XL $PINS A=tmp_net425 B=HFSNET_347 Y=HFSNET_69
XU2039 NAND2XL $PINS A=n1583 B=HFSNET_347 Y=n929
XU2040 AOI21XL $PINS A0=n1587 A1=n1586 B0=n1585 Y=n1608
XU2041 AOI22XL $PINS A0=gre_a_INV_8759_58 A1=shadow_weights[4][27] B0=n1677
+ B1=shadow_weights[5][27] Y=n1589_CDR1
XU2042 AOI22XL $PINS A0=n1679 A1=shadow_weights[14][27] B0=gre_a_INV_6610_58
+ B1=shadow_weights[11][27] Y=n1588_CDR1
XU2043 NAND2XL $PINS A=n1589_CDR1 B=n1588_CDR1 Y=n1596_CDR1
XU2044 AOI22XL $PINS A0=HFSNET_342 A1=shadow_weights[7][27] B0=n1662
+ B1=shadow_weights[9][27] Y=n1590_CDR2
XU2045 AOI22XL $PINS A0=n1669 A1=shadow_weights[8][27] B0=n1668
+ B1=shadow_weights[10][27] Y=n1593_CDR2
XU2046 AOI22XL $PINS A0=n1671 A1=shadow_weights[18][27] B0=n1673
+ B1=shadow_weights[17][27] Y=n1592_CDR1
XU2047 AOI22XL $PINS A0=n1670 A1=shadow_weights[16][27] B0=n1672
+ B1=shadow_weights[19][27] Y=n1591_CDR1
XU2048 NAND3XL $PINS A=n1593_CDR2 B=n1592_CDR1 C=n1591_CDR1 Y=n1594_CDR2
XctmTdsLR_1_2036 AOI21XL $PINS A0=n1744 A1=n1743 B0=tmp_net448 Y=n1748
XU2050 OAI21XL $PINS A0=n1608 A1=n1607 B0=n1606 Y=n1633
XU2051 AOI22XL $PINS A0=n1660 A1=shadow_weights[3][28] B0=gre_a_INV_6238_58
+ B1=shadow_weights[1][28] Y=n1618_CDR1
XU2052 AOI22XL $PINS A0=gre_a_INV_8759_58 A1=shadow_weights[4][28] B0=n1679
+ B1=shadow_weights[14][28] Y=n1610_CDR1
XU2053 AOI22XL $PINS A0=gre_a_INV_5313_58 A1=shadow_weights[12][28] B0=n1677
+ B1=shadow_weights[5][28] Y=n1609_CDR1
XU2054 NAND2XL $PINS A=n1610_CDR1 B=n1609_CDR1 Y=n1617_CDR1
XU2055 AOI22XL $PINS A0=n1662 A1=shadow_weights[9][28] B0=gre_a_INV_6610_58
+ B1=shadow_weights[11][28] Y=n1611_CDR1
XU2056 AOI22XL $PINS A0=n1669 A1=shadow_weights[8][28] B0=n1672
+ B1=shadow_weights[19][28] Y=n1614_CDR2
XU2057 AOI22XL $PINS A0=n1671 A1=shadow_weights[18][28] B0=n1673
+ B1=shadow_weights[17][28] Y=n1613_CDR1
XU2058 AOI22XL $PINS A0=n1670 A1=shadow_weights[16][28] B0=n1668
+ B1=shadow_weights[10][28] Y=n1612_CDR2
XU2059 NAND3XL $PINS A=n1614_CDR2 B=n1613_CDR1 C=n1612_CDR2 Y=n1615_CDR2
XctmTdsLR_3_2048 NAND2XL $PINS A=n443 B=n425 Y=tmp_net452
XU2061 AOI31XL $PINS A0=n1629 A1=n1628 A2=n1627 B0=n2133 Y=n1656
XU2062 INVXL $PINS A=n1656 Y=N1602
XZCTSBUF_255_1355 BUFX8 $PINS A=net1686 Y=ZCTSNET_402
XU2064 AOI22X1 $PINS A0=gre_a_INV_6238_58 A1=shadow_weights[1][29]
+ B0=gre_a_INV_6610_58 B1=shadow_weights[11][29] Y=n1644_CDR2
XU2065 AOI22XL $PINS A0=n1679 A1=shadow_weights[14][29] B0=n1677
+ B1=shadow_weights[5][29] Y=n1635_CDR2
XU2066 AOI22XL $PINS A0=n1660 A1=shadow_weights[3][29] B0=gre_a_INV_8759_58
+ B1=shadow_weights[4][29] Y=n1634_CDR1
XctmTdsLR_1_1852 NAND4XL $PINS A=tmp_net69 B=tmp_net71 C=tmp_net72 D=tmp_net70
+ Y=tmp_net340
XU2068 AOI22XL $PINS A0=n1662 A1=shadow_weights[9][29] B0=gre_a_INV_5313_58
+ B1=shadow_weights[12][29] Y=n1636_CDR2
XctmTdsLR_2_1992 OAI21XL $PINS A0=n695 A1=tmp_net423 B0=tmp_net424 Y=tmp_net425
XU2070 AOI22XL $PINS A0=n1669 A1=shadow_weights[8][29] B0=n1668
+ B1=shadow_weights[10][29] Y=n1640_CDR1
XZCTSBUF_255_1356 BUFX12 $PINS A=net1691 Y=ZCTSNET_403
XZCTSBUF_255_1357 BUFX12 $PINS A=net1696 Y=ZCTSNET_404
XctmTdsLR_2_1713 AOI222XL $PINS A0=n1278 A1=shadow_weights[8][15] B0=n1277
+ B1=shadow_weights[10][15] C0=n1279 C1=shadow_weights[16][15] Y=tmp_net243
XZCTSBUF_255_1359 BUFX16 $PINS A=net1706 Y=ZCTSNET_406
XctmTdsLR_1_1718 OR4X1 $PINS A=tmp_net248 B=tmp_net249 C=n1244_CDR2
+ D=n1245_CDR2 Y=HFSNET_167
XctmTdsLR_4_2019 NAND2XL $PINS A=tmp_net215 B=n1439 Y=tmp_net437
XZCTSBUF_675_1361 BUFX1 $PINS A=clk Y=ZCTSNET_408
XU2079 NAND3XL $PINS A=n640 B=n315 C=n1655 Y=N1488
XU2080 NOR2XL $PINS A=n1659 B=n2161 Y=n1985
XU2081 NOR2XL $PINS A=HFSNET_348 B=n1985 Y=n1697
XU2083 AOI22XL $PINS A0=n1660 A1=protected_sar_code[3] B0=gre_a_INV_6610_58
+ B1=protected_sar_code[11] Y=n1665_CDR2
XU2084 AOI22XL $PINS A0=gre_a_INV_6238_58 A1=protected_sar_code[1] B0=n1662
+ B1=protected_sar_code[9] Y=n1664_CDR2
XU2085 OAI211XL $PINS A0=n1210 A1=n2180 B0=n1665_CDR2 C0=n1664_CDR2
+ Y=n1685_CDR2
XU2086 AOI22XL $PINS A0=n1686 A1=protected_sar_code[6] B0=n1319
+ B1=protected_sar_code[13] Y=n1676_CDR2
XU2087 AOI22XL $PINS A0=ZBUF_20020_1 A1=protected_sar_code[0] B0=n1672
+ B1=protected_sar_code[19] Y=n1674_CDR2
XU2088 AOI22XL $PINS A0=n1677 A1=protected_sar_code[5] B0=n1679
+ B1=protected_sar_code[14] Y=n1682_CDR2
XU2089 AOI22XL $PINS A0=gre_a_INV_8759_58 A1=protected_sar_code[4] B0=n1687
+ B1=protected_sar_code[2] Y=n1681_CDR2
XU2090 NOR3XL $PINS A=n1685_CDR2 B=n1684_CDR2 C=n1683_CDR2 Y=n1692_CDR2
XU2091 AOI21XL $PINS A0=n1697 A1=n1694 B0=n1696 Y=n1695
XU2092 INVXL $PINS A=n1695 Y=n2328
XU2095 OAI21XL $PINS A0=gre_a_INV_6625_58 A1=n1701 B0=n1875 Y=n969
XctmTdsLR_4_1994 NAND2XL $PINS A=n695 B=tmp_net423 Y=tmp_net424
XU2097 OAI21XL $PINS A0=n1711 A1=HFSNET_346 B0=n1710 Y=n896
XU2098 OAI21XL $PINS A0=n1719 A1=HFSNET_346 B0=n1718 Y=n897
XU2099 OAI21XL $PINS A0=n1728 A1=HFSNET_346 B0=n1727 Y=n898
XU2100 INVXL $PINS A=n1729 Y=n1744
XU2101 OAI21XL $PINS A0=n1744 A1=n1740 B0=n1741 Y=n1734
XU2102 OAI21XL $PINS A0=n1739 A1=HFSNET_346 B0=n1738 Y=n899
XU2103 OAI21XL $PINS A0=n1748 A1=HFSNET_346 B0=n1747 Y=n900
XU2104 INVXL $PINS A=n1749 Y=n1774
XU2105 OAI21XL $PINS A0=n1759 A1=HFSNET_346 B0=n1758 Y=n901
XU2106 OAI21XL $PINS A0=n1770 A1=HFSNET_346 B0=n1769 Y=n902
XU2107 OAI21XL $PINS A0=n1778 A1=HFSNET_346 B0=n1777 Y=n903
XU2108 INVXL $PINS A=n1779 Y=n1852
XU2109 INVXL $PINS A=n1807 Y=n1821
XU2110 OAI21XL $PINS A0=n1796 A1=HFSNET_346 B0=n1795 Y=n904
XU2111 OAI21XL $PINS A0=n1804 A1=HFSNET_346 B0=n1803 Y=n905
XU2112 OAI21XL $PINS A0=n1817 A1=HFSNET_346 B0=n1816 Y=n906
XU2113 OAI21XL $PINS A0=n1826 A1=HFSNET_346 B0=n1825 Y=n907
XU2115 OAI21X1 $PINS A0=n1838 A1=HFSNET_346 B0=n1837 Y=n908
XU2116 OAI21XL $PINS A0=n1852 A1=n1848 B0=n1849 Y=n1843
XU2117 OAI21X1 $PINS A0=n1847 A1=HFSNET_346 B0=n1846 Y=n909
XU2118 OAI21X1 $PINS A0=n1856 A1=HFSNET_346 B0=n1855 Y=n910
XU2119 INVXL $PINS A=n1857 Y=n1893
XU2120 AOI21XL $PINS A0=n1893 A1=n1859 B0=n1858 Y=n1873
XU2121 OAI21XL $PINS A0=n1873 A1=n1869 B0=n1870 Y=n1864
XU2122 OAI21XL $PINS A0=n1868 A1=HFSNET_346 B0=n1867 Y=n911
XU2123 OAI21X1 $PINS A0=n1878 A1=HFSNET_346 B0=n1877 Y=n912
XU2124 OAI21X1 $PINS A0=n1889 A1=HFSNET_346 B0=n1888 Y=n913
XctmTdsLR_1_1995 NOR3X2 $PINS A=n1124 B=n1123_CDR2 C=tmp_net426 Y=n1129_CDR1
XU2126 OAI21XL $PINS A0=n1912 A1=n1908 B0=n1909 Y=n1903
XU2127 OAI21X1 $PINS A0=n1907 A1=HFSNET_346 B0=n1906 Y=n915
XU2128 OAI21XL $PINS A0=n1916 A1=HFSNET_346 B0=n1915 Y=n916
XU2129 NAND2XL $PINS A=n1920 B=n1919 Y=n1921
XU2130 OAI21X1 $PINS A0=n1926 A1=HFSNET_346 B0=n1925 Y=n917
XU2131 NAND2XL $PINS A=n1928 B=n1927 Y=n1929
XU2132 NOR2XL $PINS A=n1931 B=gre_a_INV_2586_58 Y=n1932
XU2133 OAI21XL $PINS A0=n1934 A1=HFSNET_346 B0=n1933 Y=n918
XU2134 NAND2XL $PINS A=n1936 B=n1935 Y=n1937
XU2135 NOR2XL $PINS A=n1939 B=gre_a_INV_2586_58 Y=n1940
XU2136 OAI21XL $PINS A0=n1943 A1=HFSNET_346 B0=n1942 Y=n919
XU2139 NOR2XL $PINS A=n1949 B=gre_a_INV_2586_58 Y=n1950
XU2140 OAI21XL $PINS A0=n1952 A1=HFSNET_346 B0=n1951 Y=n920
XU2141 NAND2XL $PINS A=n1954 B=n1953 Y=n1956
XU2142 NOR2XL $PINS A=n1957 B=gre_a_INV_2586_58 Y=n1958
XU2143 OAI21XL $PINS A0=n1960 A1=HFSNET_346 B0=n1959 Y=n921
XU2146 XOR2XL $PINS A=n1964 B=n1969 Y=n1968
XU2147 NOR2XL $PINS A=n1965 B=gre_a_INV_2586_58 Y=n1966
XU2148 OAI21XL $PINS A0=n1968 A1=HFSNET_346 B0=n1967 Y=n922
XU2151 NOR2XL $PINS A=gre_a_INV_2586_58 B=n1971 Y=n1973
XU2154 INVXL $PINS A=n1978 Y=n1981
XU2155 NOR2XL $PINS A=n1979 B=n322 Y=n1980
XU2156 OAI21XL $PINS A0=n1981 A1=avg_cnt[4] B0=n1980 Y=n963
XU2157 AOI21XL $PINS A0=wait_cnt[2] A1=n1984 B0=n1982 Y=n1983
XU2158 OAI21XL $PINS A0=n1984 A1=wait_cnt[2] B0=n1983 Y=n925
XU2159 OAI21X1 $PINS A0=n2158 A1=n729 B0=n315 Y=N1786
XU2160 OAI21XL $PINS A0=n2179 A1=n729 B0=n315 Y=N1787
XU2161 OAI21XL $PINS A0=n2068 A1=n1989 B0=n315 Y=N1723
XU2162 AOI21XL $PINS A0=n65 A1=n1987 B0=n815 Y=n1986
XU2163 OAI21XL $PINS A0=n65 A1=n1987 B0=n1986 Y=n827
XU2165 NAND3XL $PINS A=n2033 B=n1993 C=n2158 Y=n2021
XU2167 INVXL $PINS A=n2073 Y=n2005
XU2168 NAND2XL $PINS A=n2005 B=n1996 Y=n1997
XU2169 NAND3XL $PINS A=n1996 B=n2163 C=target_bit[2] Y=n1998
XZBUF_2_inst_2105 CLKBUFX3 $PINS A=tmp_net49 Y=ZBUF_2_31
XU2171 NAND2XL $PINS A=n2005 B=n2009 Y=n2013
XU2172 NAND2XL $PINS A=n2009 B=n2006 Y=n2014
XU2173 INVXL $PINS A=n2033 Y=n2025
XU2174 AOI2BB1X1 $PINS A0N=n2031 A1N=n2179 B0=n2047 Y=n2041
XU2175 NAND2XL $PINS A=n2073 B=n2041 Y=n2044
XU2176 AOI22XL $PINS A0=n2190 A1=n2044 B0=n2186 B1=n2058 Y=n2040_CDR1
XU2177 NAND2XL $PINS A=n2022 B=n2021 Y=n2051
XU2178 AOI22XL $PINS A0=n2166 A1=n57 B0=n2050 B1=n2164 Y=n2023_CDR2
XU2179 OAI21XL $PINS A0=n2053 A1=protected_sar_code[13] B0=n2023_CDR2
+ Y=n2028_CDR2
XU2180 INVXL $PINS A=n2050 Y=n2029
XU2181 OAI21XL $PINS A0=ZBUF_4201_28 A1=n2025 B0=n2029 Y=n2055
XU2182 AOI22XL $PINS A0=n2056 A1=n2184 B0=n2189 B1=n2051 Y=n2026_CDR2
XU2183 OAI2BB1XL $PINS A0N=n2187 A1N=n2054 B0=n2026_CDR2 Y=n2027_CDR2
XU2184 AOI211XL $PINS A0=n2057 A1=n2167 B0=n2028_CDR2 C0=n2027_CDR2
+ Y=n2039_CDR2
XU2185 NAND2XL $PINS A=ZBUF_4201_28 B=n2029 Y=n2057
XU2186 NAND2XL $PINS A=n2049 B=n2031 Y=n2058
XU2187 AOI22XL $PINS A0=n2165 A1=n2045 B0=target_bit[4] B1=n2182 Y=n2038_CDR2
XU2188 NOR2XL $PINS A=n2032 B=n2047 Y=n2042
XU2189 OAI22XL $PINS A0=protected_sar_code[6] A1=n2042 B0=protected_sar_code[5]
+ B1=n2041 Y=n2036
XU2190 AOI21XL $PINS A0=n2034 A1=n2033 B0=n2057 Y=n2046
XU2191 OAI22XL $PINS A0=n2049 A1=protected_sar_code[3] B0=protected_sar_code[8]
+ B1=n2046 Y=n2035
XU2192 AOI211XL $PINS A0=n2047 A1=n2180 B0=n2036 C0=n2035 Y=n2037_CDR1
XU2193 NAND4XL $PINS A=n2037_CDR1 B=n2039_CDR2 C=n2040_CDR1 D=n2038_CDR2
+ Y=n2070
XU2194 OAI22XL $PINS A0=n2168 A1=n2042 B0=n2191 B1=n2041 Y=n2043
XU2195 INVXL $PINS A=n2043 Y=n2067
XU2196 AOI22XL $PINS A0=protected_sar_code[7] A1=n2047 B0=protected_sar_code[4]
+ B1=n2044 Y=n2066_CDR2
XctmTdsLR_3_1720 NAND2XL $PINS A=ZBUF_20020_1 B=shadow_weights[0][16]
+ Y=tmp_net246
XZCTSBUF_6604_1367 BUFX16 $PINS A=ZCTSNET_413 Y=ZCTSNET_412
XU2199 AOI22XL $PINS A0=protected_sar_code[2] A1=n2045 B0=target_bit[4]
+ B1=protected_sar_code[15] Y=n2052_CDR2
XU2200 OAI21XL $PINS A0=n2053 A1=n2188 B0=n2052_CDR2 Y=n2063_CDR2
XU2201 AOI22XL $PINS A0=protected_sar_code[16] A1=n2051
+ B0=protected_sar_code[10] B1=n2055 Y=n2061_CDR1
XU2202 AOI22XL $PINS A0=protected_sar_code[12] A1=n2054
+ B0=protected_sar_code[14] B1=n2056 Y=n2060_CDR1
XU2203 AOI22XL $PINS A0=protected_sar_code[9] A1=n2057
+ B0=protected_sar_code[11] B1=n2050 Y=n2059_CDR2
XU2204 NAND3XL $PINS A=n2061_CDR1 B=n2060_CDR1 C=n2059_CDR2 Y=n2062_CDR2
XU2205 NOR3XL $PINS A=n2064_CDR2 B=n2063_CDR2 C=n2062_CDR2 Y=n2065_CDR2
XU2206 OAI21XL $PINS A0=overrange_acc A1=n2071 B0=n968 Y=n826
XU2207 OAI211XL $PINS A0=n2179 A1=n2158 B0=n2073 C0=n2072 Y=n2077
XU2208 AOI21XL $PINS A0=n2100 A1=sar_ptr[2] B0=n2074 Y=n2075
XU2209 NOR2XL $PINS A=n2079 B=sar_ptr[4] Y=n2099
XU2210 NAND3XL $PINS A=n2099 B=n1 C=n2197 Y=n2086
XU2211 OAI21XL $PINS A0=protected_sar_code[0] A1=n2081 B0=n2080 Y=n773
XU2212 NOR2XL $PINS A=sar_ptr[1] B=n2199 Y=n2115
XU2213 OAI21XL $PINS A0=protected_sar_code[1] A1=n2083 B0=n2082 Y=n772
XU2214 OAI21XL $PINS A0=protected_sar_code[2] A1=n2085 B0=n2084 Y=n771
XU2215 OAI21XL $PINS A0=protected_sar_code[3] A1=n2088 B0=n2087 Y=n770
XU2216 NOR2XL $PINS A=n2110 B=sar_ptr[3] Y=n2093
XU2217 OAI21XL $PINS A0=n2118 A1=n2090 B0=n2089 Y=n769
XU2218 OAI21XL $PINS A0=n2092 A1=n2118 B0=n2091 Y=n768
XU2219 OAI21XL $PINS A0=protected_sar_code[6] A1=n2095 B0=n2094 Y=n767
XU2220 OAI21XL $PINS A0=protected_sar_code[7] A1=n2098 B0=n2097 Y=n766
XU2221 NAND3XL $PINS A=sar_ptr[3] B=n2099 C=n2197 Y=n2107
XU2222 OAI21XL $PINS A0=protected_sar_code[8] A1=n2102 B0=n2101 Y=n765
XU2223 OAI21XL $PINS A0=protected_sar_code[9] A1=n2104 B0=n2103 Y=n764
XU2224 OAI21XL $PINS A0=protected_sar_code[10] A1=n2106 B0=n2105 Y=n763
XU2225 OAI21XL $PINS A0=protected_sar_code[11] A1=n2109 B0=n2108 Y=n762
XU2226 NOR2XL $PINS A=n1 B=n2110 Y=n2119
XU2227 OAI21XL $PINS A0=n2118 A1=n2114 B0=n2113 Y=n761
XU2228 OAI21XL $PINS A0=n2118 A1=n2117 B0=n2116 Y=n760
XU2229 OAI21XL $PINS A0=protected_sar_code[14] A1=n2121 B0=n2120 Y=n759
XU2230 OAI21XL $PINS A0=protected_sar_code[15] A1=n2124 B0=n2123 Y=n758
XU2231 OAI21XL $PINS A0=sar_code[17] A1=n2127 B0=n2126 Y=n756
XU2232 OAI21XL $PINS A0=sar_code[18] A1=n2130 B0=n2129 Y=n755
XU2233 AOI21XL $PINS A0=n2136 A1=n2134 B0=n2133 Y=n2135
XU2234 OAI21XL $PINS A0=protected_sar_code[19] A1=n2136 B0=n2135 Y=n754
XHFSINV_11_519 INVXL $PINS A=N1842 Y=HFSNET_261
XU2236 INVXL $PINS A=N1841 Y=n2138
XU2237 INVXL $PINS A=N1840 Y=n2139
XHFSINV_4_535 INVXL $PINS A=N1839 Y=HFSNET_275
XctmTdsLR_4_1721 AOI222X1 $PINS A0=n1290 A1=shadow_weights[6][16] B0=n1291
+ B1=shadow_weights[13][16] C0=n1292 C1=shadow_weights[2][16] Y=tmp_net247
XHFSINV_164_533 INVXL $PINS A=N1837 Y=HFSNET_273
XHFSINV_142_509 INVXL $PINS A=N1836 Y=HFSNET_252
XU2242 OAI221XL $PINS A0=HFSNET_252 A1=ZBUF_24_2 B0=N1836 B1=n2157 C0=n640
+ Y=n711
XctmTdsLR_5_1722 INVXL $PINS A=n1246_CDR2 Y=tmp_net249
XU2244 OAI221XL $PINS A0=N1835 A1=overrange_bits[7] B0=HFSNET_270 B1=n2157
+ C0=n640 Y=n710
XHFSINV_89_522 INVXL $PINS A=N1834 Y=HFSNET_264
XU2246 OAI221XL $PINS A0=N1834 A1=overrange_bits[8] B0=HFSNET_264 B1=n2157
+ C0=n640 Y=n709
XctmTdsLR_2_1752 AOI222XL $PINS A0=n1278 A1=shadow_weights[8][9] B0=n1277
+ B1=shadow_weights[10][9] C0=n1279 C1=shadow_weights[16][9] Y=tmp_net269
XHFSINV_180_543 INVXL $PINS A=N1832 Y=HFSNET_282
XU2249 OAI221XL $PINS A0=N1832 A1=overrange_bits[10] B0=HFSNET_282 B1=n2157
+ C0=n640 Y=n707
XHFSINV_186_538 INVXL $PINS A=N1831 Y=HFSNET_278
XU2251 OAI221XL $PINS A0=N1831 A1=overrange_bits[11] B0=HFSNET_278 B1=n2157
+ C0=n640 Y=n706
XHFSINV_11_516 INVXL $PINS A=N1830 Y=HFSNET_258
XU2253 OAI221XL $PINS A0=N1830 A1=overrange_bits[12] B0=HFSNET_258 B1=n2157
+ C0=n640 Y=n705
XctmTdsLR_2_1996 NAND2XL $PINS A=tmp_net275 B=n1125_CDR2 Y=tmp_net426
XU2255 OAI221XL $PINS A0=HFSNET_269 A1=overrange_bits[13] B0=N1829 B1=n2157
+ C0=n640 Y=n704
XHFSINV_86_514 INVXL $PINS A=N1828 Y=HFSNET_256
XU2257 OAI221XL $PINS A0=N1828 A1=overrange_bits[14] B0=HFSNET_256 B1=n2157
+ C0=n640 Y=n703
XHFSINV_167_525 INVXL $PINS A=ZBUF_17_0 Y=HFSNET_266
XU2259 OAI221XL $PINS A0=ZBUF_17_0 A1=overrange_bits[15] B0=HFSNET_266 B1=n2157
+ C0=n640 Y=n702
XU1158 OR3XL $PINS A=wr_idx_r[1] B=n670 C=n669 Y=N1826
XU2261 OAI221XL $PINS A0=HFSNET_250 A1=ZBUF_22_2 B0=N1826 B1=n2157 C0=n640
+ Y=n701
XHFSINV_4_540 INVXL $PINS A=N1825 Y=HFSNET_280
XU2263 OAI221XL $PINS A0=N1825 A1=overrange_bits[17] B0=HFSNET_280 B1=n2157
+ C0=n640 Y=n700
XU2264 INVXL $PINS A=N1824 Y=n2155
XU2265 OAI221XL $PINS A0=N1824 A1=overrange_bits[18] B0=n2155 B1=n2157 C0=n640
+ Y=n699
XU2266 OAI221XL $PINS A0=N1823 A1=overrange_bits[19] B0=n823 B1=n2157 C0=n640
+ Y=n697
XU15 INVXL $PINS A=n639 Y=n1990
XU1057 INVXL $PINS A=n617 Y=n629
XU1731 NAND2XL $PINS A=n1659 B=n2161 Y=n631
XU22 OAI2BB1XL $PINS A0N=n2343 A1N=n292 B0=n1975 Y=n923
XctmTdsLR_3_1725 NAND4XL $PINS A=n782 B=n785_CDR1 C=n784 D=n783 Y=tmp_net251
XU123 AOI211XL $PINS A0=n726 A1=n725 B0=n735 C0=n724 Y=n819
XU128 NOR2BX1 $PINS AN=n1698 B=n2161 Y=n1701
XU129 NAND2XL $PINS A=calc_cnt[3] B=n558 Y=n1698
XU199 OAI21XL $PINS A0=start_calib A1=n722 B0=n823 Y=n735
XctmTdsLR_2_1754 OAI2BB1XL $PINS A0N=shadow_weights[13][5] A1N=n1319
+ B0=tmp_net270 Y=tmp_net271
XU256 NAND2XL $PINS A=temp_acc[0] B=HFSNET_127 Y=n738
XU259 OAI21XL $PINS A0=shadow_weights[18][0] A1=n1971 B0=n1969 Y=n2343
XU274 NAND2XL $PINS A=shadow_weights[18][0] B=n1971 Y=n1969
XU302 NOR2XL $PINS A=n292 B=sar_code[18] Y=n2002
XU313 NOR2XL $PINS A=n55 B=sar_code[17] Y=n2003
XctmTdsLR_3_1755 AOI22XL $PINS A0=n1290 A1=shadow_weights[6][5] B0=n1292
+ B1=shadow_weights[2][5] Y=tmp_net270
XctmTdsLR_2_2004 NAND2XL $PINS A=n1108 B=n1107 Y=tmp_net429
XctmTdsLR_1_2005 OAI21XL $PINS A0=n1140 A1=n1139 B0=tmp_net430 Y=n1141
XU331 XNOR2XL $PINS A=HFSNET_73 B=temp_acc[29] Y=n1652
XU333 NAND2BXL $PINS AN=n1110 B=n1112 Y=n1078
XU335 NAND2BXL $PINS AN=n1908 B=n1909 Y=n1911
XU336 NAND2BXL $PINS AN=n1881 B=n1882 Y=n1884
XU341 NAND2BXL $PINS AN=n1788 B=n1789 Y=n1791
XctmTdsLR_4_2049 NOR2XL $PINS A=tmp_net219 B=tmp_net419 Y=tmp_net453
XctmTdsLR_2_2037 NAND2XL $PINS A=tmp_net447 B=n1741 Y=n1743
XU349 NAND2BXL $PINS AN=n1577 B=n1576 Y=n1554
XctmTdsLR_4_2076 NOR2XL $PINS A=n1516 B=n1501 Y=tmp_net467
XU352 NAND2BXL $PINS AN=n605 B=n606 Y=n608
XU353 NAND2BXL $PINS AN=n551 B=n552 Y=n554
XU356 NAND2BXL $PINS AN=n524 B=n525 Y=n527
XU358 NAND2BXL $PINS AN=n479 B=n480 Y=n482
XctmTdsLR_2_2006 NAND2XL $PINS A=n1140 B=n1139 Y=tmp_net430
XctmTdsLR_1_2007 OAI211XL $PINS A0=tmp_net216 A1=tmp_net431 B0=tmp_net432
+ C0=n1875 Y=n2340
XctmTdsLR_2_2008 INVXL $PINS A=n1652 Y=tmp_net431
XU362 NAND2BXL $PINS AN=n1517 B=n1518 Y=n1520
XctmTdsLR_3_2038 INVXL $PINS A=n1740 Y=tmp_net447
XU367 NAND2BXL $PINS AN=n979 B=n977 Y=n801
XU370 NAND2BXL $PINS AN=n1530 B=n1529 Y=n1483
XU371 NAND2BXL $PINS AN=n1113 B=n1111 Y=n1107
XU374 NAND2BXL $PINS AN=n1136 B=n1137 Y=n1139
XU376 NAND2BXL $PINS AN=n1508 B=n1509 Y=n1511
XU378 NAND2BXL $PINS AN=n1561 B=n1562 Y=n1564
XU380 NAND2BXL $PINS AN=n477 B=n476 Y=n445
XU381 NAND2BXL $PINS AN=n448 B=n447 Y=n380
XctmTdsLR_3_2009 NAND2XL $PINS A=tmp_net216 B=tmp_net431 Y=tmp_net432
XctmTdsLR_1_2020 AOI21XL $PINS A0=n1608 A1=n1604 B0=tmp_net439 Y=n1605
XU390 NAND2BXL $PINS AN=n1848 B=n1849 Y=n1851
XU392 NAND2BXL $PINS AN=n1762 B=n1763 Y=n1765
XZBUF_2_inst_2106 BUFX1 $PINS A=tmp_net40 Y=ZBUF_2_32
XU399 NAND2BXL $PINS AN=n1134 B=n1133 Y=n1089
XctmTdsLR_1_2077 AOI21XL $PINS A0=n779 A1=n777 B0=tmp_net469 Y=n778
XctmTdsLR_1_2050 OAI21XL $PINS A0=n1587 A1=n1547 B0=tmp_net454 Y=n1548
XU411 NAND2BXL $PINS AN=n1961 B=n1962 Y=n1964
XU412 NAND2BXL $PINS AN=n1081 B=n1080 Y=n974
XU432 NAND2BXL $PINS AN=n805 B=n804 Y=n720
XU447 NAND2BXL $PINS AN=n643 B=n642 Y=n588
XU451 NAND2BXL $PINS AN=n562 B=n561 Y=n515
XU452 NAND2BXL $PINS AN=n354 B=n356 Y=n338
XctmTdsLR_4_2039 NOR2XL $PINS A=n1744 B=n1743 Y=tmp_net448
XU462 NAND2BXL $PINS AN=n739 B=n737 Y=n690
XZBUF_2_inst_2107 CLKBUFX2 $PINS A=tmp_net256 Y=ZBUF_2_33
XU480 NAND2BXL $PINS AN=n540 B=n541 Y=n543
XU507 NAND2BXL $PINS AN=n502 B=n503 Y=n505
XctmTdsLR_2_2021 NAND2XL $PINS A=tmp_net438 B=n1606 Y=n1604
XU513 NAND2BXL $PINS AN=n449 B=n450 Y=n452
XctmTdsLR_3_2022 INVXL $PINS A=n1607 Y=tmp_net438
XctmTdsLR_2_2078 NAND2XL $PINS A=tmp_net468 B=n978 Y=n777
XU534 NAND2BXL $PINS AN=n336 B=n335 Y=n329
XctmTdsLR_4_2023 NOR2XL $PINS A=n1608 B=n1604 Y=tmp_net439
XU594 NAND2BXL $PINS AN=n1944 B=n1945 Y=n1948
XU614 NAND2BXL $PINS AN=n460 B=n459 Y=n439
XU631 NAND2BXL $PINS AN=n1494 B=n1493 Y=n1147
XU641 INVXL $PINS A=n1898 Y=n1912
XctmTdsLR_1_2024 NAND2XL $PINS A=tmp_net442 B=HFSNET_347 Y=HFSNET_67
XU873 NAND4BX1 $PINS AN=n2079 B=sar_ptr[4] C=n1 D=n2197 Y=n2131
XU910 AOI21XL $PINS A0=n1627 A1=HFSNET_117 B0=n2118 Y=n2079
XU911 INVXL $PINS A=target_bit[2] Y=n2344
XU912 AND3X1 $PINS A=n2344 B=n1993 C=target_bit[1] Y=n55
XU914 XNOR2XL $PINS A=n2214 B=n2170 Y=n286
XctmTdsLR_2_2051 NAND2XL $PINS A=n1587 B=n1547 Y=tmp_net454
XU917 NAND2BXL $PINS AN=n257 B=n256 Y=n255
XU921 NAND2BXL $PINS AN=n94 B=n95 Y=n97
XctmTdsLR_2_2025 OAI21XL $PINS A0=n814 A1=tmp_net213 B0=tmp_net441 Y=tmp_net442
XU930 NAND2BXL $PINS AN=n209 B=n210 Y=n212
XU932 NAND2BXL $PINS AN=n214 B=n215 Y=n217
XU935 NAND2BXL $PINS AN=n111 B=n112 Y=n114
XU940 NAND2BXL $PINS AN=n120 B=n121 Y=n123
XU949 NAND2BXL $PINS AN=n159 B=n160 Y=n162
XctmTdsLR_4_2027 NAND2XL $PINS A=n814 B=tmp_net213 Y=tmp_net441
XU963 NAND2BXL $PINS AN=n193 B=n194 Y=n196
XU971 NAND2BXL $PINS AN=n207 B=n206 Y=n202
XU975 NAND2BXL $PINS AN=n181 B=n182 Y=n184
XU976 INVXL $PINS A=n2345 Y=n1971
XU980 OAI21XL $PINS A0=shadow_weights[17][0] A1=temp_acc[0] B0=n172 Y=n2345
XU981 NAND2XL $PINS A=shadow_weights[17][0] B=temp_acc[0] Y=n172
XU983 NAND2BXL $PINS AN=n179 B=n178 Y=n176
XU985 NAND2BXL $PINS AN=n168 B=n169 Y=n171
XU987 OAI2BB1X1 $PINS A0N=n1235 A1N=n1164 B0=n1114 Y=n1435
XctmTdsLR_1_2028 AOI21XL $PINS A0=n1755 A1=n1754 B0=tmp_net443 Y=n1759
XctmTdsLR_2_2029 NOR2XL $PINS A=n1755 B=n1754 Y=tmp_net443
XU995 INVXL $PINS A=n2347 Y=n573
XU1023 AND2X1 $PINS A=n2022 B=n2347 Y=n2078
XU1025 OAI31X1 $PINS A0=target_bit[3] A1=target_bit[2] A2=target_bit[1]
+ B0=target_bit[4] Y=n2022
XU1056 NOR3BX2 $PINS AN=calc_cnt[2] B=calc_cnt[3] C=n1310 Y=n732
XU1059 NAND2XL $PINS A=calc_cnt[4] B=n617 Y=n1310
XU1060 NAND2X2 $PINS A=n638 B=n1990 Y=n315
XU1061 OAI22XL $PINS A0=n64 A1=state[0] B0=n56 B1=n63 Y=n2347
XU1131 NOR2XL $PINS A=state[0] B=state[1] Y=n639
XU1143 INVXL $PINS A=n1991 Y=n56
XU1152 NOR2XL $PINS A=n68 B=state[3] Y=n1991
XctmTdsLR_2_1757 OAI2BB1XL $PINS A0N=shadow_weights[3][26] A1N=n1660
+ B0=tmp_net31 Y=tmp_net272
XctmTdsLR_1_1758 AOI222XL $PINS A0=n1282 A1=shadow_weights[17][13] B0=n1281
+ B1=shadow_weights[19][13] C0=n1279 C1=shadow_weights[16][13] Y=tmp_net273
XctmTdsLR_2_1759 NAND2XL $PINS A=n1280 B=shadow_weights[18][13] Y=tmp_net274
XctmTdsLR_2_1791 AOI222XL $PINS A0=n1278 A1=shadow_weights[8][11] B0=n1277
+ B1=shadow_weights[10][11] C0=n1279 C1=shadow_weights[16][11] Y=tmp_net294
XctmTdsLR_1_2040 AOI21XL $PINS A0=n269 A1=n266 B0=tmp_net450 Y=n1708
XctmTdsLR_2_1793 AOI21XL $PINS A0=HFSNET_342 A1=shadow_weights[7][9]
+ B0=tmp_net295 Y=tmp_net296
XctmTdsLR_3_1794 NAND3XL $PINS A=n1100_CDR1 B=n1092_CDR1 C=ZBUF_2_40
+ Y=tmp_net295
XctmTdsLR_2_2041 NAND2XL $PINS A=tmp_net449 B=n267 Y=n266
XctmTdsLR_2_1796 NAND2XL $PINS A=gre_a_INV_6625_58 B=shadow_weights[15][26]
+ Y=tmp_net297
XctmTdsLR_3_1797 AOI21XL $PINS A0=n1687 A1=shadow_weights[2][26] B0=tmp_net299
+ Y=tmp_net300
XctmTdsLR_4_1798 OAI2BB1XL $PINS A0N=shadow_weights[4][26]
+ A1N=gre_a_INV_8759_58 B0=tmp_net298 Y=tmp_net299
XctmTdsLR_5_1799 AOI22XL $PINS A0=n1677 A1=shadow_weights[5][26] B0=n1686
+ B1=shadow_weights[6][26] Y=tmp_net298
XctmTdsLR_6_1800 AOI22XL $PINS A0=n1319 A1=shadow_weights[13][26]
+ B0=ZBUF_20020_1 B1=shadow_weights[0][26] Y=tmp_net301
XctmTdsLR_1_1801 NAND3X1 $PINS A=tmp_net305 B=n1477 C=tmp_net123 Y=HFSNET_166
XctmTdsLR_2_1802 NOR3XL $PINS A=tmp_net302 B=tmp_net303 C=tmp_net304
+ Y=tmp_net305
XctmTdsLR_3_1803 NAND3XL $PINS A=n1467_CDR2 B=n1471_CDR1 C=n1476_CDR1
+ Y=tmp_net302
XctmTdsLR_4_1804 NAND4XL $PINS A=n1468_CDR2 B=n1469_CDR1 C=n1470_CDR1
+ D=n1472_CDR2 Y=tmp_net303
XctmTdsLR_5_1805 OAI2BB1XL $PINS A0N=shadow_weights[7][25] A1N=HFSNET_342
+ B0=tmp_net124 Y=tmp_net304
XctmTdsLR_3_2042 INVXL $PINS A=n268 Y=tmp_net449
XctmTdsLR_4_2043 NOR2XL $PINS A=n269 B=n266 Y=tmp_net450
XctmTdsLR_1_2052 OAI21XL $PINS A0=n1633 A1=n1624 B0=tmp_net455 Y=n1625
XctmTdsLR_2_2053 NAND2XL $PINS A=n1633 B=n1624 Y=tmp_net455
XctmTdsLR_1_2054 AOI222XL $PINS A0=n1268 A1=shadow_weights[5][15]
+ B0=gre_a_INV_5313_58 B1=shadow_weights[12][15] C0=n1270
+ C1=shadow_weights[14][15] Y=tmp_net456
XctmTdsLR_1_2055 OAI21XL $PINS A0=tmp_net220 A1=n1429 B0=tmp_net458 Y=n1431
XctmTdsLR_2_2056 NAND2XL $PINS A=tmp_net457 B=n1427 Y=n1429
XctmTdsLR_3_2057 INVXL $PINS A=n1426 Y=tmp_net457
XctmTdsLR_4_2058 NAND2XL $PINS A=tmp_net220 B=n1429 Y=tmp_net458
XctmTdsLR_1_2059 OAI21XL $PINS A0=n1570 A1=n1527 B0=tmp_net460 Y=n1528
XctmTdsLR_2_2060 NAND2XL $PINS A=tmp_net459 B=n1525 Y=n1527
XctmTdsLR_3_2061 INVXL $PINS A=n1524 Y=tmp_net459
XctmTdsLR_4_2062 NAND2XL $PINS A=n1570 B=n1527 Y=tmp_net460
XctmTdsLR_1_2063 OAI21XL $PINS A0=n1734 A1=n1733 B0=tmp_net462 Y=n1739
XctmTdsLR_2_2064 NAND2XL $PINS A=tmp_net461 B=n1731 Y=n1733
XctmTdsLR_3_2065 INVXL $PINS A=n1730 Y=tmp_net461
XctmTdsLR_4_2066 NAND2XL $PINS A=n1734 B=n1733 Y=tmp_net462
Xcopt_gre_mt_inst_2141 CLKBUFX2 $PINS A=tmp_net352 Y=copt_gre_net_482
XctmTdsLR_3_2079 INVXL $PINS A=n976 Y=tmp_net468
XctmTdsLR_4_2080 NOR2XL $PINS A=n779 B=n777 Y=tmp_net469
XctmTdsLR_1_2081 NAND4XL $PINS A=tmp_net246 B=n1247 C=tmp_net470 D=tmp_net247
+ Y=tmp_net248
XctmTdsLR_1_2084 AOI21XL $PINS A0=n1724 A1=n1723 B0=tmp_net473 Y=n1728
XctmTdsLR_2_2085 NAND2XL $PINS A=tmp_net472 B=n1721 Y=n1723
XctmTdsLR_3_2086 INVXL $PINS A=n1720 Y=tmp_net472
XctmTdsLR_4_2087 NOR2XL $PINS A=n1724 B=n1723 Y=tmp_net473
XZBUF_145_inst_2112 BUFX1 $PINS A=n2024 Y=ZBUF_145_35
XZBUF_2_inst_2114 BUFXL $PINS A=tmp_net267 Y=ZBUF_2_36
XZBUF_2_inst_2116 BUFXL $PINS A=tmp_net317 Y=ZBUF_2_38
XZBUF_2_inst_2117 CLKBUFX2 $PINS A=tmp_net296 Y=ZBUF_2_39
XZBUF_2_inst_2118 BUFXL $PINS A=tmp_net269 Y=ZBUF_2_40
XZBUF_2_inst_2120 CLKBUFX3 $PINS A=n781_CDR2 Y=ZBUF_2_42
XZBUF_2_inst_2123 CLKBUFX3 $PINS A=tmp_net294 Y=ZBUF_2_45
XZBUF_2_inst_2124 BUFX1 $PINS A=n1149_CDR1 Y=ZBUF_2_46
XZBUF_2_inst_2127 CLKBUFX2 $PINS A=tmp_net268 Y=ZBUF_2_49
XZBUF_2_inst_2128 BUFXL $PINS A=tmp_net39 Y=ZBUF_2_50
XZBUF_2_inst_2129 BUFXL $PINS A=tmp_net263 Y=ZBUF_2_51
XZBUF_2_inst_2130 CLKBUFX2 $PINS A=tmp_net456 Y=ZBUF_2_52
XZBUF_2_inst_2131 BUFX1 $PINS A=tmp_net243 Y=ZBUF_2_53
XZBUF_2_inst_2132 CLKBUFX3 $PINS A=n1091 Y=ZBUF_2_54
Xcopt_gre_mt_inst_2133 CLKBUFX2 $PINS A=n745_CDR2 Y=copt_gre_net_474
Xcopt_gre_mt_inst_2134 CLKBUFX3 $PINS A=HFSNET_45 Y=copt_gre_net_475
Xcopt_gre_mt_inst_2135 CLKBUFX3 $PINS A=tmp_net50 Y=copt_gre_net_476
Xcopt_gre_mt_inst_2137 CLKBUFX2 $PINS A=tmp_net354 Y=copt_gre_net_478
Xcopt_gre_mt_inst_2138 CLKBUFX2 $PINS A=n991_CDR1 Y=copt_gre_net_479
Xcopt_gre_mt_inst_2139 CLKBUFX3 $PINS A=HFSNET_170 Y=copt_gre_net_480
XHFSBUF_32_437 BUFX2 $PINS A=aps_rename_2_ Y=overrange_bits[17]
XHFSBUF_17_438 BUFX2 $PINS A=aps_rename_1_ Y=overrange_bits[18]
XHFSBUF_32_440 CLKBUFX2 $PINS A=aps_rename_4_ Y=overrange_bits[2]
XHFSBUF_32_441 CLKBUFX2 $PINS A=aps_rename_3_ Y=overrange_bits[7]
XHFSBUF_51_461 CLKBUFX2 $PINS A=shadow_weights[17][12] Y=HFSNET_209
XHFSBUF_66_463 BUFX1 $PINS A=shadow_weights[17][14] Y=HFSNET_211
XHFSBUF_47_477 BUFX1 $PINS A=shadow_weights[18][11] Y=HFSNET_225
XHFSBUF_47_478 BUFX1 $PINS A=shadow_weights[18][12] Y=HFSNET_226
XHFSBUF_47_486 BUFX1 $PINS A=shadow_weights[18][20] Y=HFSNET_234
XHFSBUF_66_493 BUFX1 $PINS A=shadow_weights[18][26] Y=HFSNET_241
XHFSBUF_47_496 BUFX1 $PINS A=shadow_weights[18][9] Y=HFSNET_244
XHFSBUF_46_498 BUFXL $PINS A=n2162 Y=HFSNET_246
XHFSINV_63_503 INVXL $PINS A=N1833 Y=HFSNET_249
XU1049 OR3XL $PINS A=wr_idx_r[4] B=n2160 C=n671 Y=N1833
XU1389 OR2XL $PINS A=n667 B=n577 Y=N1836
XHFSINV_130_528 INVX1 $PINS A=N1829 Y=HFSNET_269
XU1723 OR2XL $PINS A=n598 B=n599 Y=N1829
XHFSINV_190_546 INVXL $PINS A=n110 Y=HFSNET_285
XHFSBUF_17_551 BUFX1 $PINS A=n2159 Y=HFSNET_290
XHFSINV_4_556 INVXL $PINS A=HFSNET_297 Y=HFSNET_295
XHFSINV_561_557 CLKINVX3 $PINS A=HFSNET_297 Y=HFSNET_296
XHFSINV_644_558 INVXL $PINS A=n70 Y=HFSNET_297
XHFSBUF_541_560 BUFX2 $PINS A=n71 Y=HFSNET_299
XHFSINV_904_562 INVX4 $PINS A=calc_result_r[10] Y=HFSNET_301
XHFSINV_529_572 INVX4 $PINS A=calc_result_r[0] Y=HFSNET_311
XHFSINV_603_588 INVX4 $PINS A=calc_result_r[2] Y=HFSNET_327
XHFSINV_606_593 INVX4 $PINS A=calc_result_r[3] Y=HFSNET_332
XHFSINV_412_597 INVX4 $PINS A=calc_result_r[4] Y=HFSNET_336
XHFSINV_801_600 CLKINVX8 $PINS A=calc_result_r[6] Y=HFSNET_339
XHFSINV_758_602 CLKINVX8 $PINS A=calc_result_r[7] Y=HFSNET_341
.ENDS

.SUBCKT sar_digi_paper_core clk dec_clk rst_n start_calib calib_comp_out
+ calib_done calib_done_pulse calib_mode_en dac_p_force[19] dac_p_force[18]
+ dac_p_force[17] dac_p_force[16] dac_p_force[15] dac_p_force[14]
+ dac_p_force[13] dac_p_force[12] dac_p_force[11] dac_p_force[10]
+ dac_p_force[9] dac_p_force[8] dac_p_force[7] dac_p_force[6] dac_p_force[5]
+ dac_p_force[4] dac_p_force[3] dac_p_force[2] dac_p_force[1] dac_p_force[0]
+ dac_n_force[19] dac_n_force[18] dac_n_force[17] dac_n_force[16]
+ dac_n_force[15] dac_n_force[14] dac_n_force[13] dac_n_force[12]
+ dac_n_force[11] dac_n_force[10] dac_n_force[9] dac_n_force[8] dac_n_force[7]
+ dac_n_force[6] dac_n_force[5] dac_n_force[4] dac_n_force[3] dac_n_force[2]
+ dac_n_force[1] dac_n_force[0] calib_overrange calib_overrange_bits[19]
+ calib_overrange_bits[18] calib_overrange_bits[17] calib_overrange_bits[16]
+ calib_overrange_bits[15] calib_overrange_bits[14] calib_overrange_bits[13]
+ calib_overrange_bits[12] calib_overrange_bits[11] calib_overrange_bits[10]
+ calib_overrange_bits[9] calib_overrange_bits[8] calib_overrange_bits[7]
+ calib_overrange_bits[6] calib_overrange_bits[5] calib_overrange_bits[4]
+ calib_overrange_bits[3] calib_overrange_bits[2] calib_overrange_bits[1]
+ calib_overrange_bits[0] data_valid_i raw_bits_i[19] raw_bits_i[18]
+ raw_bits_i[17] raw_bits_i[16] raw_bits_i[15] raw_bits_i[14] raw_bits_i[13]
+ raw_bits_i[12] raw_bits_i[11] raw_bits_i[10] raw_bits_i[9] raw_bits_i[8]
+ raw_bits_i[7] raw_bits_i[6] raw_bits_i[5] raw_bits_i[4] raw_bits_i[3]
+ raw_bits_i[2] raw_bits_i[1] raw_bits_i[0] raw_code_o[19] raw_code_o[18]
+ raw_code_o[17] raw_code_o[16] raw_code_o[15] raw_code_o[14] raw_code_o[13]
+ raw_code_o[12] raw_code_o[11] raw_code_o[10] raw_code_o[9] raw_code_o[8]
+ raw_code_o[7] raw_code_o[6] raw_code_o[5] raw_code_o[4] raw_code_o[3]
+ raw_code_o[2] raw_code_o[1] raw_code_o[0] raw_code_valid_o w_wr_en
+ w_wr_addr[4] w_wr_addr[3] w_wr_addr[2] w_wr_addr[1] w_wr_addr[0]
+ w_wr_data[29] w_wr_data[28] w_wr_data[27] w_wr_data[26] w_wr_data[25]
+ w_wr_data[24] w_wr_data[23] w_wr_data[22] w_wr_data[21] w_wr_data[20]
+ w_wr_data[19] w_wr_data[18] w_wr_data[17] w_wr_data[16] w_wr_data[15]
+ w_wr_data[14] w_wr_data[13] w_wr_data[12] w_wr_data[11] w_wr_data[10]
+ w_wr_data[9] w_wr_data[8] w_wr_data[7] w_wr_data[6] w_wr_data[5] w_wr_data[4]
+ w_wr_data[3] w_wr_data[2] w_wr_data[1] w_wr_data[0] srm_start
+ srm_decision_valid srm_decision_bit residue_consume_i srm_busy srm_done
+ srm_residue_valid srm_ones_count[4] srm_ones_count[3] srm_ones_count[2]
+ srm_ones_count[1] srm_ones_count[0] srm_total_count[4] srm_total_count[3]
+ srm_total_count[2] srm_total_count[1] srm_total_count[0] srm_count_shortfall
+ srm_stalled srm_residue_o[9] srm_residue_o[8] srm_residue_o[7]
+ srm_residue_o[6] srm_residue_o[5] srm_residue_o[4] srm_residue_o[3]
+ srm_residue_o[2] srm_residue_o[1] srm_residue_o[0]
Xu_calib_ctrl sar_calib_ctrl_serial_20_30_16_32_5_256_1_1 $PINS clk=ZCTSNET_133
+ rst_n=HFSNET_124 start_calib=start_calib calib_done=aps_rename_7_
+ calib_done_pulse=aps_rename_8_ calib_mode_en=aps_rename_9_
+ comp_out=calib_comp_out dac_p_force[19]=aps_rename_10_
+ dac_p_force[18]=aps_rename_11_ dac_p_force[17]=aps_rename_12_
+ dac_p_force[16]=aps_rename_13_ dac_p_force[15]=aps_rename_14_
+ dac_p_force[14]=aps_rename_15_ dac_p_force[13]=aps_rename_16_
+ dac_p_force[12]=aps_rename_17_ dac_p_force[11]=aps_rename_18_
+ dac_p_force[10]=aps_rename_19_ dac_p_force[9]=aps_rename_20_
+ dac_p_force[8]=aps_rename_21_ dac_p_force[7]=aps_rename_22_
+ dac_p_force[6]=dac_p_force[6] dac_p_force[5]=dac_p_force[5]
+ dac_p_force[4]=dac_p_force[4] dac_p_force[3]=dac_p_force[3]
+ dac_p_force[2]=dac_p_force[2] dac_p_force[1]=dac_p_force[1]
+ dac_p_force[0]=aps_rename_23_ dac_n_force[19]=aps_rename_24_
+ dac_n_force[18]=aps_rename_25_ dac_n_force[17]=aps_rename_26_
+ dac_n_force[16]=aps_rename_27_ dac_n_force[15]=aps_rename_28_
+ dac_n_force[14]=aps_rename_29_ dac_n_force[13]=aps_rename_30_
+ dac_n_force[12]=aps_rename_31_ dac_n_force[11]=aps_rename_32_
+ dac_n_force[10]=aps_rename_33_ dac_n_force[9]=aps_rename_34_
+ dac_n_force[8]=aps_rename_35_ dac_n_force[7]=aps_rename_36_
+ dac_n_force[6]=aps_rename_37_ dac_n_force[5]=aps_rename_38_
+ dac_n_force[4]=aps_rename_39_ dac_n_force[3]=aps_rename_40_
+ dac_n_force[2]=aps_rename_41_ dac_n_force[1]=aps_rename_42_
+ dac_n_force[0]=aps_rename_43_ w_wr_en=aps_rename_69_
+ w_wr_addr[4]=aps_rename_70_ w_wr_addr[3]=aps_rename_71_
+ w_wr_addr[2]=aps_rename_72_ w_wr_addr[1]=aps_rename_73_
+ w_wr_addr[0]=aps_rename_74_ w_wr_data[29]=aps_rename_75_
+ w_wr_data[28]=aps_rename_76_ w_wr_data[27]=aps_rename_77_
+ w_wr_data[26]=aps_rename_78_ w_wr_data[25]=aps_rename_79_
+ w_wr_data[24]=aps_rename_80_ w_wr_data[23]=aps_rename_81_
+ w_wr_data[22]=aps_rename_82_ w_wr_data[21]=aps_rename_83_
+ w_wr_data[20]=aps_rename_84_ w_wr_data[19]=aps_rename_85_
+ w_wr_data[18]=aps_rename_86_ w_wr_data[17]=aps_rename_87_
+ w_wr_data[16]=aps_rename_88_ w_wr_data[15]=aps_rename_89_
+ w_wr_data[14]=aps_rename_90_ w_wr_data[13]=aps_rename_91_
+ w_wr_data[12]=aps_rename_92_ w_wr_data[11]=aps_rename_93_
+ w_wr_data[10]=aps_rename_94_ w_wr_data[9]=aps_rename_95_
+ w_wr_data[8]=aps_rename_96_ w_wr_data[7]=aps_rename_97_
+ w_wr_data[6]=aps_rename_98_ w_wr_data[5]=aps_rename_99_
+ w_wr_data[4]=aps_rename_100_ w_wr_data[3]=aps_rename_101_
+ w_wr_data[2]=aps_rename_102_ w_wr_data[1]=aps_rename_103_
+ w_wr_data[0]=aps_rename_104_ calib_overrange=aps_rename_44_
+ overrange_bits[19]=aps_rename_45_ overrange_bits[18]=calib_overrange_bits[18]
+ overrange_bits[17]=calib_overrange_bits[17] overrange_bits[16]=aps_rename_46_
+ overrange_bits[15]=calib_overrange_bits[15]
+ overrange_bits[14]=calib_overrange_bits[14]
+ overrange_bits[13]=calib_overrange_bits[13]
+ overrange_bits[12]=calib_overrange_bits[12]
+ overrange_bits[11]=calib_overrange_bits[11]
+ overrange_bits[10]=calib_overrange_bits[10]
+ overrange_bits[9]=calib_overrange_bits[9]
+ overrange_bits[8]=calib_overrange_bits[8]
+ overrange_bits[7]=calib_overrange_bits[7] overrange_bits[6]=aps_rename_47_
+ overrange_bits[5]=calib_overrange_bits[5]
+ overrange_bits[4]=calib_overrange_bits[4]
+ overrange_bits[3]=calib_overrange_bits[3]
+ overrange_bits[2]=calib_overrange_bits[2]
+ overrange_bits[1]=calib_overrange_bits[1]
+ overrange_bits[0]=calib_overrange_bits[0] HFSNET_351=HFSNET_125
+ HFSNET_365=HFSNET_126 HFSNET_371=HFSNET_127 HFSNET_381=HFSNET_128
+ HFSNET_382=HFSNET_130 ZBUF_24_2=calib_overrange_bits[6]
+ ZBUF_22_2=calib_overrange_bits[16] ZCTSNET_411=ZCTSNET_134 ZCTSNET_413=clk
+ gre_a_BUF_36_0=gre_a_BUF_36_55 gre_a_BUF_36_1=gre_a_BUF_36_56
+ gre_a_BUF_36_2=gre_a_BUF_36_57 gre_a_BUF_36_3=gre_a_BUF_36_58
Xu_srm_residue
+ srm_residue_estimator_DECISION_COUNT22_RESIDUE_WIDTH10_RES_FRAC8_SIGMA_Q8128_STALL_CYCLES64
+ $PINS dec_clk=dec_clk decision_valid=srm_decision_valid
+ decision_bit=srm_decision_bit clk=ZCTSNET_133 rst_n=HFSNET_124 start=srm_start
+ residue_consume=residue_consume_i busy=srm_busy done=aps_rename_105_
+ residue_valid=aps_rename_106_ ones_count[4]=aps_rename_107_
+ ones_count[3]=aps_rename_108_ ones_count[2]=aps_rename_109_
+ ones_count[1]=aps_rename_110_ ones_count[0]=aps_rename_111_
+ total_count[4]=aps_rename_112_ total_count[3]=aps_rename_113_
+ total_count[2]=aps_rename_114_ total_count[1]=aps_rename_115_
+ total_count[0]=aps_rename_116_ count_shortfall=aps_rename_117_
+ stalled=aps_rename_118_ residue_q[9]=aps_rename_119_
+ residue_q[8]=aps_rename_120_ residue_q[7]=aps_rename_121_
+ residue_q[6]=aps_rename_122_ residue_q[5]=aps_rename_123_
+ residue_q[4]=aps_rename_124_ residue_q[3]=aps_rename_125_
+ residue_q[2]=aps_rename_126_ residue_q[1]=aps_rename_127_
+ residue_q[0]=aps_rename_128_ HFSNET_5=HFSNET_127 HFSNET_6=HFSNET_128
+ HFSNET_7=HFSNET_130 HFSNET_9=rst_n
Xraw_code_valid_o_reg DFFSX1 $PINS D=HFSNET_113 CK=ZCTSNET_134 SN=HFSNET_125
+ QN=aps_rename_68_
Xraw_code_o_reg[19] DFFSX1 $PINS D=n40 CK=ZCTSNET_134 SN=HFSNET_125
+ QN=aps_rename_48_
Xraw_code_o_reg[18] DFFSX1 $PINS D=n38 CK=ZCTSNET_134 SN=HFSNET_125
+ QN=aps_rename_49_
Xraw_code_o_reg[17] DFFSX1 $PINS D=n36 CK=ZCTSNET_134 SN=HFSNET_124
+ QN=aps_rename_50_
Xraw_code_o_reg[16] DFFSX1 $PINS D=n34 CK=ZCTSNET_134 SN=HFSNET_124
+ QN=aps_rename_51_
Xraw_code_o_reg[15] DFFSX1 $PINS D=n32 CK=ZCTSNET_134 SN=HFSNET_124
+ QN=aps_rename_52_
Xraw_code_o_reg[14] DFFSX1 $PINS D=n30 CK=ZCTSNET_134 SN=HFSNET_124
+ QN=aps_rename_53_
Xraw_code_o_reg[13] DFFSX1 $PINS D=n28 CK=ZCTSNET_134 SN=HFSNET_124
+ QN=aps_rename_54_
Xraw_code_o_reg[12] DFFSX1 $PINS D=n26 CK=ZCTSNET_134 SN=HFSNET_124
+ QN=aps_rename_55_
Xraw_code_o_reg[11] DFFSX1 $PINS D=n24 CK=ZCTSNET_133 SN=HFSNET_124
+ QN=aps_rename_56_
Xraw_code_o_reg[10] DFFSX1 $PINS D=n22 CK=ZCTSNET_133 SN=HFSNET_124
+ QN=aps_rename_57_
Xraw_code_o_reg[9] DFFSX1 $PINS D=n20 CK=ZCTSNET_133 SN=HFSNET_128
+ QN=aps_rename_58_
Xraw_code_o_reg[8] DFFSX1 $PINS D=n18 CK=ZCTSNET_133 SN=HFSNET_128
+ QN=aps_rename_59_
Xraw_code_o_reg[7] DFFSX1 $PINS D=n16 CK=ZCTSNET_133 SN=HFSNET_128
+ QN=aps_rename_60_
Xraw_code_o_reg[6] DFFSX1 $PINS D=HFSNET_119 CK=ZCTSNET_133 SN=HFSNET_128
+ QN=aps_rename_61_
Xraw_code_o_reg[5] DFFSX1 $PINS D=n12 CK=ZCTSNET_133 SN=HFSNET_124
+ QN=aps_rename_62_
Xraw_code_o_reg[4] DFFSX1 $PINS D=HFSNET_118 CK=ZCTSNET_133 SN=HFSNET_128
+ QN=aps_rename_63_
Xraw_code_o_reg[3] DFFSX1 $PINS D=HFSNET_117 CK=ZCTSNET_133 SN=HFSNET_128
+ QN=aps_rename_64_
Xraw_code_o_reg[2] DFFSX1 $PINS D=HFSNET_116 CK=ZCTSNET_133 SN=HFSNET_128
+ QN=aps_rename_65_
Xraw_code_o_reg[1] DFFSX1 $PINS D=HFSNET_115 CK=ZCTSNET_134 SN=HFSNET_125
+ QN=aps_rename_66_
Xraw_code_o_reg[0] DFFSX1 $PINS D=HFSNET_114 CK=ZCTSNET_134 SN=HFSNET_126
+ QN=aps_rename_67_
XU19 INVXL $PINS A=raw_bits_i[16] Y=n34
XU8 INVXL $PINS A=raw_bits_i[5] Y=n12
XHFSINV_4_341 INVXL $PINS A=raw_bits_i[4] Y=HFSNET_118
XU12 INVXL $PINS A=raw_bits_i[9] Y=n20
XU16 INVXL $PINS A=raw_bits_i[13] Y=n28
XU10 CLKINVXL $PINS A=raw_bits_i[7] Y=n16
XU18 INVXL $PINS A=raw_bits_i[15] Y=n32
XHFSINV_4_337 INVX2 $PINS A=raw_bits_i[0] Y=HFSNET_114
XU20 INVXL $PINS A=raw_bits_i[17] Y=n36
XU21 INVXL $PINS A=raw_bits_i[18] Y=n38
XHFSINV_4_342 INVXL $PINS A=raw_bits_i[6] Y=HFSNET_119
XU15 INVXL $PINS A=raw_bits_i[12] Y=n26
XU14 INVXL $PINS A=raw_bits_i[11] Y=n24
XU22 INVXL $PINS A=raw_bits_i[19] Y=n40
XHFSINV_4_336 INVXL $PINS A=data_valid_i Y=HFSNET_113
XHFSINV_4_340 INVXL $PINS A=raw_bits_i[3] Y=HFSNET_117
XHFSINV_4_338 INVXL $PINS A=raw_bits_i[1] Y=HFSNET_115
XHFSINV_4_339 INVXL $PINS A=raw_bits_i[2] Y=HFSNET_116
XU11 INVXL $PINS A=raw_bits_i[8] Y=n18
XU13 INVXL $PINS A=raw_bits_i[10] Y=n22
XU17 INVXL $PINS A=raw_bits_i[14] Y=n30
XHFSBUF_2_40 CLKBUFX2 $PINS A=aps_rename_67_ Y=raw_code_o[0]
XHFSBUF_2_41 CLKBUFX2 $PINS A=aps_rename_57_ Y=raw_code_o[10]
XHFSBUF_2_42 CLKBUFX2 $PINS A=aps_rename_56_ Y=raw_code_o[11]
XHFSBUF_2_51 CLKBUFX2 $PINS A=aps_rename_66_ Y=raw_code_o[1]
XHFSBUF_2_52 BUFX2 $PINS A=aps_rename_65_ Y=raw_code_o[2]
XHFSBUF_2_53 BUFX2 $PINS A=aps_rename_64_ Y=raw_code_o[3]
XHFSBUF_2_54 CLKBUFX2 $PINS A=aps_rename_63_ Y=raw_code_o[4]
XHFSBUF_2_55 BUFX2 $PINS A=aps_rename_62_ Y=raw_code_o[5]
XHFSBUF_2_56 CLKBUFX2 $PINS A=aps_rename_61_ Y=raw_code_o[6]
XHFSBUF_2_57 CLKBUFX2 $PINS A=aps_rename_60_ Y=raw_code_o[7]
XHFSBUF_2_58 CLKBUFX2 $PINS A=aps_rename_59_ Y=raw_code_o[8]
XHFSBUF_2_59 CLKBUFX2 $PINS A=aps_rename_58_ Y=raw_code_o[9]
XHFSBUF_2_60 CLKBUFX2 $PINS A=aps_rename_68_ Y=raw_code_valid_o
XHFSBUF_2_61 BUFX1 $PINS A=aps_rename_21_ Y=dac_p_force[8]
XHFSBUF_2_62 BUFX1 $PINS A=aps_rename_22_ Y=dac_p_force[7]
XHFSBUF_2_63 CLKBUFX2 $PINS A=aps_rename_20_ Y=dac_p_force[9]
XHFSBUF_2_64 CLKBUFX2 $PINS A=aps_rename_19_ Y=dac_p_force[10]
XHFSBUF_2_65 CLKBUFX2 $PINS A=aps_rename_36_ Y=dac_n_force[7]
XHFSBUF_2_66 CLKBUFX2 $PINS A=aps_rename_18_ Y=dac_p_force[11]
XHFSBUF_2_67 CLKBUFX2 $PINS A=aps_rename_25_ Y=dac_n_force[18]
XHFSBUF_2_68 CLKBUFX2 $PINS A=aps_rename_29_ Y=dac_n_force[14]
XHFSBUF_2_69 CLKBUFX2 $PINS A=aps_rename_37_ Y=dac_n_force[6]
XHFSBUF_2_70 CLKBUFX3 $PINS A=aps_rename_40_ Y=dac_n_force[3]
XHFSBUF_2_71 CLKBUFX2 $PINS A=aps_rename_34_ Y=dac_n_force[9]
XHFSBUF_2_72 CLKBUFX3 $PINS A=aps_rename_42_ Y=dac_n_force[1]
XHFSBUF_2_73 CLKBUFX2 $PINS A=aps_rename_39_ Y=dac_n_force[4]
XHFSBUF_2_74 CLKBUFX2 $PINS A=aps_rename_38_ Y=dac_n_force[5]
XHFSBUF_2_75 CLKBUFX3 $PINS A=aps_rename_43_ Y=dac_n_force[0]
XHFSBUF_2_76 CLKBUFX3 $PINS A=aps_rename_41_ Y=dac_n_force[2]
XHFSBUF_2_77 BUFX1 $PINS A=aps_rename_35_ Y=dac_n_force[8]
XHFSBUF_2_78 CLKBUFXL $PINS A=aps_rename_33_ Y=dac_n_force[10]
XHFSBUF_2_79 BUFX1 $PINS A=aps_rename_23_ Y=dac_p_force[0]
XHFSBUF_2_80 CLKBUFX2 $PINS A=aps_rename_11_ Y=dac_p_force[18]
XHFSBUF_2_81 CLKBUFX2 $PINS A=aps_rename_12_ Y=dac_p_force[17]
XHFSBUF_2_82 BUFX1 $PINS A=aps_rename_13_ Y=dac_p_force[16]
XHFSBUF_2_83 CLKBUFX2 $PINS A=aps_rename_14_ Y=dac_p_force[15]
XHFSBUF_2_84 CLKBUFX2 $PINS A=aps_rename_15_ Y=dac_p_force[14]
XHFSBUF_2_85 CLKBUFX2 $PINS A=aps_rename_16_ Y=dac_p_force[13]
XHFSBUF_2_86 CLKBUFX2 $PINS A=aps_rename_17_ Y=dac_p_force[12]
XHFSBUF_2_87 CLKBUFX2 $PINS A=aps_rename_27_ Y=dac_n_force[16]
XHFSBUF_2_88 CLKBUFX2 $PINS A=aps_rename_24_ Y=dac_n_force[19]
XHFSBUF_2_89 CLKBUFX2 $PINS A=aps_rename_26_ Y=dac_n_force[17]
XHFSBUF_2_90 CLKBUFX2 $PINS A=aps_rename_31_ Y=dac_n_force[12]
XHFSBUF_2_91 CLKBUFX2 $PINS A=aps_rename_10_ Y=dac_p_force[19]
XHFSBUF_2_260 CLKBUFX2 $PINS A=aps_rename_8_ Y=calib_done_pulse
XHFSBUF_2_261 CLKBUFX2 $PINS A=aps_rename_7_ Y=calib_done
XHFSBUF_2_262 CLKBUFX2 $PINS A=aps_rename_9_ Y=calib_mode_en
XHFSBUF_2_277 CLKBUFX2 $PINS A=aps_rename_74_ Y=w_wr_addr[0]
XHFSBUF_2_278 CLKBUFX2 $PINS A=aps_rename_73_ Y=w_wr_addr[1]
XHFSBUF_2_279 CLKBUFX2 $PINS A=aps_rename_72_ Y=w_wr_addr[2]
XHFSBUF_2_280 CLKBUFX2 $PINS A=aps_rename_71_ Y=w_wr_addr[3]
XHFSBUF_2_281 CLKBUFX2 $PINS A=aps_rename_70_ Y=w_wr_addr[4]
XHFSBUF_2_282 CLKBUFX2 $PINS A=aps_rename_104_ Y=w_wr_data[0]
XHFSBUF_2_283 CLKBUFX2 $PINS A=aps_rename_94_ Y=w_wr_data[10]
XHFSBUF_2_284 CLKBUFX2 $PINS A=aps_rename_93_ Y=w_wr_data[11]
XHFSBUF_2_285 CLKBUFX2 $PINS A=aps_rename_92_ Y=w_wr_data[12]
XHFSBUF_2_286 CLKBUFX2 $PINS A=aps_rename_91_ Y=w_wr_data[13]
XHFSBUF_2_287 CLKBUFX2 $PINS A=aps_rename_90_ Y=w_wr_data[14]
XHFSBUF_2_288 BUFX1 $PINS A=aps_rename_89_ Y=w_wr_data[15]
XHFSBUF_2_289 BUFX1 $PINS A=aps_rename_88_ Y=w_wr_data[16]
XHFSBUF_2_290 CLKBUFX2 $PINS A=aps_rename_87_ Y=w_wr_data[17]
XHFSBUF_2_291 CLKBUFX2 $PINS A=aps_rename_86_ Y=w_wr_data[18]
XHFSBUF_2_292 CLKBUFX2 $PINS A=aps_rename_85_ Y=w_wr_data[19]
XHFSBUF_2_293 CLKBUFX3 $PINS A=aps_rename_103_ Y=w_wr_data[1]
XHFSBUF_2_294 CLKBUFX2 $PINS A=aps_rename_84_ Y=w_wr_data[20]
XHFSBUF_2_295 CLKBUFX2 $PINS A=aps_rename_83_ Y=w_wr_data[21]
XHFSBUF_2_296 CLKBUFX2 $PINS A=aps_rename_82_ Y=w_wr_data[22]
XHFSBUF_2_297 CLKBUFX2 $PINS A=aps_rename_81_ Y=w_wr_data[23]
XHFSBUF_2_298 CLKBUFX2 $PINS A=aps_rename_80_ Y=w_wr_data[24]
XHFSBUF_2_299 CLKBUFX2 $PINS A=aps_rename_79_ Y=w_wr_data[25]
XHFSBUF_2_300 CLKBUFX2 $PINS A=aps_rename_78_ Y=w_wr_data[26]
XHFSBUF_2_301 CLKBUFX2 $PINS A=aps_rename_77_ Y=w_wr_data[27]
XHFSBUF_2_302 CLKBUFX2 $PINS A=aps_rename_76_ Y=w_wr_data[28]
XHFSBUF_2_303 CLKBUFX2 $PINS A=aps_rename_75_ Y=w_wr_data[29]
XHFSBUF_2_304 CLKBUFX2 $PINS A=aps_rename_102_ Y=w_wr_data[2]
XHFSBUF_2_305 CLKBUFX2 $PINS A=aps_rename_101_ Y=w_wr_data[3]
XHFSBUF_2_306 CLKBUFX2 $PINS A=aps_rename_100_ Y=w_wr_data[4]
XHFSBUF_2_307 CLKBUFX2 $PINS A=aps_rename_99_ Y=w_wr_data[5]
XHFSBUF_2_308 CLKBUFX2 $PINS A=aps_rename_98_ Y=w_wr_data[6]
XHFSBUF_2_309 CLKBUFX3 $PINS A=aps_rename_97_ Y=w_wr_data[7]
XHFSBUF_2_310 CLKBUFX2 $PINS A=aps_rename_96_ Y=w_wr_data[8]
XHFSBUF_2_311 CLKBUFX2 $PINS A=aps_rename_95_ Y=w_wr_data[9]
XHFSBUF_2_312 CLKBUFX2 $PINS A=aps_rename_69_ Y=w_wr_en
XHFSBUF_2_314 CLKBUFX4 $PINS A=aps_rename_117_ Y=srm_count_shortfall
XHFSBUF_2_315 CLKBUFX3 $PINS A=aps_rename_105_ Y=srm_done
XHFSBUF_2_316 BUFX2 $PINS A=aps_rename_111_ Y=srm_ones_count[0]
XHFSBUF_2_317 BUFX2 $PINS A=aps_rename_110_ Y=srm_ones_count[1]
XHFSBUF_2_318 CLKBUFX8 $PINS A=aps_rename_109_ Y=srm_ones_count[2]
XHFSBUF_2_319 CLKBUFX8 $PINS A=aps_rename_108_ Y=srm_ones_count[3]
XHFSBUF_2_320 CLKBUFX8 $PINS A=aps_rename_107_ Y=srm_ones_count[4]
XHFSBUF_2_321 CLKBUFX3 $PINS A=aps_rename_128_ Y=srm_residue_o[0]
XHFSBUF_2_322 CLKBUFX3 $PINS A=aps_rename_127_ Y=srm_residue_o[1]
XHFSBUF_2_323 CLKBUFX3 $PINS A=aps_rename_126_ Y=srm_residue_o[2]
XHFSBUF_2_324 CLKBUFX3 $PINS A=aps_rename_125_ Y=srm_residue_o[3]
XHFSBUF_2_325 CLKBUFX2 $PINS A=aps_rename_124_ Y=srm_residue_o[4]
XHFSBUF_2_326 CLKBUFX2 $PINS A=aps_rename_123_ Y=srm_residue_o[5]
XHFSBUF_2_327 CLKBUFX3 $PINS A=aps_rename_122_ Y=srm_residue_o[6]
XHFSBUF_2_328 CLKBUFX2 $PINS A=aps_rename_121_ Y=srm_residue_o[7]
XHFSBUF_2_329 CLKBUFX3 $PINS A=aps_rename_120_ Y=srm_residue_o[8]
XHFSBUF_2_330 CLKBUFX2 $PINS A=aps_rename_119_ Y=srm_residue_o[9]
XHFSBUF_2_331 CLKBUFX4 $PINS A=aps_rename_116_ Y=srm_total_count[0]
XHFSBUF_2_332 CLKBUFX4 $PINS A=aps_rename_115_ Y=srm_total_count[1]
XHFSBUF_2_333 CLKBUFX4 $PINS A=aps_rename_114_ Y=srm_total_count[2]
XHFSBUF_2_334 CLKBUFX4 $PINS A=aps_rename_113_ Y=srm_total_count[3]
XHFSBUF_2_335 CLKBUFX4 $PINS A=aps_rename_112_ Y=srm_total_count[4]
XHFSBUF_9_435 BUFX2 $PINS A=aps_rename_44_ Y=calib_overrange
XHFSBUF_9_439 BUFX2 $PINS A=aps_rename_45_ Y=calib_overrange_bits[19]
XHFSINV_11_446 CLKINVX8 $PINS A=aps_rename_106_ Y=srm_residue_valid
XHFSBUF_9_448 BUFX4 $PINS A=aps_rename_118_ Y=srm_stalled
XHFSINV_11374_613 CLKINVX4 $PINS A=HFSNET_130 Y=HFSNET_124
XHFSINV_6191_627 CLKINVX4 $PINS A=HFSNET_130 Y=HFSNET_125
XHFSINV_367_633 CLKINVX8 $PINS A=HFSNET_130 Y=HFSNET_126
XHFSINV_5477_643 CLKINVX3 $PINS A=HFSNET_130 Y=HFSNET_127
XHFSINV_5855_644 CLKINVX8 $PINS A=HFSNET_130 Y=HFSNET_128
XZBUF_24_inst_1021 CLKBUFX2 $PINS A=aps_rename_47_ Y=calib_overrange_bits[6]
XHFSINV_12329_647 INVX16 $PINS A=rst_n Y=HFSNET_130
XZBUF_22_inst_1034 BUFX2 $PINS A=aps_rename_46_ Y=calib_overrange_bits[16]
XZBUF_2_inst_1041 CLKBUFX2 $PINS A=aps_rename_32_ Y=dac_n_force[11]
XZBUF_2_inst_1047 CLKBUFX2 $PINS A=aps_rename_30_ Y=dac_n_force[13]
XZBUF_2_inst_1048 CLKBUFX2 $PINS A=aps_rename_28_ Y=dac_n_force[15]
Xcopt_gre_h_inst_2142 CLKBUFXL $PINS A=aps_rename_51_ Y=raw_code_o[16]
Xcopt_gre_h_inst_2143 CLKBUFXL $PINS A=aps_rename_53_ Y=raw_code_o[14]
XZCTSBUF_9314_1366 BUFX16 $PINS A=clk Y=ZCTSNET_133
XZCTSBUF_8899_1368 CLKBUFX8 $PINS A=clk Y=ZCTSNET_134
Xcopt_gre_h_inst_2144 CLKBUFXL $PINS A=aps_rename_52_ Y=raw_code_o[15]
Xcopt_gre_h_inst_2145 CLKBUFXL $PINS A=aps_rename_54_ Y=raw_code_o[13]
Xcopt_gre_h_inst_2146 CLKBUFXL $PINS A=aps_rename_48_ Y=raw_code_o[19]
Xcopt_gre_h_inst_2147 CLKBUFXL $PINS A=aps_rename_55_ Y=raw_code_o[12]
Xcopt_gre_h_inst_2148 CLKBUFXL $PINS A=aps_rename_50_ Y=raw_code_o[17]
Xcopt_gre_h_inst_2149 CLKBUFXL $PINS A=aps_rename_49_ Y=raw_code_o[18]
.ENDS
.GLOBAL VDD
.GLOBAL VSS
