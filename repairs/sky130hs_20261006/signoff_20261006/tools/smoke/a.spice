* Tool smoke test (not design LVS)
.subckt smoke a y vss
R1 a n1 1000
R2 n1 y 2000
R3 y vss 5000
.ends smoke
.end
