* Renamed internal nodes are equivalent
.subckt smoke a y vss
R1 a renamed 1000
R2 renamed y 2000
R3 y vss 5000
.ends smoke
.end
